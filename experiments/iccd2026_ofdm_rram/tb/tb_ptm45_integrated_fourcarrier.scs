simulator lang=spice
.include "../models/ptm45/nmos_vtl_bsim4.inc"
.include "../models/ptm45/pmos_vtl_bsim4.inc"
simulator lang=spectre

subckt inv45 (in out vdd)
MP (out in vdd vdd) PMOS_VTL w=480n l=45n
MN (out in 0 0) NMOS_VTL w=240n l=45n
ends inv45

subckt ring3 (out vdd)
parameters cload=95f
X0 (n2 out vdd) inv45
X1 (out n1 vdd) inv45
X2 (n1 n2 vdd) inv45
C0 (out 0) capacitor c=cload ic=0.45
C1 (n1 0) capacitor c=cload ic=0.65
C2 (n2 0) capacitor c=cload ic=0.55
ends ring3

subckt qphase (loi qn qp vdd)
parameters cphase=1p
RQP (loi qrc) resistor r=1k
CQP (qrc 0) capacitor c=cphase
XQB (qrc qn vdd) inv45
XINVQ (qn qp vdd) inv45
ends qphase

subckt gilbert_demod (rfp rfn lop lon outp outn vb vdd)
MTAIL (tail vb 0 0) NMOS_VTL w=600n l=90n
MRFP (xp rfp tail 0) NMOS_VTL w=600n l=90n
MRFN (xn rfn tail 0) NMOS_VTL w=600n l=90n
MSW1 (outp lop xp 0) NMOS_VTL w=600n l=90n
MSW2 (outn lon xp 0) NMOS_VTL w=600n l=90n
MSW3 (outp lon xn 0) NMOS_VTL w=600n l=90n
MSW4 (outn lop xn 0) NMOS_VTL w=600n l=90n
RLP (vdd outp) resistor r=5k
RLN (vdd outn) resistor r=5k
CINTP (outp 0) capacitor c=2p
CINTN (outn 0) capacitor c=2p
ends gilbert_demod

subckt sample_hold (in samp clki clkn vdd)
MN (samp clki in 0) NMOS_VTL w=600n l=45n
MP (samp clkn in vdd) PMOS_VTL w=1.2u l=45n
CS (samp 0) capacitor c=100f
ends sample_hold

subckt dynamic_slicer (inp inn clke dtrue dcomp vdd)
MPRP (xp clke vdd vdd) PMOS_VTL w=1.2u l=45n
MPRN (xn clke vdd vdd) PMOS_VTL w=1.2u l=45n
MIP (xp inp tail 0) NMOS_VTL w=1u l=90n
MIN (xn inn tail 0) NMOS_VTL w=1u l=90n
MT (tail clke 0 0) NMOS_VTL w=1u l=90n
MLP (xp xn tail 0) NMOS_VTL w=1u l=45n
MLN (xn xp tail 0) NMOS_VTL w=1u l=45n
MCP (xp xn vdd vdd) PMOS_VTL w=1.2u l=45n
MCN (xn xp vdd vdd) PMOS_VTL w=1.2u l=45n
XBP (xp dtrue vdd) inv45
XBN (xn dcomp vdd) inv45
ends dynamic_slicer

parameters vdd=1.1
VDD (vdd 0) vsource dc=vdd

// Four baseband fixtures control four physical PMOS carrier-current cells feeding one bitline.
VBB250 (vbb250 0) vsource type=pwl wave=[0 0.68 35n 0.68 35.1n 0.60 80n 0.60]
VBB500 (vbb500 0) vsource type=pwl wave=[0 0.67 35n 0.67 35.1n 0.63 80n 0.63]
VBB750 (vbb750 0) vsource dc=0.66
VBB1G (vbb1g 0) vsource dc=0.65

XLO250 (loi250p vdd) ring3 cload=380f
XINV250 (loi250p loi250n vdd) inv45
XQ250 (loi250p loq250n loq250p vdd) qphase cphase=4p
MPA250 (nmod250 vbb250 vdd vdd) PMOS_VTL w=500n l=45n
MMS250 (bl loi250n nmod250 vdd) PMOS_VTL w=1u l=45n
XLO500 (loi500p vdd) ring3 cload=190f
XINV500 (loi500p loi500n vdd) inv45
XQ500 (loi500p loq500n loq500p vdd) qphase cphase=2p
MPA500 (nmod500 vbb500 vdd vdd) PMOS_VTL w=500n l=45n
MMS500 (bl loi500n nmod500 vdd) PMOS_VTL w=1u l=45n
XLO750 (loi750p vdd) ring3 cload=127f
XINV750 (loi750p loi750n vdd) inv45
XQ750 (loi750p loq750n loq750p vdd) qphase cphase=1.333p
MPA750 (nmod750 vbb750 vdd vdd) PMOS_VTL w=500n l=45n
MMS750 (bl loi750n nmod750 vdd) PMOS_VTL w=1u l=45n
XLO1G (loi1gp vdd) ring3 cload=95f
XINV1G (loi1gp loi1gn vdd) inv45
XQ1G (loi1gp loq1gn loq1gp vdd) qphase cphase=1p
MPA1G (nmod1g vbb1g vdd vdd) PMOS_VTL w=500n l=45n
MMS1G (bl loi1gn nmod1g vdd) PMOS_VTL w=1u l=45n

// One physical bitline TIA receives the summed four-carrier current.
RPB (vbp 0) resistor r=1.4k
MPREF (vbp vbp vdd vdd) PMOS_VTL w=1u l=45n
MPIN (tiaout vbp bl vdd) PMOS_VTL w=1u l=45n
RTIA (tiaout 0) resistor r=5k
CTIA (tiaout 0) capacitor c=10f
RVCMH (vdd vcm) resistor r=20k
RVCML (vcm 0) resistor r=20k
CVCM (vcm 0) capacitor c=10p
CRFP (tiaout rfp) capacitor c=100f
RRFBIAS (rfp vcm) resistor r=50k
RRFNBIAS (rfn vcm) resistor r=50k
RNB (vdd vbn) resistor r=10k
MNREF (vbn vbn 0 0) NMOS_VTL w=600n l=90n

XI250 (rfp rfn loi250p loi250n i250p i250n vbn vdd) gilbert_demod
XQ250D (rfp rfn loq250p loq250n q250p q250n vbn vdd) gilbert_demod
XI500 (rfp rfn loi500p loi500n i500p i500n vbn vdd) gilbert_demod
XQ500D (rfp rfn loq500p loq500n q500p q500n vbn vdd) gilbert_demod
XI750 (rfp rfn loi750p loi750n i750p i750n vbn vdd) gilbert_demod
XQ750D (rfp rfn loq750p loq750n q750p q750n vbn vdd) gilbert_demod
XI1G (rfp rfn loi1gp loi1gn i1gp i1gn vbn vdd) gilbert_demod
XQ1GD (rfp rfn loq1gp loq1gn q1gp q1gn vbn vdd) gilbert_demod

VCLK (clki 0) vsource type=pulse val0=0 val1=1.1 delay=20n rise=20p fall=20p width=1n period=10n
VCLKE (clke 0) vsource type=pulse val0=0 val1=1.1 delay=21.2n rise=20p fall=20p width=3n period=10n
XCLKI (clki clkn vdd) inv45
XCLKE (clke clkne vdd) inv45
VCLKH (clkh 0) vsource type=pulse val0=0 val1=1.1 delay=23.50n rise=20p fall=20p width=400p period=10n
XCLKH (clkh clkhn vdd) inv45

XSI250P (i250p si250p clki clkn vdd) sample_hold
XSI250N (i250n si250n clki clkn vdd) sample_hold
XSQ250P (q250p sq250p clki clkn vdd) sample_hold
XSQ250N (q250n sq250n clki clkn vdd) sample_hold
XSI500P (i500p si500p clki clkn vdd) sample_hold
XSI500N (i500n si500n clki clkn vdd) sample_hold
XSQ500P (q500p sq500p clki clkn vdd) sample_hold
XSQ500N (q500n sq500n clki clkn vdd) sample_hold
XSI750P (i750p si750p clki clkn vdd) sample_hold
XSI750N (i750n si750n clki clkn vdd) sample_hold
XSQ750P (q750p sq750p clki clkn vdd) sample_hold
XSQ750N (q750n sq750n clki clkn vdd) sample_hold
XSI1GP (i1gp si1gp clki clkn vdd) sample_hold
XSI1GN (i1gn si1gn clki clkn vdd) sample_hold
XSQ1GP (q1gp sq1gp clki clkn vdd) sample_hold
XSQ1GN (q1gn sq1gn clki clkn vdd) sample_hold

XDI250 (si250p si250n clke di250t di250c vdd) dynamic_slicer
XDQ250 (sq250p sq250n clke dq250t dq250c vdd) dynamic_slicer
XDI500 (si500p si500n clke di500t di500c vdd) dynamic_slicer
XDQ500 (sq500p sq500n clke dq500t dq500c vdd) dynamic_slicer
XDI750 (si750p si750n clke di750t di750c vdd) dynamic_slicer
XDQ750 (sq750p sq750n clke dq750t dq750c vdd) dynamic_slicer
XDI1G (si1gp si1gn clke di1gt di1gc vdd) dynamic_slicer
XDQ1G (sq1gp sq1gn clke dq1gt dq1gc vdd) dynamic_slicer

XLDI250 (di250t dbi250 clkh clkhn vdd) sample_hold
XLDQ250 (dq250t dbq250 clkh clkhn vdd) sample_hold
XLDI500 (di500t dbi500 clkh clkhn vdd) sample_hold
XLDQ500 (dq500t dbq500 clkh clkhn vdd) sample_hold
XLDI750 (di750t dbi750 clkh clkhn vdd) sample_hold
XLDQ750 (dq750t dbq750 clkh clkhn vdd) sample_hold
XLDI1G (di1gt dbi1g clkh clkhn vdd) sample_hold
XLDQ1G (dq1gt dbq1g clkh clkhn vdd) sample_hold

tran tran stop=80n maxstep=1p skipdc=yes
save bl tiaout rfp rfn clki clke i250p i250n q250p q250n i500p i500n q500p q500n i750p i750n q750p q750n i1gp i1gn q1gp q1gn di250t di250c dq250t dq250c di500t di500c dq500t dq500c di750t di750c dq750t dq750c di1gt di1gc dq1gt dq1gc dbi250 dbq250 dbi500 dbq500 dbi750 dbq750 dbi1g dbq1g
