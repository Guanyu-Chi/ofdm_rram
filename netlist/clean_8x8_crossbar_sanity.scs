// Sanity read-state OFDM/QAM-RRAM crossbar netlist
simulator lang=spectre
global 0 vdd
model nsel mos1 type=n vto=0.35 kp=250u lambda=0.05
VDD (vdd 0) vsource dc=1.0

VWL000 (wl000 0) vsource type=pwl wave=[ 0.000000000000e+00 0.000000000000e+00 2.500000000000e-10 -1.397824734759e-01 5.000000000000e-10 -3.414213562373e-01 7.500000000000e-10 -1.331821362081e-01 1.000000000000e-09 9.714451465470e-17 1.250000000000e-09 -3.993211525331e-01 1.500000000000e-09 -5.414213562373e-01 1.750000000000e-09 3.027339492126e-01 2.000000000000e-09 1.200000000000e+00 2.250000000000e-09 9.054678984252e-01 2.500000000000e-09 -5.857864376269e-02 2.750000000000e-09 -3.496605762665e-01 3.000000000000e-09 -2.636779683485e-16 3.250000000000e-09 3.363572758386e-02 3.500000000000e-09 -2.585786437627e-01 3.750000000000e-09 -2.198912367380e-01 4.000000000000e-09 3.885780586188e-16 4.250000000000e-09 -1.397824734759e-01 4.500000000000e-09 -3.414213562373e-01 4.750000000000e-09 -1.331821362081e-01 5.000000000000e-09 6.522560269673e-16 5.250000000000e-09 -3.993211525331e-01 5.500000000000e-09 -5.414213562373e-01 5.750000000000e-09 3.027339492126e-01 6.000000000000e-09 1.200000000000e+00 6.250000000000e-09 9.054678984252e-01 6.500000000000e-09 -5.857864376269e-02 6.750000000000e-09 -3.496605762665e-01 7.000000000000e-09 2.775557561563e-17 7.250000000000e-09 3.363572758386e-02 7.500000000000e-09 -2.585786437627e-01 7.750000000000e-09 -2.198912367380e-01 8.000000000000e-09 8.326672684689e-16 8.250000000000e-09 -1.397824734759e-01 8.500000000000e-09 -3.414213562373e-01 8.750000000000e-09 -1.331821362081e-01 9.000000000000e-09 -4.579669976579e-16 9.250000000000e-09 -3.993211525331e-01 9.500000000000e-09 -5.414213562373e-01 9.750000000000e-09 3.027339492126e-01 1.000000000000e-08 1.200000000000e+00 1.025000000000e-08 9.054678984252e-01 1.050000000000e-08 -5.857864376269e-02 1.075000000000e-08 -3.496605762665e-01 1.100000000000e-08 -1.804112415016e-16 1.125000000000e-08 3.363572758386e-02 1.150000000000e-08 -2.585786437627e-01 1.175000000000e-08 -2.198912367380e-01 1.200000000000e-08 1.609823385706e-15 1.225000000000e-08 -1.397824734759e-01 1.250000000000e-08 -3.414213562373e-01 1.275000000000e-08 -1.331821362081e-01 1.300000000000e-08 1.706967900361e-15 1.325000000000e-08 -3.993211525331e-01 1.350000000000e-08 -5.414213562373e-01 1.375000000000e-08 3.027339492126e-01 1.400000000000e-08 1.200000000000e+00 1.425000000000e-08 9.054678984252e-01 1.450000000000e-08 -5.857864376269e-02 1.475000000000e-08 -3.496605762665e-01 1.500000000000e-08 -7.216449660064e-16 1.525000000000e-08 3.363572758386e-02 1.550000000000e-08 -2.585786437627e-01 1.575000000000e-08 -2.198912367380e-01 1.600000000000e-08 1.554312234475e-15 1.625000000000e-08 -1.397824734759e-01 1.650000000000e-08 -3.414213562373e-01 1.675000000000e-08 -1.331821362081e-01 1.700000000000e-08 1.804112415016e-15 1.725000000000e-08 -3.993211525331e-01 1.750000000000e-08 -5.414213562373e-01 1.775000000000e-08 3.027339492126e-01 1.800000000000e-08 1.200000000000e+00 1.825000000000e-08 9.054678984252e-01 1.850000000000e-08 -5.857864376269e-02 1.875000000000e-08 -3.496605762665e-01 1.900000000000e-08 -2.720046410332e-15 1.925000000000e-08 3.363572758386e-02 1.950000000000e-08 -2.585786437627e-01 1.975000000000e-08 -2.198912367380e-01 2.000000000000e-08 4.440892098501e-16 2.025000000000e-08 -1.397824734759e-01 2.050000000000e-08 -3.414213562373e-01 2.075000000000e-08 -1.331821362081e-01 2.100000000000e-08 -1.804112415016e-16 2.125000000000e-08 -3.993211525331e-01 2.150000000000e-08 -5.414213562373e-01 2.175000000000e-08 3.027339492126e-01 2.200000000000e-08 1.200000000000e+00 2.225000000000e-08 9.054678984252e-01 2.250000000000e-08 -5.857864376270e-02 2.275000000000e-08 -3.496605762665e-01 2.300000000000e-08 -1.137978600241e-15 2.325000000000e-08 3.363572758386e-02 2.350000000000e-08 -2.585786437627e-01 2.375000000000e-08 -2.198912367380e-01 2.400000000000e-08 3.275157922644e-15 2.425000000000e-08 -1.397824734759e-01 2.450000000000e-08 -3.414213562373e-01 2.475000000000e-08 -1.331821362081e-01 2.500000000000e-08 2.040034807749e-15 2.525000000000e-08 -3.993211525331e-01 2.550000000000e-08 -5.414213562373e-01 2.575000000000e-08 3.027339492126e-01 2.600000000000e-08 1.200000000000e+00 2.625000000000e-08 9.054678984252e-01 2.650000000000e-08 -5.857864376270e-02 2.675000000000e-08 -3.496605762665e-01 2.700000000000e-08 -2.775557561563e-15 2.725000000000e-08 3.363572758386e-02 2.750000000000e-08 -2.585786437627e-01 2.775000000000e-08 -2.198912367380e-01 2.800000000000e-08 2.442490654175e-15 2.825000000000e-08 -1.397824734759e-01 2.850000000000e-08 -3.414213562373e-01 2.875000000000e-08 -1.331821362081e-01 2.900000000000e-08 4.260480856999e-15 2.925000000000e-08 -3.993211525331e-01 2.950000000000e-08 -5.414213562373e-01 2.975000000000e-08 3.027339492126e-01 3.000000000000e-08 1.200000000000e+00 3.025000000000e-08 9.054678984252e-01 3.050000000000e-08 -5.857864376269e-02 3.075000000000e-08 -3.496605762665e-01 3.100000000000e-08 -5.065392549852e-15 3.125000000000e-08 3.363572758385e-02 3.150000000000e-08 -2.585786437627e-01 3.175000000000e-08 -2.198912367380e-01 3.200000000000e-08 3.219646771413e-15 3.225000000000e-08 -1.397824734759e-01 3.250000000000e-08 -3.414213562373e-01 3.275000000000e-08 -1.331821362081e-01 3.300000000000e-08 1.471045507628e-15 3.325000000000e-08 -3.993211525331e-01 3.350000000000e-08 -5.414213562373e-01 3.375000000000e-08 3.027339492126e-01 3.400000000000e-08 1.200000000000e+00 3.425000000000e-08 9.054678984252e-01 3.450000000000e-08 -5.857864376270e-02 3.475000000000e-08 -3.496605762665e-01 3.500000000000e-08 4.440892098501e-16 3.525000000000e-08 3.363572758385e-02 3.550000000000e-08 -2.585786437627e-01 3.575000000000e-08 -2.198912367380e-01 3.600000000000e-08 9.992007221626e-16 3.625000000000e-08 -1.397824734759e-01 3.650000000000e-08 -3.414213562373e-01 3.675000000000e-08 -1.331821362081e-01 3.700000000000e-08 8.701372955500e-15 3.725000000000e-08 -3.993211525331e-01 3.750000000000e-08 -5.414213562373e-01 3.775000000000e-08 3.027339492126e-01 3.800000000000e-08 1.200000000000e+00 3.825000000000e-08 9.054678984252e-01 3.850000000000e-08 -5.857864376268e-02 3.875000000000e-08 -3.496605762666e-01 3.900000000000e-08 -2.622901895677e-15 3.925000000000e-08 3.363572758385e-02 3.950000000000e-08 -2.585786437627e-01 3.975000000000e-08 -2.198912367380e-01 4.000000000000e-08 8.881784197001e-16 4.025000000000e-08 -1.397824734759e-01 4.050000000000e-08 -3.414213562373e-01 4.075000000000e-08 -1.331821362081e-01 4.100000000000e-08 5.981326545168e-15 4.125000000000e-08 -3.993211525331e-01 4.150000000000e-08 -5.414213562373e-01 4.175000000000e-08 3.027339492126e-01 4.200000000000e-08 1.200000000000e+00 4.225000000000e-08 9.054678984252e-01 4.250000000000e-08 -5.857864376269e-02 4.275000000000e-08 -3.496605762666e-01 4.300000000000e-08 -3.538835890993e-15 4.325000000000e-08 3.363572758386e-02 4.350000000000e-08 -2.585786437627e-01 4.375000000000e-08 -2.198912367380e-01 4.400000000000e-08 2.331468351713e-15 4.425000000000e-08 -1.397824734759e-01 4.450000000000e-08 -3.414213562373e-01 4.475000000000e-08 -1.331821362081e-01 4.500000000000e-08 3.191891195797e-15 4.525000000000e-08 -3.993211525331e-01 4.550000000000e-08 -5.414213562373e-01 4.575000000000e-08 3.027339492126e-01 4.600000000000e-08 1.200000000000e+00 4.625000000000e-08 9.054678984252e-01 4.650000000000e-08 -5.857864376270e-02 4.675000000000e-08 -3.496605762665e-01 4.700000000000e-08 1.970645868710e-15 4.725000000000e-08 3.363572758386e-02 4.750000000000e-08 -2.585786437627e-01 4.775000000000e-08 -2.198912367380e-01 4.800000000000e-08 6.550315845288e-15 4.825000000000e-08 -1.397824734759e-01 4.850000000000e-08 -3.414213562373e-01 4.875000000000e-08 -1.331821362081e-01 4.900000000000e-08 1.042221864367e-14 4.925000000000e-08 -3.993211525331e-01 4.950000000000e-08 -5.414213562373e-01 4.975000000000e-08 3.027339492126e-01 5.000000000000e-08 1.200000000000e+00 5.025000000000e-08 9.054678984252e-01 5.050000000000e-08 -5.857864376268e-02 5.075000000000e-08 -3.496605762666e-01 5.100000000000e-08 -8.146261443187e-15 5.125000000000e-08 3.363572758385e-02 5.150000000000e-08 -2.585786437627e-01 5.175000000000e-08 -2.198912367380e-01 5.200000000000e-08 3.608224830032e-15 5.225000000000e-08 -1.397824734759e-01 5.250000000000e-08 -3.414213562373e-01 5.275000000000e-08 -1.331821362081e-01 5.300000000000e-08 7.688294445529e-15 5.325000000000e-08 -3.993211525331e-01 5.350000000000e-08 -5.414213562373e-01 5.375000000000e-08 3.027339492126e-01 5.400000000000e-08 1.200000000000e+00 5.425000000000e-08 9.054678984252e-01 5.450000000000e-08 -5.857864376270e-02 5.475000000000e-08 -3.496605762665e-01 5.500000000000e-08 -1.121325254871e-14 5.525000000000e-08 3.363572758385e-02 5.550000000000e-08 -2.585786437627e-01 5.575000000000e-08 -2.198912367379e-01 5.600000000000e-08 5.051514762044e-15 5.625000000000e-08 -1.397824734759e-01 5.650000000000e-08 -3.414213562373e-01 5.675000000000e-08 -1.331821362081e-01 5.700000000000e-08 6.411537967210e-15 5.725000000000e-08 -3.993211525331e-01 5.750000000000e-08 -5.414213562373e-01 5.775000000000e-08 3.027339492126e-01 5.800000000000e-08 1.200000000000e+00 5.825000000000e-08 9.054678984252e-01 5.850000000000e-08 -5.857864376269e-02 5.875000000000e-08 -3.496605762665e-01 5.900000000000e-08 2.803313137179e-15 5.925000000000e-08 3.363572758384e-02 5.950000000000e-08 -2.585786437627e-01 5.975000000000e-08 -2.198912367380e-01 6.000000000000e-08 9.214851104389e-15 6.025000000000e-08 -1.397824734759e-01 6.050000000000e-08 -3.414213562373e-01 6.075000000000e-08 -1.331821362081e-01 6.100000000000e-08 5.051514762044e-15 6.125000000000e-08 -3.993211525331e-01 6.150000000000e-08 -5.414213562373e-01 6.175000000000e-08 3.027339492126e-01 6.200000000000e-08 1.200000000000e+00 6.225000000000e-08 9.054678984252e-01 6.250000000000e-08 -5.857864376272e-02 6.275000000000e-08 -3.496605762665e-01 6.300000000000e-08 -2.775557561563e-16 6.325000000000e-08 3.363572758385e-02 6.350000000000e-08 -2.585786437627e-01 6.375000000000e-08 -2.198912367380e-01 6.400000000000e-08 6.272760089132e-15 6.425000000000e-08 -1.397824734759e-01 6.450000000000e-08 -3.414213562373e-01 6.475000000000e-08 -1.331821362081e-01 6.500000000000e-08 1.079691891448e-14 6.525000000000e-08 -3.993211525331e-01 6.550000000000e-08 -5.414213562373e-01 6.575000000000e-08 3.027339492126e-01 6.600000000000e-08 1.200000000000e+00 6.625000000000e-08 9.054678984252e-01 6.650000000000e-08 -5.857864376270e-02 6.675000000000e-08 -3.496605762666e-01 6.700000000000e-08 -1.859623566247e-15 6.725000000000e-08 3.363572758384e-02 6.750000000000e-08 -2.585786437627e-01 6.775000000000e-08 -2.198912367380e-01 6.800000000000e-08 3.441691376338e-15 6.825000000000e-08 -1.397824734759e-01 6.850000000000e-08 -3.414213562373e-01 6.875000000000e-08 -1.331821362081e-01 6.900000000000e-08 -4.163336342344e-16 6.925000000000e-08 -3.993211525331e-01 6.950000000000e-08 -5.414213562373e-01 6.975000000000e-08 3.027339492126e-01 7.000000000000e-08 1.200000000000e+00 7.025000000000e-08 9.054678984251e-01 7.050000000000e-08 -5.857864376269e-02 7.075000000000e-08 -3.496605762665e-01 7.100000000000e-08 -3.511080315377e-15 7.125000000000e-08 3.363572758384e-02 7.150000000000e-08 -2.585786437627e-01 7.175000000000e-08 -2.198912367379e-01 7.200000000000e-08 1.942890293094e-15 7.225000000000e-08 -1.397824734759e-01 7.250000000000e-08 -3.414213562373e-01 7.275000000000e-08 -1.331821362081e-01 7.300000000000e-08 -1.762479051592e-15 7.325000000000e-08 -3.993211525331e-01 7.350000000000e-08 -5.414213562373e-01 7.375000000000e-08 3.027339492126e-01 7.400000000000e-08 1.200000000000e+00 7.425000000000e-08 9.054678984251e-01 7.450000000000e-08 -5.857864376268e-02 7.475000000000e-08 -3.496605762665e-01 7.500000000000e-08 -6.480926906249e-15 7.525000000000e-08 3.363572758385e-02 7.550000000000e-08 -2.585786437627e-01 7.575000000000e-08 -2.198912367379e-01 7.600000000000e-08 4.829470157119e-15 7.625000000000e-08 -1.397824734759e-01 7.650000000000e-08 -3.414213562373e-01 7.675000000000e-08 -1.331821362081e-01 7.700000000000e-08 1.398881011028e-14 7.725000000000e-08 -3.993211525331e-01 7.750000000000e-08 -5.414213562373e-01 7.775000000000e-08 3.027339492126e-01 7.800000000000e-08 1.200000000000e+00 7.825000000000e-08 9.054678984252e-01 7.850000000000e-08 -5.857864376271e-02 7.875000000000e-08 -3.496605762665e-01 7.900000000000e-08 -9.561795799584e-15 7.925000000000e-08 3.363572758385e-02 7.950000000000e-08 -2.585786437627e-01 7.975000000000e-08 -2.198912367380e-01 8.000000000000e-08 1.887379141863e-15 ]
VWL001 (wl001 0) vsource type=pwl wave=[ 0.000000000000e+00 0.000000000000e+00 2.500000000000e-10 -1.801087632620e-01 5.000000000000e-10 2.426406871193e-02 7.500000000000e-10 2.336357275839e-01 1.000000000000e-09 -9.714451465470e-17 1.250000000000e-09 -5.033942373345e-02 1.500000000000e-09 6.242640687119e-01 1.750000000000e-09 1.105467898425e+00 2.000000000000e-09 4.000000000000e-01 2.250000000000e-09 -7.027339492126e-01 2.500000000000e-09 -8.242640687119e-01 2.750000000000e-09 -1.993211525331e-01 3.000000000000e-09 -5.412337245048e-16 3.250000000000e-09 -2.668178637919e-01 3.500000000000e-09 -2.242640687119e-01 3.750000000000e-09 6.021752652407e-02 4.000000000000e-09 -1.193489751472e-15 4.250000000000e-09 -1.801087632620e-01 4.500000000000e-09 2.426406871193e-02 4.750000000000e-09 2.336357275839e-01 5.000000000000e-09 4.024558464266e-16 5.250000000000e-09 -5.033942373345e-02 5.500000000000e-09 6.242640687119e-01 5.750000000000e-09 1.105467898425e+00 6.000000000000e-09 4.000000000000e-01 6.250000000000e-09 -7.027339492126e-01 6.500000000000e-09 -8.242640687119e-01 6.750000000000e-09 -1.993211525331e-01 7.000000000000e-09 -8.743006318923e-16 7.250000000000e-09 -2.668178637919e-01 7.500000000000e-09 -2.242640687119e-01 7.750000000000e-09 6.021752652407e-02 8.000000000000e-09 -2.373101715136e-15 8.250000000000e-09 -1.801087632620e-01 8.500000000000e-09 2.426406871193e-02 8.750000000000e-09 2.336357275839e-01 9.000000000000e-09 -1.013078509970e-15 9.250000000000e-09 -5.033942373345e-02 9.500000000000e-09 6.242640687119e-01 9.750000000000e-09 1.105467898425e+00 1.000000000000e-08 4.000000000000e-01 1.025000000000e-08 -7.027339492126e-01 1.050000000000e-08 -8.242640687119e-01 1.075000000000e-08 -1.993211525331e-01 1.100000000000e-08 -7.632783294298e-16 1.125000000000e-08 -2.668178637919e-01 1.150000000000e-08 -2.242640687119e-01 1.175000000000e-08 6.021752652407e-02 1.200000000000e-08 -4.898859096159e-15 1.225000000000e-08 -1.801087632620e-01 1.250000000000e-08 2.426406871193e-02 1.275000000000e-08 2.336357275839e-01 1.300000000000e-08 -4.163336342344e-17 1.325000000000e-08 -5.033942373345e-02 1.350000000000e-08 6.242640687119e-01 1.375000000000e-08 1.105467898425e+00 1.400000000000e-08 4.000000000000e-01 1.425000000000e-08 -7.027339492126e-01 1.450000000000e-08 -8.242640687119e-01 1.475000000000e-08 -1.993211525331e-01 1.500000000000e-08 -3.191891195797e-15 1.525000000000e-08 -2.668178637919e-01 1.550000000000e-08 -2.242640687119e-01 1.575000000000e-08 6.021752652407e-02 1.600000000000e-08 -4.732325642465e-15 1.625000000000e-08 -1.801087632620e-01 1.650000000000e-08 2.426406871193e-02 1.675000000000e-08 2.336357275839e-01 1.700000000000e-08 1.110223024625e-16 1.725000000000e-08 -5.033942373345e-02 1.750000000000e-08 6.242640687119e-01 1.775000000000e-08 1.105467898425e+00 1.800000000000e-08 4.000000000000e-01 1.825000000000e-08 -7.027339492126e-01 1.850000000000e-08 -8.242640687119e-01 1.875000000000e-08 -1.993211525331e-01 1.900000000000e-08 -1.304512053935e-15 1.925000000000e-08 -2.668178637919e-01 1.950000000000e-08 -2.242640687119e-01 1.975000000000e-08 6.021752652407e-02 2.000000000000e-08 -1.387778780781e-15 2.025000000000e-08 -1.801087632620e-01 2.050000000000e-08 2.426406871193e-02 2.075000000000e-08 2.336357275839e-01 2.100000000000e-08 -4.024558464266e-16 2.125000000000e-08 -5.033942373345e-02 2.150000000000e-08 6.242640687119e-01 2.175000000000e-08 1.105467898425e+00 2.200000000000e-08 4.000000000000e-01 2.225000000000e-08 -7.027339492126e-01 2.250000000000e-08 -8.242640687119e-01 2.275000000000e-08 -1.993211525331e-01 2.300000000000e-08 -2.955968803064e-15 2.325000000000e-08 -2.668178637919e-01 2.350000000000e-08 -2.242640687119e-01 2.375000000000e-08 6.021752652407e-02 2.400000000000e-08 -9.769962616701e-15 2.425000000000e-08 -1.801087632620e-01 2.450000000000e-08 2.426406871193e-02 2.475000000000e-08 2.336357275839e-01 2.500000000000e-08 4.718447854657e-16 2.525000000000e-08 -5.033942373345e-02 2.550000000000e-08 6.242640687119e-01 2.575000000000e-08 1.105467898425e+00 2.600000000000e-08 4.000000000000e-01 2.625000000000e-08 -7.027339492126e-01 2.650000000000e-08 -8.242640687119e-01 2.675000000000e-08 -1.993211525331e-01 2.700000000000e-08 1.346145417358e-15 2.725000000000e-08 -2.668178637919e-01 2.750000000000e-08 -2.242640687119e-01 2.775000000000e-08 6.021752652407e-02 2.800000000000e-08 -7.494005416220e-15 2.825000000000e-08 -1.801087632620e-01 2.850000000000e-08 2.426406871193e-02 2.875000000000e-08 2.336357275839e-01 2.900000000000e-08 1.443289932013e-15 2.925000000000e-08 -5.033942373345e-02 2.950000000000e-08 6.242640687119e-01 2.975000000000e-08 1.105467898425e+00 3.000000000000e-08 4.000000000000e-01 3.025000000000e-08 -7.027339492126e-01 3.050000000000e-08 -8.242640687119e-01 3.075000000000e-08 -1.993211525331e-01 3.100000000000e-08 7.632783294298e-16 3.125000000000e-08 -2.668178637919e-01 3.150000000000e-08 -2.242640687119e-01 3.175000000000e-08 6.021752652407e-02 3.200000000000e-08 -9.478529072737e-15 3.225000000000e-08 -1.801087632620e-01 3.250000000000e-08 2.426406871193e-02 3.275000000000e-08 2.336357275839e-01 3.300000000000e-08 -4.052314039882e-15 3.325000000000e-08 -5.033942373345e-02 3.350000000000e-08 6.242640687119e-01 3.375000000000e-08 1.105467898425e+00 3.400000000000e-08 4.000000000000e-01 3.425000000000e-08 -7.027339492126e-01 3.450000000000e-08 -8.242640687119e-01 3.475000000000e-08 -1.993211525331e-01 3.500000000000e-08 -2.012279232133e-15 3.525000000000e-08 -2.668178637919e-01 3.550000000000e-08 -2.242640687119e-01 3.575000000000e-08 6.021752652407e-02 3.600000000000e-08 -2.942091015257e-15 3.625000000000e-08 -1.801087632620e-01 3.650000000000e-08 2.426406871193e-02 3.675000000000e-08 2.336357275839e-01 3.700000000000e-08 3.233524559221e-15 3.725000000000e-08 -5.033942373346e-02 3.750000000000e-08 6.242640687119e-01 3.775000000000e-08 1.105467898425e+00 3.800000000000e-08 4.000000000000e-01 3.825000000000e-08 -7.027339492126e-01 3.850000000000e-08 -8.242640687119e-01 3.875000000000e-08 -1.993211525331e-01 3.900000000000e-08 -7.591149930875e-15 3.925000000000e-08 -2.668178637919e-01 3.950000000000e-08 -2.242640687119e-01 3.975000000000e-08 6.021752652407e-02 4.000000000000e-08 -2.789435349371e-15 4.025000000000e-08 -1.801087632620e-01 4.050000000000e-08 2.426406871194e-02 4.075000000000e-08 2.336357275839e-01 4.100000000000e-08 -2.275957200482e-15 4.125000000000e-08 -5.033942373345e-02 4.150000000000e-08 6.242640687119e-01 4.175000000000e-08 1.105467898425e+00 4.200000000000e-08 4.000000000000e-01 4.225000000000e-08 -7.027339492126e-01 4.250000000000e-08 -8.242640687119e-01 4.275000000000e-08 -1.993211525331e-01 4.300000000000e-08 1.748601263785e-15 4.325000000000e-08 -2.668178637919e-01 4.350000000000e-08 -2.242640687119e-01 4.375000000000e-08 6.021752652407e-02 4.400000000000e-08 -6.911138328292e-15 4.425000000000e-08 -1.801087632620e-01 4.450000000000e-08 2.426406871193e-02 4.475000000000e-08 2.336357275839e-01 4.500000000000e-08 -7.716050021145e-15 4.525000000000e-08 -5.033942373345e-02 4.550000000000e-08 6.242640687119e-01 4.575000000000e-08 1.105467898425e+00 4.600000000000e-08 4.000000000000e-01 4.625000000000e-08 -7.027339492126e-01 4.650000000000e-08 -8.242640687119e-01 4.675000000000e-08 -1.993211525331e-01 4.700000000000e-08 -9.714451465470e-16 4.725000000000e-08 -2.668178637919e-01 4.750000000000e-08 -2.242640687119e-01 4.775000000000e-08 6.021752652407e-02 4.800000000000e-08 -1.955380302121e-14 4.825000000000e-08 -1.801087632620e-01 4.850000000000e-08 2.426406871194e-02 4.875000000000e-08 2.336357275839e-01 4.900000000000e-08 -4.302114220422e-16 4.925000000000e-08 -5.033942373345e-02 4.950000000000e-08 6.242640687119e-01 4.975000000000e-08 1.105467898425e+00 5.000000000000e-08 4.000000000000e-01 5.025000000000e-08 -7.027339492126e-01 5.050000000000e-08 -8.242640687119e-01 5.075000000000e-08 -1.993211525331e-01 5.100000000000e-08 5.551115123126e-16 5.125000000000e-08 -2.668178637919e-01 5.150000000000e-08 -2.242640687119e-01 5.175000000000e-08 6.021752652407e-02 5.200000000000e-08 -1.088018564133e-14 5.225000000000e-08 -1.801087632620e-01 5.250000000000e-08 2.426406871193e-02 5.275000000000e-08 2.336357275839e-01 5.300000000000e-08 -5.925815393937e-15 5.325000000000e-08 -5.033942373345e-02 5.350000000000e-08 6.242640687119e-01 5.375000000000e-08 1.105467898425e+00 5.400000000000e-08 4.000000000000e-01 5.425000000000e-08 -7.027339492126e-01 5.450000000000e-08 -8.242640687119e-01 5.475000000000e-08 -1.993211525331e-01 5.500000000000e-08 -5.065392549852e-15 5.525000000000e-08 -2.668178637919e-01 5.550000000000e-08 -2.242640687119e-01 5.575000000000e-08 6.021752652407e-02 5.600000000000e-08 -1.498801083244e-14 5.625000000000e-08 -1.801087632620e-01 5.650000000000e-08 2.426406871194e-02 5.675000000000e-08 2.336357275839e-01 5.700000000000e-08 -1.457167719821e-15 5.725000000000e-08 -5.033942373345e-02 5.750000000000e-08 6.242640687119e-01 5.775000000000e-08 1.105467898425e+00 5.800000000000e-08 4.000000000000e-01 5.825000000000e-08 -7.027339492126e-01 5.850000000000e-08 -8.242640687119e-01 5.875000000000e-08 -1.993211525331e-01 5.900000000000e-08 -4.968248035198e-15 5.925000000000e-08 -2.668178637919e-01 5.950000000000e-08 -2.242640687119e-01 5.975000000000e-08 6.021752652407e-02 6.000000000000e-08 -2.765843110097e-14 6.025000000000e-08 -1.801087632620e-01 6.050000000000e-08 2.426406871195e-02 6.075000000000e-08 2.336357275839e-01 6.100000000000e-08 2.942091015257e-15 6.125000000000e-08 -5.033942373345e-02 6.150000000000e-08 6.242640687119e-01 6.175000000000e-08 1.105467898425e+00 6.200000000000e-08 4.000000000000e-01 6.225000000000e-08 -7.027339492126e-01 6.250000000000e-08 -8.242640687119e-01 6.275000000000e-08 -1.993211525331e-01 6.300000000000e-08 -1.051936315832e-14 6.325000000000e-08 -2.668178637919e-01 6.350000000000e-08 -2.242640687119e-01 6.375000000000e-08 6.021752652407e-02 6.400000000000e-08 -1.897093593328e-14 6.425000000000e-08 -1.801087632620e-01 6.450000000000e-08 2.426406871195e-02 6.475000000000e-08 2.336357275839e-01 6.500000000000e-08 3.330669073875e-16 6.525000000000e-08 -5.033942373345e-02 6.550000000000e-08 6.242640687119e-01 6.575000000000e-08 1.105467898425e+00 6.600000000000e-08 4.000000000000e-01 6.625000000000e-08 -7.027339492126e-01 6.650000000000e-08 -8.242640687119e-01 6.675000000000e-08 -1.993211525331e-01 6.700000000000e-08 -6.161737786670e-15 6.725000000000e-08 -2.668178637919e-01 6.750000000000e-08 -2.242640687119e-01 6.775000000000e-08 6.021752652407e-02 6.800000000000e-08 -1.028344076559e-14 6.825000000000e-08 -1.801087632620e-01 6.850000000000e-08 2.426406871194e-02 6.875000000000e-08 2.336357275839e-01 6.900000000000e-08 -7.993605777301e-15 6.925000000000e-08 -5.033942373346e-02 6.950000000000e-08 6.242640687119e-01 6.975000000000e-08 1.105467898425e+00 7.000000000000e-08 4.000000000000e-01 7.025000000000e-08 -7.027339492126e-01 7.050000000000e-08 -8.242640687119e-01 7.075000000000e-08 -1.993211525331e-01 7.100000000000e-08 -1.817990202824e-15 7.125000000000e-08 -2.668178637919e-01 7.150000000000e-08 -2.242640687119e-01 7.175000000000e-08 6.021752652407e-02 7.200000000000e-08 -5.884182030513e-15 7.225000000000e-08 -1.801087632620e-01 7.250000000000e-08 2.426406871194e-02 7.275000000000e-08 2.336357275839e-01 7.300000000000e-08 -3.524958103185e-15 7.325000000000e-08 -5.033942373344e-02 7.350000000000e-08 6.242640687119e-01 7.375000000000e-08 1.105467898425e+00 7.400000000000e-08 4.000000000000e-01 7.425000000000e-08 -7.027339492126e-01 7.450000000000e-08 -8.242640687119e-01 7.475000000000e-08 -1.993211525331e-01 7.500000000000e-08 -7.369105325949e-15 7.525000000000e-08 -2.668178637919e-01 7.550000000000e-08 -2.242640687119e-01 7.575000000000e-08 6.021752652407e-02 7.600000000000e-08 -1.426636586643e-14 7.625000000000e-08 -1.801087632620e-01 7.650000000000e-08 2.426406871193e-02 7.675000000000e-08 2.336357275839e-01 7.700000000000e-08 6.647460359943e-15 7.725000000000e-08 -5.033942373345e-02 7.750000000000e-08 6.242640687119e-01 7.775000000000e-08 1.105467898425e+00 7.800000000000e-08 4.000000000000e-01 7.825000000000e-08 -7.027339492126e-01 7.850000000000e-08 -8.242640687119e-01 7.875000000000e-08 -1.993211525331e-01 7.900000000000e-08 -1.297573160031e-14 7.925000000000e-08 -2.668178637919e-01 7.950000000000e-08 -2.242640687119e-01 7.975000000000e-08 6.021752652407e-02 8.000000000000e-08 -5.578870698741e-15 ]
VWL002 (wl002 0) vsource type=pwl wave=[ 0.000000000000e+00 0.000000000000e+00 2.500000000000e-10 1.397824734759e-01 5.000000000000e-10 3.414213562373e-01 7.500000000000e-10 1.331821362081e-01 1.000000000000e-09 -9.714451465470e-17 1.250000000000e-09 3.993211525331e-01 1.500000000000e-09 5.414213562373e-01 1.750000000000e-09 -3.027339492126e-01 2.000000000000e-09 -1.200000000000e+00 2.250000000000e-09 -9.054678984252e-01 2.500000000000e-09 5.857864376269e-02 2.750000000000e-09 3.496605762665e-01 3.000000000000e-09 2.636779683485e-16 3.250000000000e-09 -3.363572758386e-02 3.500000000000e-09 2.585786437627e-01 3.750000000000e-09 2.198912367380e-01 4.000000000000e-09 -3.885780586188e-16 4.250000000000e-09 1.397824734759e-01 4.500000000000e-09 3.414213562373e-01 4.750000000000e-09 1.331821362081e-01 5.000000000000e-09 -6.522560269673e-16 5.250000000000e-09 3.993211525331e-01 5.500000000000e-09 5.414213562373e-01 5.750000000000e-09 -3.027339492126e-01 6.000000000000e-09 -1.200000000000e+00 6.250000000000e-09 -9.054678984252e-01 6.500000000000e-09 5.857864376269e-02 6.750000000000e-09 3.496605762665e-01 7.000000000000e-09 -2.775557561563e-17 7.250000000000e-09 -3.363572758386e-02 7.500000000000e-09 2.585786437627e-01 7.750000000000e-09 2.198912367380e-01 8.000000000000e-09 -8.326672684689e-16 8.250000000000e-09 1.397824734759e-01 8.500000000000e-09 3.414213562373e-01 8.750000000000e-09 1.331821362081e-01 9.000000000000e-09 4.579669976579e-16 9.250000000000e-09 3.993211525331e-01 9.500000000000e-09 5.414213562373e-01 9.750000000000e-09 -3.027339492126e-01 1.000000000000e-08 -1.200000000000e+00 1.025000000000e-08 -9.054678984252e-01 1.050000000000e-08 5.857864376269e-02 1.075000000000e-08 3.496605762665e-01 1.100000000000e-08 1.804112415016e-16 1.125000000000e-08 -3.363572758386e-02 1.150000000000e-08 2.585786437627e-01 1.175000000000e-08 2.198912367380e-01 1.200000000000e-08 -1.609823385706e-15 1.225000000000e-08 1.397824734759e-01 1.250000000000e-08 3.414213562373e-01 1.275000000000e-08 1.331821362081e-01 1.300000000000e-08 -1.706967900361e-15 1.325000000000e-08 3.993211525331e-01 1.350000000000e-08 5.414213562373e-01 1.375000000000e-08 -3.027339492126e-01 1.400000000000e-08 -1.200000000000e+00 1.425000000000e-08 -9.054678984252e-01 1.450000000000e-08 5.857864376269e-02 1.475000000000e-08 3.496605762665e-01 1.500000000000e-08 7.216449660064e-16 1.525000000000e-08 -3.363572758386e-02 1.550000000000e-08 2.585786437627e-01 1.575000000000e-08 2.198912367380e-01 1.600000000000e-08 -1.554312234475e-15 1.625000000000e-08 1.397824734759e-01 1.650000000000e-08 3.414213562373e-01 1.675000000000e-08 1.331821362081e-01 1.700000000000e-08 -1.804112415016e-15 1.725000000000e-08 3.993211525331e-01 1.750000000000e-08 5.414213562373e-01 1.775000000000e-08 -3.027339492126e-01 1.800000000000e-08 -1.200000000000e+00 1.825000000000e-08 -9.054678984252e-01 1.850000000000e-08 5.857864376269e-02 1.875000000000e-08 3.496605762665e-01 1.900000000000e-08 2.720046410332e-15 1.925000000000e-08 -3.363572758386e-02 1.950000000000e-08 2.585786437627e-01 1.975000000000e-08 2.198912367380e-01 2.000000000000e-08 -4.440892098501e-16 2.025000000000e-08 1.397824734759e-01 2.050000000000e-08 3.414213562373e-01 2.075000000000e-08 1.331821362081e-01 2.100000000000e-08 1.804112415016e-16 2.125000000000e-08 3.993211525331e-01 2.150000000000e-08 5.414213562373e-01 2.175000000000e-08 -3.027339492126e-01 2.200000000000e-08 -1.200000000000e+00 2.225000000000e-08 -9.054678984252e-01 2.250000000000e-08 5.857864376270e-02 2.275000000000e-08 3.496605762665e-01 2.300000000000e-08 1.137978600241e-15 2.325000000000e-08 -3.363572758386e-02 2.350000000000e-08 2.585786437627e-01 2.375000000000e-08 2.198912367380e-01 2.400000000000e-08 -3.275157922644e-15 2.425000000000e-08 1.397824734759e-01 2.450000000000e-08 3.414213562373e-01 2.475000000000e-08 1.331821362081e-01 2.500000000000e-08 -2.040034807749e-15 2.525000000000e-08 3.993211525331e-01 2.550000000000e-08 5.414213562373e-01 2.575000000000e-08 -3.027339492126e-01 2.600000000000e-08 -1.200000000000e+00 2.625000000000e-08 -9.054678984252e-01 2.650000000000e-08 5.857864376270e-02 2.675000000000e-08 3.496605762665e-01 2.700000000000e-08 2.775557561563e-15 2.725000000000e-08 -3.363572758386e-02 2.750000000000e-08 2.585786437627e-01 2.775000000000e-08 2.198912367380e-01 2.800000000000e-08 -2.442490654175e-15 2.825000000000e-08 1.397824734759e-01 2.850000000000e-08 3.414213562373e-01 2.875000000000e-08 1.331821362081e-01 2.900000000000e-08 -4.260480856999e-15 2.925000000000e-08 3.993211525331e-01 2.950000000000e-08 5.414213562373e-01 2.975000000000e-08 -3.027339492126e-01 3.000000000000e-08 -1.200000000000e+00 3.025000000000e-08 -9.054678984252e-01 3.050000000000e-08 5.857864376269e-02 3.075000000000e-08 3.496605762665e-01 3.100000000000e-08 5.065392549852e-15 3.125000000000e-08 -3.363572758385e-02 3.150000000000e-08 2.585786437627e-01 3.175000000000e-08 2.198912367380e-01 3.200000000000e-08 -3.219646771413e-15 3.225000000000e-08 1.397824734759e-01 3.250000000000e-08 3.414213562373e-01 3.275000000000e-08 1.331821362081e-01 3.300000000000e-08 -1.471045507628e-15 3.325000000000e-08 3.993211525331e-01 3.350000000000e-08 5.414213562373e-01 3.375000000000e-08 -3.027339492126e-01 3.400000000000e-08 -1.200000000000e+00 3.425000000000e-08 -9.054678984252e-01 3.450000000000e-08 5.857864376270e-02 3.475000000000e-08 3.496605762665e-01 3.500000000000e-08 -4.440892098501e-16 3.525000000000e-08 -3.363572758385e-02 3.550000000000e-08 2.585786437627e-01 3.575000000000e-08 2.198912367380e-01 3.600000000000e-08 -9.992007221626e-16 3.625000000000e-08 1.397824734759e-01 3.650000000000e-08 3.414213562373e-01 3.675000000000e-08 1.331821362081e-01 3.700000000000e-08 -8.701372955500e-15 3.725000000000e-08 3.993211525331e-01 3.750000000000e-08 5.414213562373e-01 3.775000000000e-08 -3.027339492126e-01 3.800000000000e-08 -1.200000000000e+00 3.825000000000e-08 -9.054678984252e-01 3.850000000000e-08 5.857864376268e-02 3.875000000000e-08 3.496605762666e-01 3.900000000000e-08 2.622901895677e-15 3.925000000000e-08 -3.363572758385e-02 3.950000000000e-08 2.585786437627e-01 3.975000000000e-08 2.198912367380e-01 4.000000000000e-08 -8.881784197001e-16 4.025000000000e-08 1.397824734759e-01 4.050000000000e-08 3.414213562373e-01 4.075000000000e-08 1.331821362081e-01 4.100000000000e-08 -5.981326545168e-15 4.125000000000e-08 3.993211525331e-01 4.150000000000e-08 5.414213562373e-01 4.175000000000e-08 -3.027339492126e-01 4.200000000000e-08 -1.200000000000e+00 4.225000000000e-08 -9.054678984252e-01 4.250000000000e-08 5.857864376269e-02 4.275000000000e-08 3.496605762666e-01 4.300000000000e-08 3.538835890993e-15 4.325000000000e-08 -3.363572758386e-02 4.350000000000e-08 2.585786437627e-01 4.375000000000e-08 2.198912367380e-01 4.400000000000e-08 -2.331468351713e-15 4.425000000000e-08 1.397824734759e-01 4.450000000000e-08 3.414213562373e-01 4.475000000000e-08 1.331821362081e-01 4.500000000000e-08 -3.191891195797e-15 4.525000000000e-08 3.993211525331e-01 4.550000000000e-08 5.414213562373e-01 4.575000000000e-08 -3.027339492126e-01 4.600000000000e-08 -1.200000000000e+00 4.625000000000e-08 -9.054678984252e-01 4.650000000000e-08 5.857864376270e-02 4.675000000000e-08 3.496605762665e-01 4.700000000000e-08 -1.970645868710e-15 4.725000000000e-08 -3.363572758386e-02 4.750000000000e-08 2.585786437627e-01 4.775000000000e-08 2.198912367380e-01 4.800000000000e-08 -6.550315845288e-15 4.825000000000e-08 1.397824734759e-01 4.850000000000e-08 3.414213562373e-01 4.875000000000e-08 1.331821362081e-01 4.900000000000e-08 -1.042221864367e-14 4.925000000000e-08 3.993211525331e-01 4.950000000000e-08 5.414213562373e-01 4.975000000000e-08 -3.027339492126e-01 5.000000000000e-08 -1.200000000000e+00 5.025000000000e-08 -9.054678984252e-01 5.050000000000e-08 5.857864376268e-02 5.075000000000e-08 3.496605762666e-01 5.100000000000e-08 8.146261443187e-15 5.125000000000e-08 -3.363572758385e-02 5.150000000000e-08 2.585786437627e-01 5.175000000000e-08 2.198912367380e-01 5.200000000000e-08 -3.608224830032e-15 5.225000000000e-08 1.397824734759e-01 5.250000000000e-08 3.414213562373e-01 5.275000000000e-08 1.331821362081e-01 5.300000000000e-08 -7.688294445529e-15 5.325000000000e-08 3.993211525331e-01 5.350000000000e-08 5.414213562373e-01 5.375000000000e-08 -3.027339492126e-01 5.400000000000e-08 -1.200000000000e+00 5.425000000000e-08 -9.054678984252e-01 5.450000000000e-08 5.857864376270e-02 5.475000000000e-08 3.496605762665e-01 5.500000000000e-08 1.121325254871e-14 5.525000000000e-08 -3.363572758385e-02 5.550000000000e-08 2.585786437627e-01 5.575000000000e-08 2.198912367379e-01 5.600000000000e-08 -5.051514762044e-15 5.625000000000e-08 1.397824734759e-01 5.650000000000e-08 3.414213562373e-01 5.675000000000e-08 1.331821362081e-01 5.700000000000e-08 -6.411537967210e-15 5.725000000000e-08 3.993211525331e-01 5.750000000000e-08 5.414213562373e-01 5.775000000000e-08 -3.027339492126e-01 5.800000000000e-08 -1.200000000000e+00 5.825000000000e-08 -9.054678984252e-01 5.850000000000e-08 5.857864376269e-02 5.875000000000e-08 3.496605762665e-01 5.900000000000e-08 -2.803313137179e-15 5.925000000000e-08 -3.363572758384e-02 5.950000000000e-08 2.585786437627e-01 5.975000000000e-08 2.198912367380e-01 6.000000000000e-08 -9.214851104389e-15 6.025000000000e-08 1.397824734759e-01 6.050000000000e-08 3.414213562373e-01 6.075000000000e-08 1.331821362081e-01 6.100000000000e-08 -5.051514762044e-15 6.125000000000e-08 3.993211525331e-01 6.150000000000e-08 5.414213562373e-01 6.175000000000e-08 -3.027339492126e-01 6.200000000000e-08 -1.200000000000e+00 6.225000000000e-08 -9.054678984252e-01 6.250000000000e-08 5.857864376272e-02 6.275000000000e-08 3.496605762665e-01 6.300000000000e-08 2.775557561563e-16 6.325000000000e-08 -3.363572758385e-02 6.350000000000e-08 2.585786437627e-01 6.375000000000e-08 2.198912367380e-01 6.400000000000e-08 -6.272760089132e-15 6.425000000000e-08 1.397824734759e-01 6.450000000000e-08 3.414213562373e-01 6.475000000000e-08 1.331821362081e-01 6.500000000000e-08 -1.079691891448e-14 6.525000000000e-08 3.993211525331e-01 6.550000000000e-08 5.414213562373e-01 6.575000000000e-08 -3.027339492126e-01 6.600000000000e-08 -1.200000000000e+00 6.625000000000e-08 -9.054678984252e-01 6.650000000000e-08 5.857864376270e-02 6.675000000000e-08 3.496605762666e-01 6.700000000000e-08 1.859623566247e-15 6.725000000000e-08 -3.363572758384e-02 6.750000000000e-08 2.585786437627e-01 6.775000000000e-08 2.198912367380e-01 6.800000000000e-08 -3.441691376338e-15 6.825000000000e-08 1.397824734759e-01 6.850000000000e-08 3.414213562373e-01 6.875000000000e-08 1.331821362081e-01 6.900000000000e-08 4.163336342344e-16 6.925000000000e-08 3.993211525331e-01 6.950000000000e-08 5.414213562373e-01 6.975000000000e-08 -3.027339492126e-01 7.000000000000e-08 -1.200000000000e+00 7.025000000000e-08 -9.054678984251e-01 7.050000000000e-08 5.857864376269e-02 7.075000000000e-08 3.496605762665e-01 7.100000000000e-08 3.511080315377e-15 7.125000000000e-08 -3.363572758384e-02 7.150000000000e-08 2.585786437627e-01 7.175000000000e-08 2.198912367379e-01 7.200000000000e-08 -1.942890293094e-15 7.225000000000e-08 1.397824734759e-01 7.250000000000e-08 3.414213562373e-01 7.275000000000e-08 1.331821362081e-01 7.300000000000e-08 1.762479051592e-15 7.325000000000e-08 3.993211525331e-01 7.350000000000e-08 5.414213562373e-01 7.375000000000e-08 -3.027339492126e-01 7.400000000000e-08 -1.200000000000e+00 7.425000000000e-08 -9.054678984251e-01 7.450000000000e-08 5.857864376268e-02 7.475000000000e-08 3.496605762665e-01 7.500000000000e-08 6.480926906249e-15 7.525000000000e-08 -3.363572758385e-02 7.550000000000e-08 2.585786437627e-01 7.575000000000e-08 2.198912367379e-01 7.600000000000e-08 -4.829470157119e-15 7.625000000000e-08 1.397824734759e-01 7.650000000000e-08 3.414213562373e-01 7.675000000000e-08 1.331821362081e-01 7.700000000000e-08 -1.398881011028e-14 7.725000000000e-08 3.993211525331e-01 7.750000000000e-08 5.414213562373e-01 7.775000000000e-08 -3.027339492126e-01 7.800000000000e-08 -1.200000000000e+00 7.825000000000e-08 -9.054678984252e-01 7.850000000000e-08 5.857864376271e-02 7.875000000000e-08 3.496605762665e-01 7.900000000000e-08 9.561795799584e-15 7.925000000000e-08 -3.363572758385e-02 7.950000000000e-08 2.585786437627e-01 7.975000000000e-08 2.198912367380e-01 8.000000000000e-08 -1.887379141863e-15 ]
VWL003 (wl003 0) vsource type=pwl wave=[ 0.000000000000e+00 0.000000000000e+00 2.500000000000e-10 1.801087632620e-01 5.000000000000e-10 -2.426406871193e-02 7.500000000000e-10 -2.336357275839e-01 1.000000000000e-09 9.714451465470e-17 1.250000000000e-09 5.033942373345e-02 1.500000000000e-09 -6.242640687119e-01 1.750000000000e-09 -1.105467898425e+00 2.000000000000e-09 -4.000000000000e-01 2.250000000000e-09 7.027339492126e-01 2.500000000000e-09 8.242640687119e-01 2.750000000000e-09 1.993211525331e-01 3.000000000000e-09 5.412337245048e-16 3.250000000000e-09 2.668178637919e-01 3.500000000000e-09 2.242640687119e-01 3.750000000000e-09 -6.021752652407e-02 4.000000000000e-09 1.193489751472e-15 4.250000000000e-09 1.801087632620e-01 4.500000000000e-09 -2.426406871193e-02 4.750000000000e-09 -2.336357275839e-01 5.000000000000e-09 -4.024558464266e-16 5.250000000000e-09 5.033942373345e-02 5.500000000000e-09 -6.242640687119e-01 5.750000000000e-09 -1.105467898425e+00 6.000000000000e-09 -4.000000000000e-01 6.250000000000e-09 7.027339492126e-01 6.500000000000e-09 8.242640687119e-01 6.750000000000e-09 1.993211525331e-01 7.000000000000e-09 8.743006318923e-16 7.250000000000e-09 2.668178637919e-01 7.500000000000e-09 2.242640687119e-01 7.750000000000e-09 -6.021752652407e-02 8.000000000000e-09 2.373101715136e-15 8.250000000000e-09 1.801087632620e-01 8.500000000000e-09 -2.426406871193e-02 8.750000000000e-09 -2.336357275839e-01 9.000000000000e-09 1.013078509970e-15 9.250000000000e-09 5.033942373345e-02 9.500000000000e-09 -6.242640687119e-01 9.750000000000e-09 -1.105467898425e+00 1.000000000000e-08 -4.000000000000e-01 1.025000000000e-08 7.027339492126e-01 1.050000000000e-08 8.242640687119e-01 1.075000000000e-08 1.993211525331e-01 1.100000000000e-08 7.632783294298e-16 1.125000000000e-08 2.668178637919e-01 1.150000000000e-08 2.242640687119e-01 1.175000000000e-08 -6.021752652407e-02 1.200000000000e-08 4.898859096159e-15 1.225000000000e-08 1.801087632620e-01 1.250000000000e-08 -2.426406871193e-02 1.275000000000e-08 -2.336357275839e-01 1.300000000000e-08 4.163336342344e-17 1.325000000000e-08 5.033942373345e-02 1.350000000000e-08 -6.242640687119e-01 1.375000000000e-08 -1.105467898425e+00 1.400000000000e-08 -4.000000000000e-01 1.425000000000e-08 7.027339492126e-01 1.450000000000e-08 8.242640687119e-01 1.475000000000e-08 1.993211525331e-01 1.500000000000e-08 3.191891195797e-15 1.525000000000e-08 2.668178637919e-01 1.550000000000e-08 2.242640687119e-01 1.575000000000e-08 -6.021752652407e-02 1.600000000000e-08 4.732325642465e-15 1.625000000000e-08 1.801087632620e-01 1.650000000000e-08 -2.426406871193e-02 1.675000000000e-08 -2.336357275839e-01 1.700000000000e-08 -1.110223024625e-16 1.725000000000e-08 5.033942373345e-02 1.750000000000e-08 -6.242640687119e-01 1.775000000000e-08 -1.105467898425e+00 1.800000000000e-08 -4.000000000000e-01 1.825000000000e-08 7.027339492126e-01 1.850000000000e-08 8.242640687119e-01 1.875000000000e-08 1.993211525331e-01 1.900000000000e-08 1.304512053935e-15 1.925000000000e-08 2.668178637919e-01 1.950000000000e-08 2.242640687119e-01 1.975000000000e-08 -6.021752652407e-02 2.000000000000e-08 1.387778780781e-15 2.025000000000e-08 1.801087632620e-01 2.050000000000e-08 -2.426406871193e-02 2.075000000000e-08 -2.336357275839e-01 2.100000000000e-08 4.024558464266e-16 2.125000000000e-08 5.033942373345e-02 2.150000000000e-08 -6.242640687119e-01 2.175000000000e-08 -1.105467898425e+00 2.200000000000e-08 -4.000000000000e-01 2.225000000000e-08 7.027339492126e-01 2.250000000000e-08 8.242640687119e-01 2.275000000000e-08 1.993211525331e-01 2.300000000000e-08 2.955968803064e-15 2.325000000000e-08 2.668178637919e-01 2.350000000000e-08 2.242640687119e-01 2.375000000000e-08 -6.021752652407e-02 2.400000000000e-08 9.769962616701e-15 2.425000000000e-08 1.801087632620e-01 2.450000000000e-08 -2.426406871193e-02 2.475000000000e-08 -2.336357275839e-01 2.500000000000e-08 -4.718447854657e-16 2.525000000000e-08 5.033942373345e-02 2.550000000000e-08 -6.242640687119e-01 2.575000000000e-08 -1.105467898425e+00 2.600000000000e-08 -4.000000000000e-01 2.625000000000e-08 7.027339492126e-01 2.650000000000e-08 8.242640687119e-01 2.675000000000e-08 1.993211525331e-01 2.700000000000e-08 -1.346145417358e-15 2.725000000000e-08 2.668178637919e-01 2.750000000000e-08 2.242640687119e-01 2.775000000000e-08 -6.021752652407e-02 2.800000000000e-08 7.494005416220e-15 2.825000000000e-08 1.801087632620e-01 2.850000000000e-08 -2.426406871193e-02 2.875000000000e-08 -2.336357275839e-01 2.900000000000e-08 -1.443289932013e-15 2.925000000000e-08 5.033942373345e-02 2.950000000000e-08 -6.242640687119e-01 2.975000000000e-08 -1.105467898425e+00 3.000000000000e-08 -4.000000000000e-01 3.025000000000e-08 7.027339492126e-01 3.050000000000e-08 8.242640687119e-01 3.075000000000e-08 1.993211525331e-01 3.100000000000e-08 -7.632783294298e-16 3.125000000000e-08 2.668178637919e-01 3.150000000000e-08 2.242640687119e-01 3.175000000000e-08 -6.021752652407e-02 3.200000000000e-08 9.478529072737e-15 3.225000000000e-08 1.801087632620e-01 3.250000000000e-08 -2.426406871193e-02 3.275000000000e-08 -2.336357275839e-01 3.300000000000e-08 4.052314039882e-15 3.325000000000e-08 5.033942373345e-02 3.350000000000e-08 -6.242640687119e-01 3.375000000000e-08 -1.105467898425e+00 3.400000000000e-08 -4.000000000000e-01 3.425000000000e-08 7.027339492126e-01 3.450000000000e-08 8.242640687119e-01 3.475000000000e-08 1.993211525331e-01 3.500000000000e-08 2.012279232133e-15 3.525000000000e-08 2.668178637919e-01 3.550000000000e-08 2.242640687119e-01 3.575000000000e-08 -6.021752652407e-02 3.600000000000e-08 2.942091015257e-15 3.625000000000e-08 1.801087632620e-01 3.650000000000e-08 -2.426406871193e-02 3.675000000000e-08 -2.336357275839e-01 3.700000000000e-08 -3.233524559221e-15 3.725000000000e-08 5.033942373346e-02 3.750000000000e-08 -6.242640687119e-01 3.775000000000e-08 -1.105467898425e+00 3.800000000000e-08 -4.000000000000e-01 3.825000000000e-08 7.027339492126e-01 3.850000000000e-08 8.242640687119e-01 3.875000000000e-08 1.993211525331e-01 3.900000000000e-08 7.591149930875e-15 3.925000000000e-08 2.668178637919e-01 3.950000000000e-08 2.242640687119e-01 3.975000000000e-08 -6.021752652407e-02 4.000000000000e-08 2.789435349371e-15 4.025000000000e-08 1.801087632620e-01 4.050000000000e-08 -2.426406871194e-02 4.075000000000e-08 -2.336357275839e-01 4.100000000000e-08 2.275957200482e-15 4.125000000000e-08 5.033942373345e-02 4.150000000000e-08 -6.242640687119e-01 4.175000000000e-08 -1.105467898425e+00 4.200000000000e-08 -4.000000000000e-01 4.225000000000e-08 7.027339492126e-01 4.250000000000e-08 8.242640687119e-01 4.275000000000e-08 1.993211525331e-01 4.300000000000e-08 -1.748601263785e-15 4.325000000000e-08 2.668178637919e-01 4.350000000000e-08 2.242640687119e-01 4.375000000000e-08 -6.021752652407e-02 4.400000000000e-08 6.911138328292e-15 4.425000000000e-08 1.801087632620e-01 4.450000000000e-08 -2.426406871193e-02 4.475000000000e-08 -2.336357275839e-01 4.500000000000e-08 7.716050021145e-15 4.525000000000e-08 5.033942373345e-02 4.550000000000e-08 -6.242640687119e-01 4.575000000000e-08 -1.105467898425e+00 4.600000000000e-08 -4.000000000000e-01 4.625000000000e-08 7.027339492126e-01 4.650000000000e-08 8.242640687119e-01 4.675000000000e-08 1.993211525331e-01 4.700000000000e-08 9.714451465470e-16 4.725000000000e-08 2.668178637919e-01 4.750000000000e-08 2.242640687119e-01 4.775000000000e-08 -6.021752652407e-02 4.800000000000e-08 1.955380302121e-14 4.825000000000e-08 1.801087632620e-01 4.850000000000e-08 -2.426406871194e-02 4.875000000000e-08 -2.336357275839e-01 4.900000000000e-08 4.302114220422e-16 4.925000000000e-08 5.033942373345e-02 4.950000000000e-08 -6.242640687119e-01 4.975000000000e-08 -1.105467898425e+00 5.000000000000e-08 -4.000000000000e-01 5.025000000000e-08 7.027339492126e-01 5.050000000000e-08 8.242640687119e-01 5.075000000000e-08 1.993211525331e-01 5.100000000000e-08 -5.551115123126e-16 5.125000000000e-08 2.668178637919e-01 5.150000000000e-08 2.242640687119e-01 5.175000000000e-08 -6.021752652407e-02 5.200000000000e-08 1.088018564133e-14 5.225000000000e-08 1.801087632620e-01 5.250000000000e-08 -2.426406871193e-02 5.275000000000e-08 -2.336357275839e-01 5.300000000000e-08 5.925815393937e-15 5.325000000000e-08 5.033942373345e-02 5.350000000000e-08 -6.242640687119e-01 5.375000000000e-08 -1.105467898425e+00 5.400000000000e-08 -4.000000000000e-01 5.425000000000e-08 7.027339492126e-01 5.450000000000e-08 8.242640687119e-01 5.475000000000e-08 1.993211525331e-01 5.500000000000e-08 5.065392549852e-15 5.525000000000e-08 2.668178637919e-01 5.550000000000e-08 2.242640687119e-01 5.575000000000e-08 -6.021752652407e-02 5.600000000000e-08 1.498801083244e-14 5.625000000000e-08 1.801087632620e-01 5.650000000000e-08 -2.426406871194e-02 5.675000000000e-08 -2.336357275839e-01 5.700000000000e-08 1.457167719821e-15 5.725000000000e-08 5.033942373345e-02 5.750000000000e-08 -6.242640687119e-01 5.775000000000e-08 -1.105467898425e+00 5.800000000000e-08 -4.000000000000e-01 5.825000000000e-08 7.027339492126e-01 5.850000000000e-08 8.242640687119e-01 5.875000000000e-08 1.993211525331e-01 5.900000000000e-08 4.968248035198e-15 5.925000000000e-08 2.668178637919e-01 5.950000000000e-08 2.242640687119e-01 5.975000000000e-08 -6.021752652407e-02 6.000000000000e-08 2.765843110097e-14 6.025000000000e-08 1.801087632620e-01 6.050000000000e-08 -2.426406871195e-02 6.075000000000e-08 -2.336357275839e-01 6.100000000000e-08 -2.942091015257e-15 6.125000000000e-08 5.033942373345e-02 6.150000000000e-08 -6.242640687119e-01 6.175000000000e-08 -1.105467898425e+00 6.200000000000e-08 -4.000000000000e-01 6.225000000000e-08 7.027339492126e-01 6.250000000000e-08 8.242640687119e-01 6.275000000000e-08 1.993211525331e-01 6.300000000000e-08 1.051936315832e-14 6.325000000000e-08 2.668178637919e-01 6.350000000000e-08 2.242640687119e-01 6.375000000000e-08 -6.021752652407e-02 6.400000000000e-08 1.897093593328e-14 6.425000000000e-08 1.801087632620e-01 6.450000000000e-08 -2.426406871195e-02 6.475000000000e-08 -2.336357275839e-01 6.500000000000e-08 -3.330669073875e-16 6.525000000000e-08 5.033942373345e-02 6.550000000000e-08 -6.242640687119e-01 6.575000000000e-08 -1.105467898425e+00 6.600000000000e-08 -4.000000000000e-01 6.625000000000e-08 7.027339492126e-01 6.650000000000e-08 8.242640687119e-01 6.675000000000e-08 1.993211525331e-01 6.700000000000e-08 6.161737786670e-15 6.725000000000e-08 2.668178637919e-01 6.750000000000e-08 2.242640687119e-01 6.775000000000e-08 -6.021752652407e-02 6.800000000000e-08 1.028344076559e-14 6.825000000000e-08 1.801087632620e-01 6.850000000000e-08 -2.426406871194e-02 6.875000000000e-08 -2.336357275839e-01 6.900000000000e-08 7.993605777301e-15 6.925000000000e-08 5.033942373346e-02 6.950000000000e-08 -6.242640687119e-01 6.975000000000e-08 -1.105467898425e+00 7.000000000000e-08 -4.000000000000e-01 7.025000000000e-08 7.027339492126e-01 7.050000000000e-08 8.242640687119e-01 7.075000000000e-08 1.993211525331e-01 7.100000000000e-08 1.817990202824e-15 7.125000000000e-08 2.668178637919e-01 7.150000000000e-08 2.242640687119e-01 7.175000000000e-08 -6.021752652407e-02 7.200000000000e-08 5.884182030513e-15 7.225000000000e-08 1.801087632620e-01 7.250000000000e-08 -2.426406871194e-02 7.275000000000e-08 -2.336357275839e-01 7.300000000000e-08 3.524958103185e-15 7.325000000000e-08 5.033942373344e-02 7.350000000000e-08 -6.242640687119e-01 7.375000000000e-08 -1.105467898425e+00 7.400000000000e-08 -4.000000000000e-01 7.425000000000e-08 7.027339492126e-01 7.450000000000e-08 8.242640687119e-01 7.475000000000e-08 1.993211525331e-01 7.500000000000e-08 7.369105325949e-15 7.525000000000e-08 2.668178637919e-01 7.550000000000e-08 2.242640687119e-01 7.575000000000e-08 -6.021752652407e-02 7.600000000000e-08 1.426636586643e-14 7.625000000000e-08 1.801087632620e-01 7.650000000000e-08 -2.426406871193e-02 7.675000000000e-08 -2.336357275839e-01 7.700000000000e-08 -6.647460359943e-15 7.725000000000e-08 5.033942373345e-02 7.750000000000e-08 -6.242640687119e-01 7.775000000000e-08 -1.105467898425e+00 7.800000000000e-08 -4.000000000000e-01 7.825000000000e-08 7.027339492126e-01 7.850000000000e-08 8.242640687119e-01 7.875000000000e-08 1.993211525331e-01 7.900000000000e-08 1.297573160031e-14 7.925000000000e-08 2.668178637919e-01 7.950000000000e-08 2.242640687119e-01 7.975000000000e-08 -6.021752652407e-02 8.000000000000e-08 5.578870698741e-15 ]
VWL004 (wl004 0) vsource type=pwl wave=[ 0.000000000000e+00 0.000000000000e+00 2.500000000000e-10 -1.397824734759e-01 5.000000000000e-10 -3.414213562373e-01 7.500000000000e-10 -1.331821362081e-01 1.000000000000e-09 9.714451465470e-17 1.250000000000e-09 -3.993211525331e-01 1.500000000000e-09 -5.414213562373e-01 1.750000000000e-09 3.027339492126e-01 2.000000000000e-09 1.200000000000e+00 2.250000000000e-09 9.054678984252e-01 2.500000000000e-09 -5.857864376269e-02 2.750000000000e-09 -3.496605762665e-01 3.000000000000e-09 -2.636779683485e-16 3.250000000000e-09 3.363572758386e-02 3.500000000000e-09 -2.585786437627e-01 3.750000000000e-09 -2.198912367380e-01 4.000000000000e-09 3.885780586188e-16 4.250000000000e-09 -1.397824734759e-01 4.500000000000e-09 -3.414213562373e-01 4.750000000000e-09 -1.331821362081e-01 5.000000000000e-09 6.522560269673e-16 5.250000000000e-09 -3.993211525331e-01 5.500000000000e-09 -5.414213562373e-01 5.750000000000e-09 3.027339492126e-01 6.000000000000e-09 1.200000000000e+00 6.250000000000e-09 9.054678984252e-01 6.500000000000e-09 -5.857864376269e-02 6.750000000000e-09 -3.496605762665e-01 7.000000000000e-09 2.775557561563e-17 7.250000000000e-09 3.363572758386e-02 7.500000000000e-09 -2.585786437627e-01 7.750000000000e-09 -2.198912367380e-01 8.000000000000e-09 8.326672684689e-16 8.250000000000e-09 -1.397824734759e-01 8.500000000000e-09 -3.414213562373e-01 8.750000000000e-09 -1.331821362081e-01 9.000000000000e-09 -4.579669976579e-16 9.250000000000e-09 -3.993211525331e-01 9.500000000000e-09 -5.414213562373e-01 9.750000000000e-09 3.027339492126e-01 1.000000000000e-08 1.200000000000e+00 1.025000000000e-08 9.054678984252e-01 1.050000000000e-08 -5.857864376269e-02 1.075000000000e-08 -3.496605762665e-01 1.100000000000e-08 -1.804112415016e-16 1.125000000000e-08 3.363572758386e-02 1.150000000000e-08 -2.585786437627e-01 1.175000000000e-08 -2.198912367380e-01 1.200000000000e-08 1.609823385706e-15 1.225000000000e-08 -1.397824734759e-01 1.250000000000e-08 -3.414213562373e-01 1.275000000000e-08 -1.331821362081e-01 1.300000000000e-08 1.706967900361e-15 1.325000000000e-08 -3.993211525331e-01 1.350000000000e-08 -5.414213562373e-01 1.375000000000e-08 3.027339492126e-01 1.400000000000e-08 1.200000000000e+00 1.425000000000e-08 9.054678984252e-01 1.450000000000e-08 -5.857864376269e-02 1.475000000000e-08 -3.496605762665e-01 1.500000000000e-08 -7.216449660064e-16 1.525000000000e-08 3.363572758386e-02 1.550000000000e-08 -2.585786437627e-01 1.575000000000e-08 -2.198912367380e-01 1.600000000000e-08 1.554312234475e-15 1.625000000000e-08 -1.397824734759e-01 1.650000000000e-08 -3.414213562373e-01 1.675000000000e-08 -1.331821362081e-01 1.700000000000e-08 1.804112415016e-15 1.725000000000e-08 -3.993211525331e-01 1.750000000000e-08 -5.414213562373e-01 1.775000000000e-08 3.027339492126e-01 1.800000000000e-08 1.200000000000e+00 1.825000000000e-08 9.054678984252e-01 1.850000000000e-08 -5.857864376269e-02 1.875000000000e-08 -3.496605762665e-01 1.900000000000e-08 -2.720046410332e-15 1.925000000000e-08 3.363572758386e-02 1.950000000000e-08 -2.585786437627e-01 1.975000000000e-08 -2.198912367380e-01 2.000000000000e-08 4.440892098501e-16 2.025000000000e-08 -1.397824734759e-01 2.050000000000e-08 -3.414213562373e-01 2.075000000000e-08 -1.331821362081e-01 2.100000000000e-08 -1.804112415016e-16 2.125000000000e-08 -3.993211525331e-01 2.150000000000e-08 -5.414213562373e-01 2.175000000000e-08 3.027339492126e-01 2.200000000000e-08 1.200000000000e+00 2.225000000000e-08 9.054678984252e-01 2.250000000000e-08 -5.857864376270e-02 2.275000000000e-08 -3.496605762665e-01 2.300000000000e-08 -1.137978600241e-15 2.325000000000e-08 3.363572758386e-02 2.350000000000e-08 -2.585786437627e-01 2.375000000000e-08 -2.198912367380e-01 2.400000000000e-08 3.275157922644e-15 2.425000000000e-08 -1.397824734759e-01 2.450000000000e-08 -3.414213562373e-01 2.475000000000e-08 -1.331821362081e-01 2.500000000000e-08 2.040034807749e-15 2.525000000000e-08 -3.993211525331e-01 2.550000000000e-08 -5.414213562373e-01 2.575000000000e-08 3.027339492126e-01 2.600000000000e-08 1.200000000000e+00 2.625000000000e-08 9.054678984252e-01 2.650000000000e-08 -5.857864376270e-02 2.675000000000e-08 -3.496605762665e-01 2.700000000000e-08 -2.775557561563e-15 2.725000000000e-08 3.363572758386e-02 2.750000000000e-08 -2.585786437627e-01 2.775000000000e-08 -2.198912367380e-01 2.800000000000e-08 2.442490654175e-15 2.825000000000e-08 -1.397824734759e-01 2.850000000000e-08 -3.414213562373e-01 2.875000000000e-08 -1.331821362081e-01 2.900000000000e-08 4.260480856999e-15 2.925000000000e-08 -3.993211525331e-01 2.950000000000e-08 -5.414213562373e-01 2.975000000000e-08 3.027339492126e-01 3.000000000000e-08 1.200000000000e+00 3.025000000000e-08 9.054678984252e-01 3.050000000000e-08 -5.857864376269e-02 3.075000000000e-08 -3.496605762665e-01 3.100000000000e-08 -5.065392549852e-15 3.125000000000e-08 3.363572758385e-02 3.150000000000e-08 -2.585786437627e-01 3.175000000000e-08 -2.198912367380e-01 3.200000000000e-08 3.219646771413e-15 3.225000000000e-08 -1.397824734759e-01 3.250000000000e-08 -3.414213562373e-01 3.275000000000e-08 -1.331821362081e-01 3.300000000000e-08 1.471045507628e-15 3.325000000000e-08 -3.993211525331e-01 3.350000000000e-08 -5.414213562373e-01 3.375000000000e-08 3.027339492126e-01 3.400000000000e-08 1.200000000000e+00 3.425000000000e-08 9.054678984252e-01 3.450000000000e-08 -5.857864376270e-02 3.475000000000e-08 -3.496605762665e-01 3.500000000000e-08 4.440892098501e-16 3.525000000000e-08 3.363572758385e-02 3.550000000000e-08 -2.585786437627e-01 3.575000000000e-08 -2.198912367380e-01 3.600000000000e-08 9.992007221626e-16 3.625000000000e-08 -1.397824734759e-01 3.650000000000e-08 -3.414213562373e-01 3.675000000000e-08 -1.331821362081e-01 3.700000000000e-08 8.701372955500e-15 3.725000000000e-08 -3.993211525331e-01 3.750000000000e-08 -5.414213562373e-01 3.775000000000e-08 3.027339492126e-01 3.800000000000e-08 1.200000000000e+00 3.825000000000e-08 9.054678984252e-01 3.850000000000e-08 -5.857864376268e-02 3.875000000000e-08 -3.496605762666e-01 3.900000000000e-08 -2.622901895677e-15 3.925000000000e-08 3.363572758385e-02 3.950000000000e-08 -2.585786437627e-01 3.975000000000e-08 -2.198912367380e-01 4.000000000000e-08 8.881784197001e-16 4.025000000000e-08 -1.397824734759e-01 4.050000000000e-08 -3.414213562373e-01 4.075000000000e-08 -1.331821362081e-01 4.100000000000e-08 5.981326545168e-15 4.125000000000e-08 -3.993211525331e-01 4.150000000000e-08 -5.414213562373e-01 4.175000000000e-08 3.027339492126e-01 4.200000000000e-08 1.200000000000e+00 4.225000000000e-08 9.054678984252e-01 4.250000000000e-08 -5.857864376269e-02 4.275000000000e-08 -3.496605762666e-01 4.300000000000e-08 -3.538835890993e-15 4.325000000000e-08 3.363572758386e-02 4.350000000000e-08 -2.585786437627e-01 4.375000000000e-08 -2.198912367380e-01 4.400000000000e-08 2.331468351713e-15 4.425000000000e-08 -1.397824734759e-01 4.450000000000e-08 -3.414213562373e-01 4.475000000000e-08 -1.331821362081e-01 4.500000000000e-08 3.191891195797e-15 4.525000000000e-08 -3.993211525331e-01 4.550000000000e-08 -5.414213562373e-01 4.575000000000e-08 3.027339492126e-01 4.600000000000e-08 1.200000000000e+00 4.625000000000e-08 9.054678984252e-01 4.650000000000e-08 -5.857864376270e-02 4.675000000000e-08 -3.496605762665e-01 4.700000000000e-08 1.970645868710e-15 4.725000000000e-08 3.363572758386e-02 4.750000000000e-08 -2.585786437627e-01 4.775000000000e-08 -2.198912367380e-01 4.800000000000e-08 6.550315845288e-15 4.825000000000e-08 -1.397824734759e-01 4.850000000000e-08 -3.414213562373e-01 4.875000000000e-08 -1.331821362081e-01 4.900000000000e-08 1.042221864367e-14 4.925000000000e-08 -3.993211525331e-01 4.950000000000e-08 -5.414213562373e-01 4.975000000000e-08 3.027339492126e-01 5.000000000000e-08 1.200000000000e+00 5.025000000000e-08 9.054678984252e-01 5.050000000000e-08 -5.857864376268e-02 5.075000000000e-08 -3.496605762666e-01 5.100000000000e-08 -8.146261443187e-15 5.125000000000e-08 3.363572758385e-02 5.150000000000e-08 -2.585786437627e-01 5.175000000000e-08 -2.198912367380e-01 5.200000000000e-08 3.608224830032e-15 5.225000000000e-08 -1.397824734759e-01 5.250000000000e-08 -3.414213562373e-01 5.275000000000e-08 -1.331821362081e-01 5.300000000000e-08 7.688294445529e-15 5.325000000000e-08 -3.993211525331e-01 5.350000000000e-08 -5.414213562373e-01 5.375000000000e-08 3.027339492126e-01 5.400000000000e-08 1.200000000000e+00 5.425000000000e-08 9.054678984252e-01 5.450000000000e-08 -5.857864376270e-02 5.475000000000e-08 -3.496605762665e-01 5.500000000000e-08 -1.121325254871e-14 5.525000000000e-08 3.363572758385e-02 5.550000000000e-08 -2.585786437627e-01 5.575000000000e-08 -2.198912367379e-01 5.600000000000e-08 5.051514762044e-15 5.625000000000e-08 -1.397824734759e-01 5.650000000000e-08 -3.414213562373e-01 5.675000000000e-08 -1.331821362081e-01 5.700000000000e-08 6.411537967210e-15 5.725000000000e-08 -3.993211525331e-01 5.750000000000e-08 -5.414213562373e-01 5.775000000000e-08 3.027339492126e-01 5.800000000000e-08 1.200000000000e+00 5.825000000000e-08 9.054678984252e-01 5.850000000000e-08 -5.857864376269e-02 5.875000000000e-08 -3.496605762665e-01 5.900000000000e-08 2.803313137179e-15 5.925000000000e-08 3.363572758384e-02 5.950000000000e-08 -2.585786437627e-01 5.975000000000e-08 -2.198912367380e-01 6.000000000000e-08 9.214851104389e-15 6.025000000000e-08 -1.397824734759e-01 6.050000000000e-08 -3.414213562373e-01 6.075000000000e-08 -1.331821362081e-01 6.100000000000e-08 5.051514762044e-15 6.125000000000e-08 -3.993211525331e-01 6.150000000000e-08 -5.414213562373e-01 6.175000000000e-08 3.027339492126e-01 6.200000000000e-08 1.200000000000e+00 6.225000000000e-08 9.054678984252e-01 6.250000000000e-08 -5.857864376272e-02 6.275000000000e-08 -3.496605762665e-01 6.300000000000e-08 -2.775557561563e-16 6.325000000000e-08 3.363572758385e-02 6.350000000000e-08 -2.585786437627e-01 6.375000000000e-08 -2.198912367380e-01 6.400000000000e-08 6.272760089132e-15 6.425000000000e-08 -1.397824734759e-01 6.450000000000e-08 -3.414213562373e-01 6.475000000000e-08 -1.331821362081e-01 6.500000000000e-08 1.079691891448e-14 6.525000000000e-08 -3.993211525331e-01 6.550000000000e-08 -5.414213562373e-01 6.575000000000e-08 3.027339492126e-01 6.600000000000e-08 1.200000000000e+00 6.625000000000e-08 9.054678984252e-01 6.650000000000e-08 -5.857864376270e-02 6.675000000000e-08 -3.496605762666e-01 6.700000000000e-08 -1.859623566247e-15 6.725000000000e-08 3.363572758384e-02 6.750000000000e-08 -2.585786437627e-01 6.775000000000e-08 -2.198912367380e-01 6.800000000000e-08 3.441691376338e-15 6.825000000000e-08 -1.397824734759e-01 6.850000000000e-08 -3.414213562373e-01 6.875000000000e-08 -1.331821362081e-01 6.900000000000e-08 -4.163336342344e-16 6.925000000000e-08 -3.993211525331e-01 6.950000000000e-08 -5.414213562373e-01 6.975000000000e-08 3.027339492126e-01 7.000000000000e-08 1.200000000000e+00 7.025000000000e-08 9.054678984251e-01 7.050000000000e-08 -5.857864376269e-02 7.075000000000e-08 -3.496605762665e-01 7.100000000000e-08 -3.511080315377e-15 7.125000000000e-08 3.363572758384e-02 7.150000000000e-08 -2.585786437627e-01 7.175000000000e-08 -2.198912367379e-01 7.200000000000e-08 1.942890293094e-15 7.225000000000e-08 -1.397824734759e-01 7.250000000000e-08 -3.414213562373e-01 7.275000000000e-08 -1.331821362081e-01 7.300000000000e-08 -1.762479051592e-15 7.325000000000e-08 -3.993211525331e-01 7.350000000000e-08 -5.414213562373e-01 7.375000000000e-08 3.027339492126e-01 7.400000000000e-08 1.200000000000e+00 7.425000000000e-08 9.054678984251e-01 7.450000000000e-08 -5.857864376268e-02 7.475000000000e-08 -3.496605762665e-01 7.500000000000e-08 -6.480926906249e-15 7.525000000000e-08 3.363572758385e-02 7.550000000000e-08 -2.585786437627e-01 7.575000000000e-08 -2.198912367379e-01 7.600000000000e-08 4.829470157119e-15 7.625000000000e-08 -1.397824734759e-01 7.650000000000e-08 -3.414213562373e-01 7.675000000000e-08 -1.331821362081e-01 7.700000000000e-08 1.398881011028e-14 7.725000000000e-08 -3.993211525331e-01 7.750000000000e-08 -5.414213562373e-01 7.775000000000e-08 3.027339492126e-01 7.800000000000e-08 1.200000000000e+00 7.825000000000e-08 9.054678984252e-01 7.850000000000e-08 -5.857864376271e-02 7.875000000000e-08 -3.496605762665e-01 7.900000000000e-08 -9.561795799584e-15 7.925000000000e-08 3.363572758385e-02 7.950000000000e-08 -2.585786437627e-01 7.975000000000e-08 -2.198912367380e-01 8.000000000000e-08 1.887379141863e-15 ]
VWL005 (wl005 0) vsource type=pwl wave=[ 0.000000000000e+00 0.000000000000e+00 2.500000000000e-10 -1.801087632620e-01 5.000000000000e-10 2.426406871193e-02 7.500000000000e-10 2.336357275839e-01 1.000000000000e-09 -9.714451465470e-17 1.250000000000e-09 -5.033942373345e-02 1.500000000000e-09 6.242640687119e-01 1.750000000000e-09 1.105467898425e+00 2.000000000000e-09 4.000000000000e-01 2.250000000000e-09 -7.027339492126e-01 2.500000000000e-09 -8.242640687119e-01 2.750000000000e-09 -1.993211525331e-01 3.000000000000e-09 -5.412337245048e-16 3.250000000000e-09 -2.668178637919e-01 3.500000000000e-09 -2.242640687119e-01 3.750000000000e-09 6.021752652407e-02 4.000000000000e-09 -1.193489751472e-15 4.250000000000e-09 -1.801087632620e-01 4.500000000000e-09 2.426406871193e-02 4.750000000000e-09 2.336357275839e-01 5.000000000000e-09 4.024558464266e-16 5.250000000000e-09 -5.033942373345e-02 5.500000000000e-09 6.242640687119e-01 5.750000000000e-09 1.105467898425e+00 6.000000000000e-09 4.000000000000e-01 6.250000000000e-09 -7.027339492126e-01 6.500000000000e-09 -8.242640687119e-01 6.750000000000e-09 -1.993211525331e-01 7.000000000000e-09 -8.743006318923e-16 7.250000000000e-09 -2.668178637919e-01 7.500000000000e-09 -2.242640687119e-01 7.750000000000e-09 6.021752652407e-02 8.000000000000e-09 -2.373101715136e-15 8.250000000000e-09 -1.801087632620e-01 8.500000000000e-09 2.426406871193e-02 8.750000000000e-09 2.336357275839e-01 9.000000000000e-09 -1.013078509970e-15 9.250000000000e-09 -5.033942373345e-02 9.500000000000e-09 6.242640687119e-01 9.750000000000e-09 1.105467898425e+00 1.000000000000e-08 4.000000000000e-01 1.025000000000e-08 -7.027339492126e-01 1.050000000000e-08 -8.242640687119e-01 1.075000000000e-08 -1.993211525331e-01 1.100000000000e-08 -7.632783294298e-16 1.125000000000e-08 -2.668178637919e-01 1.150000000000e-08 -2.242640687119e-01 1.175000000000e-08 6.021752652407e-02 1.200000000000e-08 -4.898859096159e-15 1.225000000000e-08 -1.801087632620e-01 1.250000000000e-08 2.426406871193e-02 1.275000000000e-08 2.336357275839e-01 1.300000000000e-08 -4.163336342344e-17 1.325000000000e-08 -5.033942373345e-02 1.350000000000e-08 6.242640687119e-01 1.375000000000e-08 1.105467898425e+00 1.400000000000e-08 4.000000000000e-01 1.425000000000e-08 -7.027339492126e-01 1.450000000000e-08 -8.242640687119e-01 1.475000000000e-08 -1.993211525331e-01 1.500000000000e-08 -3.191891195797e-15 1.525000000000e-08 -2.668178637919e-01 1.550000000000e-08 -2.242640687119e-01 1.575000000000e-08 6.021752652407e-02 1.600000000000e-08 -4.732325642465e-15 1.625000000000e-08 -1.801087632620e-01 1.650000000000e-08 2.426406871193e-02 1.675000000000e-08 2.336357275839e-01 1.700000000000e-08 1.110223024625e-16 1.725000000000e-08 -5.033942373345e-02 1.750000000000e-08 6.242640687119e-01 1.775000000000e-08 1.105467898425e+00 1.800000000000e-08 4.000000000000e-01 1.825000000000e-08 -7.027339492126e-01 1.850000000000e-08 -8.242640687119e-01 1.875000000000e-08 -1.993211525331e-01 1.900000000000e-08 -1.304512053935e-15 1.925000000000e-08 -2.668178637919e-01 1.950000000000e-08 -2.242640687119e-01 1.975000000000e-08 6.021752652407e-02 2.000000000000e-08 -1.387778780781e-15 2.025000000000e-08 -1.801087632620e-01 2.050000000000e-08 2.426406871193e-02 2.075000000000e-08 2.336357275839e-01 2.100000000000e-08 -4.024558464266e-16 2.125000000000e-08 -5.033942373345e-02 2.150000000000e-08 6.242640687119e-01 2.175000000000e-08 1.105467898425e+00 2.200000000000e-08 4.000000000000e-01 2.225000000000e-08 -7.027339492126e-01 2.250000000000e-08 -8.242640687119e-01 2.275000000000e-08 -1.993211525331e-01 2.300000000000e-08 -2.955968803064e-15 2.325000000000e-08 -2.668178637919e-01 2.350000000000e-08 -2.242640687119e-01 2.375000000000e-08 6.021752652407e-02 2.400000000000e-08 -9.769962616701e-15 2.425000000000e-08 -1.801087632620e-01 2.450000000000e-08 2.426406871193e-02 2.475000000000e-08 2.336357275839e-01 2.500000000000e-08 4.718447854657e-16 2.525000000000e-08 -5.033942373345e-02 2.550000000000e-08 6.242640687119e-01 2.575000000000e-08 1.105467898425e+00 2.600000000000e-08 4.000000000000e-01 2.625000000000e-08 -7.027339492126e-01 2.650000000000e-08 -8.242640687119e-01 2.675000000000e-08 -1.993211525331e-01 2.700000000000e-08 1.346145417358e-15 2.725000000000e-08 -2.668178637919e-01 2.750000000000e-08 -2.242640687119e-01 2.775000000000e-08 6.021752652407e-02 2.800000000000e-08 -7.494005416220e-15 2.825000000000e-08 -1.801087632620e-01 2.850000000000e-08 2.426406871193e-02 2.875000000000e-08 2.336357275839e-01 2.900000000000e-08 1.443289932013e-15 2.925000000000e-08 -5.033942373345e-02 2.950000000000e-08 6.242640687119e-01 2.975000000000e-08 1.105467898425e+00 3.000000000000e-08 4.000000000000e-01 3.025000000000e-08 -7.027339492126e-01 3.050000000000e-08 -8.242640687119e-01 3.075000000000e-08 -1.993211525331e-01 3.100000000000e-08 7.632783294298e-16 3.125000000000e-08 -2.668178637919e-01 3.150000000000e-08 -2.242640687119e-01 3.175000000000e-08 6.021752652407e-02 3.200000000000e-08 -9.478529072737e-15 3.225000000000e-08 -1.801087632620e-01 3.250000000000e-08 2.426406871193e-02 3.275000000000e-08 2.336357275839e-01 3.300000000000e-08 -4.052314039882e-15 3.325000000000e-08 -5.033942373345e-02 3.350000000000e-08 6.242640687119e-01 3.375000000000e-08 1.105467898425e+00 3.400000000000e-08 4.000000000000e-01 3.425000000000e-08 -7.027339492126e-01 3.450000000000e-08 -8.242640687119e-01 3.475000000000e-08 -1.993211525331e-01 3.500000000000e-08 -2.012279232133e-15 3.525000000000e-08 -2.668178637919e-01 3.550000000000e-08 -2.242640687119e-01 3.575000000000e-08 6.021752652407e-02 3.600000000000e-08 -2.942091015257e-15 3.625000000000e-08 -1.801087632620e-01 3.650000000000e-08 2.426406871193e-02 3.675000000000e-08 2.336357275839e-01 3.700000000000e-08 3.233524559221e-15 3.725000000000e-08 -5.033942373346e-02 3.750000000000e-08 6.242640687119e-01 3.775000000000e-08 1.105467898425e+00 3.800000000000e-08 4.000000000000e-01 3.825000000000e-08 -7.027339492126e-01 3.850000000000e-08 -8.242640687119e-01 3.875000000000e-08 -1.993211525331e-01 3.900000000000e-08 -7.591149930875e-15 3.925000000000e-08 -2.668178637919e-01 3.950000000000e-08 -2.242640687119e-01 3.975000000000e-08 6.021752652407e-02 4.000000000000e-08 -2.789435349371e-15 4.025000000000e-08 -1.801087632620e-01 4.050000000000e-08 2.426406871194e-02 4.075000000000e-08 2.336357275839e-01 4.100000000000e-08 -2.275957200482e-15 4.125000000000e-08 -5.033942373345e-02 4.150000000000e-08 6.242640687119e-01 4.175000000000e-08 1.105467898425e+00 4.200000000000e-08 4.000000000000e-01 4.225000000000e-08 -7.027339492126e-01 4.250000000000e-08 -8.242640687119e-01 4.275000000000e-08 -1.993211525331e-01 4.300000000000e-08 1.748601263785e-15 4.325000000000e-08 -2.668178637919e-01 4.350000000000e-08 -2.242640687119e-01 4.375000000000e-08 6.021752652407e-02 4.400000000000e-08 -6.911138328292e-15 4.425000000000e-08 -1.801087632620e-01 4.450000000000e-08 2.426406871193e-02 4.475000000000e-08 2.336357275839e-01 4.500000000000e-08 -7.716050021145e-15 4.525000000000e-08 -5.033942373345e-02 4.550000000000e-08 6.242640687119e-01 4.575000000000e-08 1.105467898425e+00 4.600000000000e-08 4.000000000000e-01 4.625000000000e-08 -7.027339492126e-01 4.650000000000e-08 -8.242640687119e-01 4.675000000000e-08 -1.993211525331e-01 4.700000000000e-08 -9.714451465470e-16 4.725000000000e-08 -2.668178637919e-01 4.750000000000e-08 -2.242640687119e-01 4.775000000000e-08 6.021752652407e-02 4.800000000000e-08 -1.955380302121e-14 4.825000000000e-08 -1.801087632620e-01 4.850000000000e-08 2.426406871194e-02 4.875000000000e-08 2.336357275839e-01 4.900000000000e-08 -4.302114220422e-16 4.925000000000e-08 -5.033942373345e-02 4.950000000000e-08 6.242640687119e-01 4.975000000000e-08 1.105467898425e+00 5.000000000000e-08 4.000000000000e-01 5.025000000000e-08 -7.027339492126e-01 5.050000000000e-08 -8.242640687119e-01 5.075000000000e-08 -1.993211525331e-01 5.100000000000e-08 5.551115123126e-16 5.125000000000e-08 -2.668178637919e-01 5.150000000000e-08 -2.242640687119e-01 5.175000000000e-08 6.021752652407e-02 5.200000000000e-08 -1.088018564133e-14 5.225000000000e-08 -1.801087632620e-01 5.250000000000e-08 2.426406871193e-02 5.275000000000e-08 2.336357275839e-01 5.300000000000e-08 -5.925815393937e-15 5.325000000000e-08 -5.033942373345e-02 5.350000000000e-08 6.242640687119e-01 5.375000000000e-08 1.105467898425e+00 5.400000000000e-08 4.000000000000e-01 5.425000000000e-08 -7.027339492126e-01 5.450000000000e-08 -8.242640687119e-01 5.475000000000e-08 -1.993211525331e-01 5.500000000000e-08 -5.065392549852e-15 5.525000000000e-08 -2.668178637919e-01 5.550000000000e-08 -2.242640687119e-01 5.575000000000e-08 6.021752652407e-02 5.600000000000e-08 -1.498801083244e-14 5.625000000000e-08 -1.801087632620e-01 5.650000000000e-08 2.426406871194e-02 5.675000000000e-08 2.336357275839e-01 5.700000000000e-08 -1.457167719821e-15 5.725000000000e-08 -5.033942373345e-02 5.750000000000e-08 6.242640687119e-01 5.775000000000e-08 1.105467898425e+00 5.800000000000e-08 4.000000000000e-01 5.825000000000e-08 -7.027339492126e-01 5.850000000000e-08 -8.242640687119e-01 5.875000000000e-08 -1.993211525331e-01 5.900000000000e-08 -4.968248035198e-15 5.925000000000e-08 -2.668178637919e-01 5.950000000000e-08 -2.242640687119e-01 5.975000000000e-08 6.021752652407e-02 6.000000000000e-08 -2.765843110097e-14 6.025000000000e-08 -1.801087632620e-01 6.050000000000e-08 2.426406871195e-02 6.075000000000e-08 2.336357275839e-01 6.100000000000e-08 2.942091015257e-15 6.125000000000e-08 -5.033942373345e-02 6.150000000000e-08 6.242640687119e-01 6.175000000000e-08 1.105467898425e+00 6.200000000000e-08 4.000000000000e-01 6.225000000000e-08 -7.027339492126e-01 6.250000000000e-08 -8.242640687119e-01 6.275000000000e-08 -1.993211525331e-01 6.300000000000e-08 -1.051936315832e-14 6.325000000000e-08 -2.668178637919e-01 6.350000000000e-08 -2.242640687119e-01 6.375000000000e-08 6.021752652407e-02 6.400000000000e-08 -1.897093593328e-14 6.425000000000e-08 -1.801087632620e-01 6.450000000000e-08 2.426406871195e-02 6.475000000000e-08 2.336357275839e-01 6.500000000000e-08 3.330669073875e-16 6.525000000000e-08 -5.033942373345e-02 6.550000000000e-08 6.242640687119e-01 6.575000000000e-08 1.105467898425e+00 6.600000000000e-08 4.000000000000e-01 6.625000000000e-08 -7.027339492126e-01 6.650000000000e-08 -8.242640687119e-01 6.675000000000e-08 -1.993211525331e-01 6.700000000000e-08 -6.161737786670e-15 6.725000000000e-08 -2.668178637919e-01 6.750000000000e-08 -2.242640687119e-01 6.775000000000e-08 6.021752652407e-02 6.800000000000e-08 -1.028344076559e-14 6.825000000000e-08 -1.801087632620e-01 6.850000000000e-08 2.426406871194e-02 6.875000000000e-08 2.336357275839e-01 6.900000000000e-08 -7.993605777301e-15 6.925000000000e-08 -5.033942373346e-02 6.950000000000e-08 6.242640687119e-01 6.975000000000e-08 1.105467898425e+00 7.000000000000e-08 4.000000000000e-01 7.025000000000e-08 -7.027339492126e-01 7.050000000000e-08 -8.242640687119e-01 7.075000000000e-08 -1.993211525331e-01 7.100000000000e-08 -1.817990202824e-15 7.125000000000e-08 -2.668178637919e-01 7.150000000000e-08 -2.242640687119e-01 7.175000000000e-08 6.021752652407e-02 7.200000000000e-08 -5.884182030513e-15 7.225000000000e-08 -1.801087632620e-01 7.250000000000e-08 2.426406871194e-02 7.275000000000e-08 2.336357275839e-01 7.300000000000e-08 -3.524958103185e-15 7.325000000000e-08 -5.033942373344e-02 7.350000000000e-08 6.242640687119e-01 7.375000000000e-08 1.105467898425e+00 7.400000000000e-08 4.000000000000e-01 7.425000000000e-08 -7.027339492126e-01 7.450000000000e-08 -8.242640687119e-01 7.475000000000e-08 -1.993211525331e-01 7.500000000000e-08 -7.369105325949e-15 7.525000000000e-08 -2.668178637919e-01 7.550000000000e-08 -2.242640687119e-01 7.575000000000e-08 6.021752652407e-02 7.600000000000e-08 -1.426636586643e-14 7.625000000000e-08 -1.801087632620e-01 7.650000000000e-08 2.426406871193e-02 7.675000000000e-08 2.336357275839e-01 7.700000000000e-08 6.647460359943e-15 7.725000000000e-08 -5.033942373345e-02 7.750000000000e-08 6.242640687119e-01 7.775000000000e-08 1.105467898425e+00 7.800000000000e-08 4.000000000000e-01 7.825000000000e-08 -7.027339492126e-01 7.850000000000e-08 -8.242640687119e-01 7.875000000000e-08 -1.993211525331e-01 7.900000000000e-08 -1.297573160031e-14 7.925000000000e-08 -2.668178637919e-01 7.950000000000e-08 -2.242640687119e-01 7.975000000000e-08 6.021752652407e-02 8.000000000000e-08 -5.578870698741e-15 ]
VWL006 (wl006 0) vsource type=pwl wave=[ 0.000000000000e+00 0.000000000000e+00 2.500000000000e-10 1.397824734759e-01 5.000000000000e-10 3.414213562373e-01 7.500000000000e-10 1.331821362081e-01 1.000000000000e-09 -9.714451465470e-17 1.250000000000e-09 3.993211525331e-01 1.500000000000e-09 5.414213562373e-01 1.750000000000e-09 -3.027339492126e-01 2.000000000000e-09 -1.200000000000e+00 2.250000000000e-09 -9.054678984252e-01 2.500000000000e-09 5.857864376269e-02 2.750000000000e-09 3.496605762665e-01 3.000000000000e-09 2.636779683485e-16 3.250000000000e-09 -3.363572758386e-02 3.500000000000e-09 2.585786437627e-01 3.750000000000e-09 2.198912367380e-01 4.000000000000e-09 -3.885780586188e-16 4.250000000000e-09 1.397824734759e-01 4.500000000000e-09 3.414213562373e-01 4.750000000000e-09 1.331821362081e-01 5.000000000000e-09 -6.522560269673e-16 5.250000000000e-09 3.993211525331e-01 5.500000000000e-09 5.414213562373e-01 5.750000000000e-09 -3.027339492126e-01 6.000000000000e-09 -1.200000000000e+00 6.250000000000e-09 -9.054678984252e-01 6.500000000000e-09 5.857864376269e-02 6.750000000000e-09 3.496605762665e-01 7.000000000000e-09 -2.775557561563e-17 7.250000000000e-09 -3.363572758386e-02 7.500000000000e-09 2.585786437627e-01 7.750000000000e-09 2.198912367380e-01 8.000000000000e-09 -8.326672684689e-16 8.250000000000e-09 1.397824734759e-01 8.500000000000e-09 3.414213562373e-01 8.750000000000e-09 1.331821362081e-01 9.000000000000e-09 4.579669976579e-16 9.250000000000e-09 3.993211525331e-01 9.500000000000e-09 5.414213562373e-01 9.750000000000e-09 -3.027339492126e-01 1.000000000000e-08 -1.200000000000e+00 1.025000000000e-08 -9.054678984252e-01 1.050000000000e-08 5.857864376269e-02 1.075000000000e-08 3.496605762665e-01 1.100000000000e-08 1.804112415016e-16 1.125000000000e-08 -3.363572758386e-02 1.150000000000e-08 2.585786437627e-01 1.175000000000e-08 2.198912367380e-01 1.200000000000e-08 -1.609823385706e-15 1.225000000000e-08 1.397824734759e-01 1.250000000000e-08 3.414213562373e-01 1.275000000000e-08 1.331821362081e-01 1.300000000000e-08 -1.706967900361e-15 1.325000000000e-08 3.993211525331e-01 1.350000000000e-08 5.414213562373e-01 1.375000000000e-08 -3.027339492126e-01 1.400000000000e-08 -1.200000000000e+00 1.425000000000e-08 -9.054678984252e-01 1.450000000000e-08 5.857864376269e-02 1.475000000000e-08 3.496605762665e-01 1.500000000000e-08 7.216449660064e-16 1.525000000000e-08 -3.363572758386e-02 1.550000000000e-08 2.585786437627e-01 1.575000000000e-08 2.198912367380e-01 1.600000000000e-08 -1.554312234475e-15 1.625000000000e-08 1.397824734759e-01 1.650000000000e-08 3.414213562373e-01 1.675000000000e-08 1.331821362081e-01 1.700000000000e-08 -1.804112415016e-15 1.725000000000e-08 3.993211525331e-01 1.750000000000e-08 5.414213562373e-01 1.775000000000e-08 -3.027339492126e-01 1.800000000000e-08 -1.200000000000e+00 1.825000000000e-08 -9.054678984252e-01 1.850000000000e-08 5.857864376269e-02 1.875000000000e-08 3.496605762665e-01 1.900000000000e-08 2.720046410332e-15 1.925000000000e-08 -3.363572758386e-02 1.950000000000e-08 2.585786437627e-01 1.975000000000e-08 2.198912367380e-01 2.000000000000e-08 -4.440892098501e-16 2.025000000000e-08 1.397824734759e-01 2.050000000000e-08 3.414213562373e-01 2.075000000000e-08 1.331821362081e-01 2.100000000000e-08 1.804112415016e-16 2.125000000000e-08 3.993211525331e-01 2.150000000000e-08 5.414213562373e-01 2.175000000000e-08 -3.027339492126e-01 2.200000000000e-08 -1.200000000000e+00 2.225000000000e-08 -9.054678984252e-01 2.250000000000e-08 5.857864376270e-02 2.275000000000e-08 3.496605762665e-01 2.300000000000e-08 1.137978600241e-15 2.325000000000e-08 -3.363572758386e-02 2.350000000000e-08 2.585786437627e-01 2.375000000000e-08 2.198912367380e-01 2.400000000000e-08 -3.275157922644e-15 2.425000000000e-08 1.397824734759e-01 2.450000000000e-08 3.414213562373e-01 2.475000000000e-08 1.331821362081e-01 2.500000000000e-08 -2.040034807749e-15 2.525000000000e-08 3.993211525331e-01 2.550000000000e-08 5.414213562373e-01 2.575000000000e-08 -3.027339492126e-01 2.600000000000e-08 -1.200000000000e+00 2.625000000000e-08 -9.054678984252e-01 2.650000000000e-08 5.857864376270e-02 2.675000000000e-08 3.496605762665e-01 2.700000000000e-08 2.775557561563e-15 2.725000000000e-08 -3.363572758386e-02 2.750000000000e-08 2.585786437627e-01 2.775000000000e-08 2.198912367380e-01 2.800000000000e-08 -2.442490654175e-15 2.825000000000e-08 1.397824734759e-01 2.850000000000e-08 3.414213562373e-01 2.875000000000e-08 1.331821362081e-01 2.900000000000e-08 -4.260480856999e-15 2.925000000000e-08 3.993211525331e-01 2.950000000000e-08 5.414213562373e-01 2.975000000000e-08 -3.027339492126e-01 3.000000000000e-08 -1.200000000000e+00 3.025000000000e-08 -9.054678984252e-01 3.050000000000e-08 5.857864376269e-02 3.075000000000e-08 3.496605762665e-01 3.100000000000e-08 5.065392549852e-15 3.125000000000e-08 -3.363572758385e-02 3.150000000000e-08 2.585786437627e-01 3.175000000000e-08 2.198912367380e-01 3.200000000000e-08 -3.219646771413e-15 3.225000000000e-08 1.397824734759e-01 3.250000000000e-08 3.414213562373e-01 3.275000000000e-08 1.331821362081e-01 3.300000000000e-08 -1.471045507628e-15 3.325000000000e-08 3.993211525331e-01 3.350000000000e-08 5.414213562373e-01 3.375000000000e-08 -3.027339492126e-01 3.400000000000e-08 -1.200000000000e+00 3.425000000000e-08 -9.054678984252e-01 3.450000000000e-08 5.857864376270e-02 3.475000000000e-08 3.496605762665e-01 3.500000000000e-08 -4.440892098501e-16 3.525000000000e-08 -3.363572758385e-02 3.550000000000e-08 2.585786437627e-01 3.575000000000e-08 2.198912367380e-01 3.600000000000e-08 -9.992007221626e-16 3.625000000000e-08 1.397824734759e-01 3.650000000000e-08 3.414213562373e-01 3.675000000000e-08 1.331821362081e-01 3.700000000000e-08 -8.701372955500e-15 3.725000000000e-08 3.993211525331e-01 3.750000000000e-08 5.414213562373e-01 3.775000000000e-08 -3.027339492126e-01 3.800000000000e-08 -1.200000000000e+00 3.825000000000e-08 -9.054678984252e-01 3.850000000000e-08 5.857864376268e-02 3.875000000000e-08 3.496605762666e-01 3.900000000000e-08 2.622901895677e-15 3.925000000000e-08 -3.363572758385e-02 3.950000000000e-08 2.585786437627e-01 3.975000000000e-08 2.198912367380e-01 4.000000000000e-08 -8.881784197001e-16 4.025000000000e-08 1.397824734759e-01 4.050000000000e-08 3.414213562373e-01 4.075000000000e-08 1.331821362081e-01 4.100000000000e-08 -5.981326545168e-15 4.125000000000e-08 3.993211525331e-01 4.150000000000e-08 5.414213562373e-01 4.175000000000e-08 -3.027339492126e-01 4.200000000000e-08 -1.200000000000e+00 4.225000000000e-08 -9.054678984252e-01 4.250000000000e-08 5.857864376269e-02 4.275000000000e-08 3.496605762666e-01 4.300000000000e-08 3.538835890993e-15 4.325000000000e-08 -3.363572758386e-02 4.350000000000e-08 2.585786437627e-01 4.375000000000e-08 2.198912367380e-01 4.400000000000e-08 -2.331468351713e-15 4.425000000000e-08 1.397824734759e-01 4.450000000000e-08 3.414213562373e-01 4.475000000000e-08 1.331821362081e-01 4.500000000000e-08 -3.191891195797e-15 4.525000000000e-08 3.993211525331e-01 4.550000000000e-08 5.414213562373e-01 4.575000000000e-08 -3.027339492126e-01 4.600000000000e-08 -1.200000000000e+00 4.625000000000e-08 -9.054678984252e-01 4.650000000000e-08 5.857864376270e-02 4.675000000000e-08 3.496605762665e-01 4.700000000000e-08 -1.970645868710e-15 4.725000000000e-08 -3.363572758386e-02 4.750000000000e-08 2.585786437627e-01 4.775000000000e-08 2.198912367380e-01 4.800000000000e-08 -6.550315845288e-15 4.825000000000e-08 1.397824734759e-01 4.850000000000e-08 3.414213562373e-01 4.875000000000e-08 1.331821362081e-01 4.900000000000e-08 -1.042221864367e-14 4.925000000000e-08 3.993211525331e-01 4.950000000000e-08 5.414213562373e-01 4.975000000000e-08 -3.027339492126e-01 5.000000000000e-08 -1.200000000000e+00 5.025000000000e-08 -9.054678984252e-01 5.050000000000e-08 5.857864376268e-02 5.075000000000e-08 3.496605762666e-01 5.100000000000e-08 8.146261443187e-15 5.125000000000e-08 -3.363572758385e-02 5.150000000000e-08 2.585786437627e-01 5.175000000000e-08 2.198912367380e-01 5.200000000000e-08 -3.608224830032e-15 5.225000000000e-08 1.397824734759e-01 5.250000000000e-08 3.414213562373e-01 5.275000000000e-08 1.331821362081e-01 5.300000000000e-08 -7.688294445529e-15 5.325000000000e-08 3.993211525331e-01 5.350000000000e-08 5.414213562373e-01 5.375000000000e-08 -3.027339492126e-01 5.400000000000e-08 -1.200000000000e+00 5.425000000000e-08 -9.054678984252e-01 5.450000000000e-08 5.857864376270e-02 5.475000000000e-08 3.496605762665e-01 5.500000000000e-08 1.121325254871e-14 5.525000000000e-08 -3.363572758385e-02 5.550000000000e-08 2.585786437627e-01 5.575000000000e-08 2.198912367379e-01 5.600000000000e-08 -5.051514762044e-15 5.625000000000e-08 1.397824734759e-01 5.650000000000e-08 3.414213562373e-01 5.675000000000e-08 1.331821362081e-01 5.700000000000e-08 -6.411537967210e-15 5.725000000000e-08 3.993211525331e-01 5.750000000000e-08 5.414213562373e-01 5.775000000000e-08 -3.027339492126e-01 5.800000000000e-08 -1.200000000000e+00 5.825000000000e-08 -9.054678984252e-01 5.850000000000e-08 5.857864376269e-02 5.875000000000e-08 3.496605762665e-01 5.900000000000e-08 -2.803313137179e-15 5.925000000000e-08 -3.363572758384e-02 5.950000000000e-08 2.585786437627e-01 5.975000000000e-08 2.198912367380e-01 6.000000000000e-08 -9.214851104389e-15 6.025000000000e-08 1.397824734759e-01 6.050000000000e-08 3.414213562373e-01 6.075000000000e-08 1.331821362081e-01 6.100000000000e-08 -5.051514762044e-15 6.125000000000e-08 3.993211525331e-01 6.150000000000e-08 5.414213562373e-01 6.175000000000e-08 -3.027339492126e-01 6.200000000000e-08 -1.200000000000e+00 6.225000000000e-08 -9.054678984252e-01 6.250000000000e-08 5.857864376272e-02 6.275000000000e-08 3.496605762665e-01 6.300000000000e-08 2.775557561563e-16 6.325000000000e-08 -3.363572758385e-02 6.350000000000e-08 2.585786437627e-01 6.375000000000e-08 2.198912367380e-01 6.400000000000e-08 -6.272760089132e-15 6.425000000000e-08 1.397824734759e-01 6.450000000000e-08 3.414213562373e-01 6.475000000000e-08 1.331821362081e-01 6.500000000000e-08 -1.079691891448e-14 6.525000000000e-08 3.993211525331e-01 6.550000000000e-08 5.414213562373e-01 6.575000000000e-08 -3.027339492126e-01 6.600000000000e-08 -1.200000000000e+00 6.625000000000e-08 -9.054678984252e-01 6.650000000000e-08 5.857864376270e-02 6.675000000000e-08 3.496605762666e-01 6.700000000000e-08 1.859623566247e-15 6.725000000000e-08 -3.363572758384e-02 6.750000000000e-08 2.585786437627e-01 6.775000000000e-08 2.198912367380e-01 6.800000000000e-08 -3.441691376338e-15 6.825000000000e-08 1.397824734759e-01 6.850000000000e-08 3.414213562373e-01 6.875000000000e-08 1.331821362081e-01 6.900000000000e-08 4.163336342344e-16 6.925000000000e-08 3.993211525331e-01 6.950000000000e-08 5.414213562373e-01 6.975000000000e-08 -3.027339492126e-01 7.000000000000e-08 -1.200000000000e+00 7.025000000000e-08 -9.054678984251e-01 7.050000000000e-08 5.857864376269e-02 7.075000000000e-08 3.496605762665e-01 7.100000000000e-08 3.511080315377e-15 7.125000000000e-08 -3.363572758384e-02 7.150000000000e-08 2.585786437627e-01 7.175000000000e-08 2.198912367379e-01 7.200000000000e-08 -1.942890293094e-15 7.225000000000e-08 1.397824734759e-01 7.250000000000e-08 3.414213562373e-01 7.275000000000e-08 1.331821362081e-01 7.300000000000e-08 1.762479051592e-15 7.325000000000e-08 3.993211525331e-01 7.350000000000e-08 5.414213562373e-01 7.375000000000e-08 -3.027339492126e-01 7.400000000000e-08 -1.200000000000e+00 7.425000000000e-08 -9.054678984251e-01 7.450000000000e-08 5.857864376268e-02 7.475000000000e-08 3.496605762665e-01 7.500000000000e-08 6.480926906249e-15 7.525000000000e-08 -3.363572758385e-02 7.550000000000e-08 2.585786437627e-01 7.575000000000e-08 2.198912367379e-01 7.600000000000e-08 -4.829470157119e-15 7.625000000000e-08 1.397824734759e-01 7.650000000000e-08 3.414213562373e-01 7.675000000000e-08 1.331821362081e-01 7.700000000000e-08 -1.398881011028e-14 7.725000000000e-08 3.993211525331e-01 7.750000000000e-08 5.414213562373e-01 7.775000000000e-08 -3.027339492126e-01 7.800000000000e-08 -1.200000000000e+00 7.825000000000e-08 -9.054678984252e-01 7.850000000000e-08 5.857864376271e-02 7.875000000000e-08 3.496605762665e-01 7.900000000000e-08 9.561795799584e-15 7.925000000000e-08 -3.363572758385e-02 7.950000000000e-08 2.585786437627e-01 7.975000000000e-08 2.198912367380e-01 8.000000000000e-08 -1.887379141863e-15 ]
VWL007 (wl007 0) vsource type=pwl wave=[ 0.000000000000e+00 0.000000000000e+00 2.500000000000e-10 1.801087632620e-01 5.000000000000e-10 -2.426406871193e-02 7.500000000000e-10 -2.336357275839e-01 1.000000000000e-09 9.714451465470e-17 1.250000000000e-09 5.033942373345e-02 1.500000000000e-09 -6.242640687119e-01 1.750000000000e-09 -1.105467898425e+00 2.000000000000e-09 -4.000000000000e-01 2.250000000000e-09 7.027339492126e-01 2.500000000000e-09 8.242640687119e-01 2.750000000000e-09 1.993211525331e-01 3.000000000000e-09 5.412337245048e-16 3.250000000000e-09 2.668178637919e-01 3.500000000000e-09 2.242640687119e-01 3.750000000000e-09 -6.021752652407e-02 4.000000000000e-09 1.193489751472e-15 4.250000000000e-09 1.801087632620e-01 4.500000000000e-09 -2.426406871193e-02 4.750000000000e-09 -2.336357275839e-01 5.000000000000e-09 -4.024558464266e-16 5.250000000000e-09 5.033942373345e-02 5.500000000000e-09 -6.242640687119e-01 5.750000000000e-09 -1.105467898425e+00 6.000000000000e-09 -4.000000000000e-01 6.250000000000e-09 7.027339492126e-01 6.500000000000e-09 8.242640687119e-01 6.750000000000e-09 1.993211525331e-01 7.000000000000e-09 8.743006318923e-16 7.250000000000e-09 2.668178637919e-01 7.500000000000e-09 2.242640687119e-01 7.750000000000e-09 -6.021752652407e-02 8.000000000000e-09 2.373101715136e-15 8.250000000000e-09 1.801087632620e-01 8.500000000000e-09 -2.426406871193e-02 8.750000000000e-09 -2.336357275839e-01 9.000000000000e-09 1.013078509970e-15 9.250000000000e-09 5.033942373345e-02 9.500000000000e-09 -6.242640687119e-01 9.750000000000e-09 -1.105467898425e+00 1.000000000000e-08 -4.000000000000e-01 1.025000000000e-08 7.027339492126e-01 1.050000000000e-08 8.242640687119e-01 1.075000000000e-08 1.993211525331e-01 1.100000000000e-08 7.632783294298e-16 1.125000000000e-08 2.668178637919e-01 1.150000000000e-08 2.242640687119e-01 1.175000000000e-08 -6.021752652407e-02 1.200000000000e-08 4.898859096159e-15 1.225000000000e-08 1.801087632620e-01 1.250000000000e-08 -2.426406871193e-02 1.275000000000e-08 -2.336357275839e-01 1.300000000000e-08 4.163336342344e-17 1.325000000000e-08 5.033942373345e-02 1.350000000000e-08 -6.242640687119e-01 1.375000000000e-08 -1.105467898425e+00 1.400000000000e-08 -4.000000000000e-01 1.425000000000e-08 7.027339492126e-01 1.450000000000e-08 8.242640687119e-01 1.475000000000e-08 1.993211525331e-01 1.500000000000e-08 3.191891195797e-15 1.525000000000e-08 2.668178637919e-01 1.550000000000e-08 2.242640687119e-01 1.575000000000e-08 -6.021752652407e-02 1.600000000000e-08 4.732325642465e-15 1.625000000000e-08 1.801087632620e-01 1.650000000000e-08 -2.426406871193e-02 1.675000000000e-08 -2.336357275839e-01 1.700000000000e-08 -1.110223024625e-16 1.725000000000e-08 5.033942373345e-02 1.750000000000e-08 -6.242640687119e-01 1.775000000000e-08 -1.105467898425e+00 1.800000000000e-08 -4.000000000000e-01 1.825000000000e-08 7.027339492126e-01 1.850000000000e-08 8.242640687119e-01 1.875000000000e-08 1.993211525331e-01 1.900000000000e-08 1.304512053935e-15 1.925000000000e-08 2.668178637919e-01 1.950000000000e-08 2.242640687119e-01 1.975000000000e-08 -6.021752652407e-02 2.000000000000e-08 1.387778780781e-15 2.025000000000e-08 1.801087632620e-01 2.050000000000e-08 -2.426406871193e-02 2.075000000000e-08 -2.336357275839e-01 2.100000000000e-08 4.024558464266e-16 2.125000000000e-08 5.033942373345e-02 2.150000000000e-08 -6.242640687119e-01 2.175000000000e-08 -1.105467898425e+00 2.200000000000e-08 -4.000000000000e-01 2.225000000000e-08 7.027339492126e-01 2.250000000000e-08 8.242640687119e-01 2.275000000000e-08 1.993211525331e-01 2.300000000000e-08 2.955968803064e-15 2.325000000000e-08 2.668178637919e-01 2.350000000000e-08 2.242640687119e-01 2.375000000000e-08 -6.021752652407e-02 2.400000000000e-08 9.769962616701e-15 2.425000000000e-08 1.801087632620e-01 2.450000000000e-08 -2.426406871193e-02 2.475000000000e-08 -2.336357275839e-01 2.500000000000e-08 -4.718447854657e-16 2.525000000000e-08 5.033942373345e-02 2.550000000000e-08 -6.242640687119e-01 2.575000000000e-08 -1.105467898425e+00 2.600000000000e-08 -4.000000000000e-01 2.625000000000e-08 7.027339492126e-01 2.650000000000e-08 8.242640687119e-01 2.675000000000e-08 1.993211525331e-01 2.700000000000e-08 -1.346145417358e-15 2.725000000000e-08 2.668178637919e-01 2.750000000000e-08 2.242640687119e-01 2.775000000000e-08 -6.021752652407e-02 2.800000000000e-08 7.494005416220e-15 2.825000000000e-08 1.801087632620e-01 2.850000000000e-08 -2.426406871193e-02 2.875000000000e-08 -2.336357275839e-01 2.900000000000e-08 -1.443289932013e-15 2.925000000000e-08 5.033942373345e-02 2.950000000000e-08 -6.242640687119e-01 2.975000000000e-08 -1.105467898425e+00 3.000000000000e-08 -4.000000000000e-01 3.025000000000e-08 7.027339492126e-01 3.050000000000e-08 8.242640687119e-01 3.075000000000e-08 1.993211525331e-01 3.100000000000e-08 -7.632783294298e-16 3.125000000000e-08 2.668178637919e-01 3.150000000000e-08 2.242640687119e-01 3.175000000000e-08 -6.021752652407e-02 3.200000000000e-08 9.478529072737e-15 3.225000000000e-08 1.801087632620e-01 3.250000000000e-08 -2.426406871193e-02 3.275000000000e-08 -2.336357275839e-01 3.300000000000e-08 4.052314039882e-15 3.325000000000e-08 5.033942373345e-02 3.350000000000e-08 -6.242640687119e-01 3.375000000000e-08 -1.105467898425e+00 3.400000000000e-08 -4.000000000000e-01 3.425000000000e-08 7.027339492126e-01 3.450000000000e-08 8.242640687119e-01 3.475000000000e-08 1.993211525331e-01 3.500000000000e-08 2.012279232133e-15 3.525000000000e-08 2.668178637919e-01 3.550000000000e-08 2.242640687119e-01 3.575000000000e-08 -6.021752652407e-02 3.600000000000e-08 2.942091015257e-15 3.625000000000e-08 1.801087632620e-01 3.650000000000e-08 -2.426406871193e-02 3.675000000000e-08 -2.336357275839e-01 3.700000000000e-08 -3.233524559221e-15 3.725000000000e-08 5.033942373346e-02 3.750000000000e-08 -6.242640687119e-01 3.775000000000e-08 -1.105467898425e+00 3.800000000000e-08 -4.000000000000e-01 3.825000000000e-08 7.027339492126e-01 3.850000000000e-08 8.242640687119e-01 3.875000000000e-08 1.993211525331e-01 3.900000000000e-08 7.591149930875e-15 3.925000000000e-08 2.668178637919e-01 3.950000000000e-08 2.242640687119e-01 3.975000000000e-08 -6.021752652407e-02 4.000000000000e-08 2.789435349371e-15 4.025000000000e-08 1.801087632620e-01 4.050000000000e-08 -2.426406871194e-02 4.075000000000e-08 -2.336357275839e-01 4.100000000000e-08 2.275957200482e-15 4.125000000000e-08 5.033942373345e-02 4.150000000000e-08 -6.242640687119e-01 4.175000000000e-08 -1.105467898425e+00 4.200000000000e-08 -4.000000000000e-01 4.225000000000e-08 7.027339492126e-01 4.250000000000e-08 8.242640687119e-01 4.275000000000e-08 1.993211525331e-01 4.300000000000e-08 -1.748601263785e-15 4.325000000000e-08 2.668178637919e-01 4.350000000000e-08 2.242640687119e-01 4.375000000000e-08 -6.021752652407e-02 4.400000000000e-08 6.911138328292e-15 4.425000000000e-08 1.801087632620e-01 4.450000000000e-08 -2.426406871193e-02 4.475000000000e-08 -2.336357275839e-01 4.500000000000e-08 7.716050021145e-15 4.525000000000e-08 5.033942373345e-02 4.550000000000e-08 -6.242640687119e-01 4.575000000000e-08 -1.105467898425e+00 4.600000000000e-08 -4.000000000000e-01 4.625000000000e-08 7.027339492126e-01 4.650000000000e-08 8.242640687119e-01 4.675000000000e-08 1.993211525331e-01 4.700000000000e-08 9.714451465470e-16 4.725000000000e-08 2.668178637919e-01 4.750000000000e-08 2.242640687119e-01 4.775000000000e-08 -6.021752652407e-02 4.800000000000e-08 1.955380302121e-14 4.825000000000e-08 1.801087632620e-01 4.850000000000e-08 -2.426406871194e-02 4.875000000000e-08 -2.336357275839e-01 4.900000000000e-08 4.302114220422e-16 4.925000000000e-08 5.033942373345e-02 4.950000000000e-08 -6.242640687119e-01 4.975000000000e-08 -1.105467898425e+00 5.000000000000e-08 -4.000000000000e-01 5.025000000000e-08 7.027339492126e-01 5.050000000000e-08 8.242640687119e-01 5.075000000000e-08 1.993211525331e-01 5.100000000000e-08 -5.551115123126e-16 5.125000000000e-08 2.668178637919e-01 5.150000000000e-08 2.242640687119e-01 5.175000000000e-08 -6.021752652407e-02 5.200000000000e-08 1.088018564133e-14 5.225000000000e-08 1.801087632620e-01 5.250000000000e-08 -2.426406871193e-02 5.275000000000e-08 -2.336357275839e-01 5.300000000000e-08 5.925815393937e-15 5.325000000000e-08 5.033942373345e-02 5.350000000000e-08 -6.242640687119e-01 5.375000000000e-08 -1.105467898425e+00 5.400000000000e-08 -4.000000000000e-01 5.425000000000e-08 7.027339492126e-01 5.450000000000e-08 8.242640687119e-01 5.475000000000e-08 1.993211525331e-01 5.500000000000e-08 5.065392549852e-15 5.525000000000e-08 2.668178637919e-01 5.550000000000e-08 2.242640687119e-01 5.575000000000e-08 -6.021752652407e-02 5.600000000000e-08 1.498801083244e-14 5.625000000000e-08 1.801087632620e-01 5.650000000000e-08 -2.426406871194e-02 5.675000000000e-08 -2.336357275839e-01 5.700000000000e-08 1.457167719821e-15 5.725000000000e-08 5.033942373345e-02 5.750000000000e-08 -6.242640687119e-01 5.775000000000e-08 -1.105467898425e+00 5.800000000000e-08 -4.000000000000e-01 5.825000000000e-08 7.027339492126e-01 5.850000000000e-08 8.242640687119e-01 5.875000000000e-08 1.993211525331e-01 5.900000000000e-08 4.968248035198e-15 5.925000000000e-08 2.668178637919e-01 5.950000000000e-08 2.242640687119e-01 5.975000000000e-08 -6.021752652407e-02 6.000000000000e-08 2.765843110097e-14 6.025000000000e-08 1.801087632620e-01 6.050000000000e-08 -2.426406871195e-02 6.075000000000e-08 -2.336357275839e-01 6.100000000000e-08 -2.942091015257e-15 6.125000000000e-08 5.033942373345e-02 6.150000000000e-08 -6.242640687119e-01 6.175000000000e-08 -1.105467898425e+00 6.200000000000e-08 -4.000000000000e-01 6.225000000000e-08 7.027339492126e-01 6.250000000000e-08 8.242640687119e-01 6.275000000000e-08 1.993211525331e-01 6.300000000000e-08 1.051936315832e-14 6.325000000000e-08 2.668178637919e-01 6.350000000000e-08 2.242640687119e-01 6.375000000000e-08 -6.021752652407e-02 6.400000000000e-08 1.897093593328e-14 6.425000000000e-08 1.801087632620e-01 6.450000000000e-08 -2.426406871195e-02 6.475000000000e-08 -2.336357275839e-01 6.500000000000e-08 -3.330669073875e-16 6.525000000000e-08 5.033942373345e-02 6.550000000000e-08 -6.242640687119e-01 6.575000000000e-08 -1.105467898425e+00 6.600000000000e-08 -4.000000000000e-01 6.625000000000e-08 7.027339492126e-01 6.650000000000e-08 8.242640687119e-01 6.675000000000e-08 1.993211525331e-01 6.700000000000e-08 6.161737786670e-15 6.725000000000e-08 2.668178637919e-01 6.750000000000e-08 2.242640687119e-01 6.775000000000e-08 -6.021752652407e-02 6.800000000000e-08 1.028344076559e-14 6.825000000000e-08 1.801087632620e-01 6.850000000000e-08 -2.426406871194e-02 6.875000000000e-08 -2.336357275839e-01 6.900000000000e-08 7.993605777301e-15 6.925000000000e-08 5.033942373346e-02 6.950000000000e-08 -6.242640687119e-01 6.975000000000e-08 -1.105467898425e+00 7.000000000000e-08 -4.000000000000e-01 7.025000000000e-08 7.027339492126e-01 7.050000000000e-08 8.242640687119e-01 7.075000000000e-08 1.993211525331e-01 7.100000000000e-08 1.817990202824e-15 7.125000000000e-08 2.668178637919e-01 7.150000000000e-08 2.242640687119e-01 7.175000000000e-08 -6.021752652407e-02 7.200000000000e-08 5.884182030513e-15 7.225000000000e-08 1.801087632620e-01 7.250000000000e-08 -2.426406871194e-02 7.275000000000e-08 -2.336357275839e-01 7.300000000000e-08 3.524958103185e-15 7.325000000000e-08 5.033942373344e-02 7.350000000000e-08 -6.242640687119e-01 7.375000000000e-08 -1.105467898425e+00 7.400000000000e-08 -4.000000000000e-01 7.425000000000e-08 7.027339492126e-01 7.450000000000e-08 8.242640687119e-01 7.475000000000e-08 1.993211525331e-01 7.500000000000e-08 7.369105325949e-15 7.525000000000e-08 2.668178637919e-01 7.550000000000e-08 2.242640687119e-01 7.575000000000e-08 -6.021752652407e-02 7.600000000000e-08 1.426636586643e-14 7.625000000000e-08 1.801087632620e-01 7.650000000000e-08 -2.426406871193e-02 7.675000000000e-08 -2.336357275839e-01 7.700000000000e-08 -6.647460359943e-15 7.725000000000e-08 5.033942373345e-02 7.750000000000e-08 -6.242640687119e-01 7.775000000000e-08 -1.105467898425e+00 7.800000000000e-08 -4.000000000000e-01 7.825000000000e-08 7.027339492126e-01 7.850000000000e-08 8.242640687119e-01 7.875000000000e-08 1.993211525331e-01 7.900000000000e-08 1.297573160031e-14 7.925000000000e-08 2.668178637919e-01 7.950000000000e-08 2.242640687119e-01 7.975000000000e-08 -6.021752652407e-02 8.000000000000e-08 5.578870698741e-15 ]
RBLLOAD000 (bl000 0) resistor r=1
RBLLOAD001 (bl001 0) resistor r=1
RBLLOAD002 (bl002 0) resistor r=1
RBLLOAD003 (bl003 0) resistor r=1
RBLLOAD004 (bl004 0) resistor r=1
RBLLOAD005 (bl005 0) resistor r=1
RBLLOAD006 (bl006 0) resistor r=1
RBLLOAD007 (bl007 0) resistor r=1
MSEL_r000_c000 (n_r000_c000 vdd wl000 wl000) nsel w=45n l=45n
RRAM_r000_c000 (n_r000_c000 bl000) resistor r=1k
MSEL_r000_c001 (n_r000_c001 vdd wl000 wl000) nsel w=45n l=45n
RRAM_r000_c001 (n_r000_c001 bl001) resistor r=1k
MSEL_r000_c002 (n_r000_c002 vdd wl000 wl000) nsel w=45n l=45n
RRAM_r000_c002 (n_r000_c002 bl002) resistor r=1meg
MSEL_r000_c003 (n_r000_c003 vdd wl000 wl000) nsel w=45n l=45n
RRAM_r000_c003 (n_r000_c003 bl003) resistor r=1k
MSEL_r000_c004 (n_r000_c004 vdd wl000 wl000) nsel w=45n l=45n
RRAM_r000_c004 (n_r000_c004 bl004) resistor r=1k
MSEL_r000_c005 (n_r000_c005 vdd wl000 wl000) nsel w=45n l=45n
RRAM_r000_c005 (n_r000_c005 bl005) resistor r=1k
MSEL_r000_c006 (n_r000_c006 vdd wl000 wl000) nsel w=45n l=45n
RRAM_r000_c006 (n_r000_c006 bl006) resistor r=1k
MSEL_r000_c007 (n_r000_c007 vdd wl000 wl000) nsel w=45n l=45n
RRAM_r000_c007 (n_r000_c007 bl007) resistor r=1k
MSEL_r001_c000 (n_r001_c000 vdd wl001 wl001) nsel w=45n l=45n
RRAM_r001_c000 (n_r001_c000 bl000) resistor r=1k
MSEL_r001_c001 (n_r001_c001 vdd wl001 wl001) nsel w=45n l=45n
RRAM_r001_c001 (n_r001_c001 bl001) resistor r=1k
MSEL_r001_c002 (n_r001_c002 vdd wl001 wl001) nsel w=45n l=45n
RRAM_r001_c002 (n_r001_c002 bl002) resistor r=1meg
MSEL_r001_c003 (n_r001_c003 vdd wl001 wl001) nsel w=45n l=45n
RRAM_r001_c003 (n_r001_c003 bl003) resistor r=1k
MSEL_r001_c004 (n_r001_c004 vdd wl001 wl001) nsel w=45n l=45n
RRAM_r001_c004 (n_r001_c004 bl004) resistor r=1k
MSEL_r001_c005 (n_r001_c005 vdd wl001 wl001) nsel w=45n l=45n
RRAM_r001_c005 (n_r001_c005 bl005) resistor r=1meg
MSEL_r001_c006 (n_r001_c006 vdd wl001 wl001) nsel w=45n l=45n
RRAM_r001_c006 (n_r001_c006 bl006) resistor r=1meg
MSEL_r001_c007 (n_r001_c007 vdd wl001 wl001) nsel w=45n l=45n
RRAM_r001_c007 (n_r001_c007 bl007) resistor r=1meg
MSEL_r002_c000 (n_r002_c000 vdd wl002 wl002) nsel w=45n l=45n
RRAM_r002_c000 (n_r002_c000 bl000) resistor r=1k
MSEL_r002_c001 (n_r002_c001 vdd wl002 wl002) nsel w=45n l=45n
RRAM_r002_c001 (n_r002_c001 bl001) resistor r=1k
MSEL_r002_c002 (n_r002_c002 vdd wl002 wl002) nsel w=45n l=45n
RRAM_r002_c002 (n_r002_c002 bl002) resistor r=1k
MSEL_r002_c003 (n_r002_c003 vdd wl002 wl002) nsel w=45n l=45n
RRAM_r002_c003 (n_r002_c003 bl003) resistor r=1meg
MSEL_r002_c004 (n_r002_c004 vdd wl002 wl002) nsel w=45n l=45n
RRAM_r002_c004 (n_r002_c004 bl004) resistor r=1k
MSEL_r002_c005 (n_r002_c005 vdd wl002 wl002) nsel w=45n l=45n
RRAM_r002_c005 (n_r002_c005 bl005) resistor r=1k
MSEL_r002_c006 (n_r002_c006 vdd wl002 wl002) nsel w=45n l=45n
RRAM_r002_c006 (n_r002_c006 bl006) resistor r=1k
MSEL_r002_c007 (n_r002_c007 vdd wl002 wl002) nsel w=45n l=45n
RRAM_r002_c007 (n_r002_c007 bl007) resistor r=1k
MSEL_r003_c000 (n_r003_c000 vdd wl003 wl003) nsel w=45n l=45n
RRAM_r003_c000 (n_r003_c000 bl000) resistor r=1k
MSEL_r003_c001 (n_r003_c001 vdd wl003 wl003) nsel w=45n l=45n
RRAM_r003_c001 (n_r003_c001 bl001) resistor r=1k
MSEL_r003_c002 (n_r003_c002 vdd wl003 wl003) nsel w=45n l=45n
RRAM_r003_c002 (n_r003_c002 bl002) resistor r=1meg
MSEL_r003_c003 (n_r003_c003 vdd wl003 wl003) nsel w=45n l=45n
RRAM_r003_c003 (n_r003_c003 bl003) resistor r=1k
MSEL_r003_c004 (n_r003_c004 vdd wl003 wl003) nsel w=45n l=45n
RRAM_r003_c004 (n_r003_c004 bl004) resistor r=1k
MSEL_r003_c005 (n_r003_c005 vdd wl003 wl003) nsel w=45n l=45n
RRAM_r003_c005 (n_r003_c005 bl005) resistor r=1k
MSEL_r003_c006 (n_r003_c006 vdd wl003 wl003) nsel w=45n l=45n
RRAM_r003_c006 (n_r003_c006 bl006) resistor r=1meg
MSEL_r003_c007 (n_r003_c007 vdd wl003 wl003) nsel w=45n l=45n
RRAM_r003_c007 (n_r003_c007 bl007) resistor r=1meg
MSEL_r004_c000 (n_r004_c000 vdd wl004 wl004) nsel w=45n l=45n
RRAM_r004_c000 (n_r004_c000 bl000) resistor r=1k
MSEL_r004_c001 (n_r004_c001 vdd wl004 wl004) nsel w=45n l=45n
RRAM_r004_c001 (n_r004_c001 bl001) resistor r=1k
MSEL_r004_c002 (n_r004_c002 vdd wl004 wl004) nsel w=45n l=45n
RRAM_r004_c002 (n_r004_c002 bl002) resistor r=1meg
MSEL_r004_c003 (n_r004_c003 vdd wl004 wl004) nsel w=45n l=45n
RRAM_r004_c003 (n_r004_c003 bl003) resistor r=1meg
MSEL_r004_c004 (n_r004_c004 vdd wl004 wl004) nsel w=45n l=45n
RRAM_r004_c004 (n_r004_c004 bl004) resistor r=1meg
MSEL_r004_c005 (n_r004_c005 vdd wl004 wl004) nsel w=45n l=45n
RRAM_r004_c005 (n_r004_c005 bl005) resistor r=1k
MSEL_r004_c006 (n_r004_c006 vdd wl004 wl004) nsel w=45n l=45n
RRAM_r004_c006 (n_r004_c006 bl006) resistor r=1k
MSEL_r004_c007 (n_r004_c007 vdd wl004 wl004) nsel w=45n l=45n
RRAM_r004_c007 (n_r004_c007 bl007) resistor r=1k
MSEL_r005_c000 (n_r005_c000 vdd wl005 wl005) nsel w=45n l=45n
RRAM_r005_c000 (n_r005_c000 bl000) resistor r=1meg
MSEL_r005_c001 (n_r005_c001 vdd wl005 wl005) nsel w=45n l=45n
RRAM_r005_c001 (n_r005_c001 bl001) resistor r=1k
MSEL_r005_c002 (n_r005_c002 vdd wl005 wl005) nsel w=45n l=45n
RRAM_r005_c002 (n_r005_c002 bl002) resistor r=1k
MSEL_r005_c003 (n_r005_c003 vdd wl005 wl005) nsel w=45n l=45n
RRAM_r005_c003 (n_r005_c003 bl003) resistor r=1k
MSEL_r005_c004 (n_r005_c004 vdd wl005 wl005) nsel w=45n l=45n
RRAM_r005_c004 (n_r005_c004 bl004) resistor r=1meg
MSEL_r005_c005 (n_r005_c005 vdd wl005 wl005) nsel w=45n l=45n
RRAM_r005_c005 (n_r005_c005 bl005) resistor r=1k
MSEL_r005_c006 (n_r005_c006 vdd wl005 wl005) nsel w=45n l=45n
RRAM_r005_c006 (n_r005_c006 bl006) resistor r=1k
MSEL_r005_c007 (n_r005_c007 vdd wl005 wl005) nsel w=45n l=45n
RRAM_r005_c007 (n_r005_c007 bl007) resistor r=1k
MSEL_r006_c000 (n_r006_c000 vdd wl006 wl006) nsel w=45n l=45n
RRAM_r006_c000 (n_r006_c000 bl000) resistor r=1k
MSEL_r006_c001 (n_r006_c001 vdd wl006 wl006) nsel w=45n l=45n
RRAM_r006_c001 (n_r006_c001 bl001) resistor r=1k
MSEL_r006_c002 (n_r006_c002 vdd wl006 wl006) nsel w=45n l=45n
RRAM_r006_c002 (n_r006_c002 bl002) resistor r=1meg
MSEL_r006_c003 (n_r006_c003 vdd wl006 wl006) nsel w=45n l=45n
RRAM_r006_c003 (n_r006_c003 bl003) resistor r=1meg
MSEL_r006_c004 (n_r006_c004 vdd wl006 wl006) nsel w=45n l=45n
RRAM_r006_c004 (n_r006_c004 bl004) resistor r=1k
MSEL_r006_c005 (n_r006_c005 vdd wl006 wl006) nsel w=45n l=45n
RRAM_r006_c005 (n_r006_c005 bl005) resistor r=1meg
MSEL_r006_c006 (n_r006_c006 vdd wl006 wl006) nsel w=45n l=45n
RRAM_r006_c006 (n_r006_c006 bl006) resistor r=1meg
MSEL_r006_c007 (n_r006_c007 vdd wl006 wl006) nsel w=45n l=45n
RRAM_r006_c007 (n_r006_c007 bl007) resistor r=1meg
MSEL_r007_c000 (n_r007_c000 vdd wl007 wl007) nsel w=45n l=45n
RRAM_r007_c000 (n_r007_c000 bl000) resistor r=1meg
MSEL_r007_c001 (n_r007_c001 vdd wl007 wl007) nsel w=45n l=45n
RRAM_r007_c001 (n_r007_c001 bl001) resistor r=1k
MSEL_r007_c002 (n_r007_c002 vdd wl007 wl007) nsel w=45n l=45n
RRAM_r007_c002 (n_r007_c002 bl002) resistor r=1meg
MSEL_r007_c003 (n_r007_c003 vdd wl007 wl007) nsel w=45n l=45n
RRAM_r007_c003 (n_r007_c003 bl003) resistor r=1meg
MSEL_r007_c004 (n_r007_c004 vdd wl007 wl007) nsel w=45n l=45n
RRAM_r007_c004 (n_r007_c004 bl004) resistor r=1meg
MSEL_r007_c005 (n_r007_c005 vdd wl007 wl007) nsel w=45n l=45n
RRAM_r007_c005 (n_r007_c005 bl005) resistor r=1meg
MSEL_r007_c006 (n_r007_c006 vdd wl007 wl007) nsel w=45n l=45n
RRAM_r007_c006 (n_r007_c006 bl006) resistor r=1meg
MSEL_r007_c007 (n_r007_c007 vdd wl007 wl007) nsel w=45n l=45n
RRAM_r007_c007 (n_r007_c007 bl007) resistor r=1meg
save bl000
save bl001
save bl002
save bl003
save bl004
save bl005
save bl006
save bl007
