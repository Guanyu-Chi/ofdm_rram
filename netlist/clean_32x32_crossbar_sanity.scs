// Sanity read-state OFDM/QAM-RRAM crossbar netlist
simulator lang=spectre
global 0 vdd
model nsel mos1 type=n vto=0.35 kp=250u lambda=0.05
VDD (vdd 0) vsource dc=1.0

VWL000 (wl000 0) vsource type=pwl wave=[ 0.000000000000e+00 0.000000000000e+00 2.500000000000e-10 -1.397824734759e-01 5.000000000000e-10 -3.414213562373e-01 7.500000000000e-10 -1.331821362081e-01 1.000000000000e-09 9.714451465470e-17 1.250000000000e-09 -3.993211525331e-01 1.500000000000e-09 -5.414213562373e-01 1.750000000000e-09 3.027339492126e-01 2.000000000000e-09 1.200000000000e+00 2.250000000000e-09 9.054678984252e-01 2.500000000000e-09 -5.857864376269e-02 2.750000000000e-09 -3.496605762665e-01 3.000000000000e-09 -2.636779683485e-16 3.250000000000e-09 3.363572758386e-02 3.500000000000e-09 -2.585786437627e-01 3.750000000000e-09 -2.198912367380e-01 4.000000000000e-09 3.885780586188e-16 4.250000000000e-09 -1.397824734759e-01 4.500000000000e-09 -3.414213562373e-01 4.750000000000e-09 -1.331821362081e-01 5.000000000000e-09 6.522560269673e-16 5.250000000000e-09 -3.993211525331e-01 5.500000000000e-09 -5.414213562373e-01 5.750000000000e-09 3.027339492126e-01 6.000000000000e-09 1.200000000000e+00 6.250000000000e-09 9.054678984252e-01 6.500000000000e-09 -5.857864376269e-02 6.750000000000e-09 -3.496605762665e-01 7.000000000000e-09 2.775557561563e-17 7.250000000000e-09 3.363572758386e-02 7.500000000000e-09 -2.585786437627e-01 7.750000000000e-09 -2.198912367380e-01 8.000000000000e-09 8.326672684689e-16 8.250000000000e-09 -1.397824734759e-01 8.500000000000e-09 -3.414213562373e-01 8.750000000000e-09 -1.331821362081e-01 9.000000000000e-09 -4.579669976579e-16 9.250000000000e-09 -3.993211525331e-01 9.500000000000e-09 -5.414213562373e-01 9.750000000000e-09 3.027339492126e-01 1.000000000000e-08 1.200000000000e+00 1.025000000000e-08 9.054678984252e-01 1.050000000000e-08 -5.857864376269e-02 1.075000000000e-08 -3.496605762665e-01 1.100000000000e-08 -1.804112415016e-16 1.125000000000e-08 3.363572758386e-02 1.150000000000e-08 -2.585786437627e-01 1.175000000000e-08 -2.198912367380e-01 1.200000000000e-08 1.609823385706e-15 1.225000000000e-08 -1.397824734759e-01 1.250000000000e-08 -3.414213562373e-01 1.275000000000e-08 -1.331821362081e-01 1.300000000000e-08 1.706967900361e-15 1.325000000000e-08 -3.993211525331e-01 1.350000000000e-08 -5.414213562373e-01 1.375000000000e-08 3.027339492126e-01 1.400000000000e-08 1.200000000000e+00 1.425000000000e-08 9.054678984252e-01 1.450000000000e-08 -5.857864376269e-02 1.475000000000e-08 -3.496605762665e-01 1.500000000000e-08 -7.216449660064e-16 1.525000000000e-08 3.363572758386e-02 1.550000000000e-08 -2.585786437627e-01 1.575000000000e-08 -2.198912367380e-01 1.600000000000e-08 1.554312234475e-15 1.625000000000e-08 -1.397824734759e-01 1.650000000000e-08 -3.414213562373e-01 1.675000000000e-08 -1.331821362081e-01 1.700000000000e-08 1.804112415016e-15 1.725000000000e-08 -3.993211525331e-01 1.750000000000e-08 -5.414213562373e-01 1.775000000000e-08 3.027339492126e-01 1.800000000000e-08 1.200000000000e+00 1.825000000000e-08 9.054678984252e-01 1.850000000000e-08 -5.857864376269e-02 1.875000000000e-08 -3.496605762665e-01 1.900000000000e-08 -2.720046410332e-15 1.925000000000e-08 3.363572758386e-02 1.950000000000e-08 -2.585786437627e-01 1.975000000000e-08 -2.198912367380e-01 2.000000000000e-08 4.440892098501e-16 2.025000000000e-08 -1.397824734759e-01 2.050000000000e-08 -3.414213562373e-01 2.075000000000e-08 -1.331821362081e-01 2.100000000000e-08 -1.804112415016e-16 2.125000000000e-08 -3.993211525331e-01 2.150000000000e-08 -5.414213562373e-01 2.175000000000e-08 3.027339492126e-01 2.200000000000e-08 1.200000000000e+00 2.225000000000e-08 9.054678984252e-01 2.250000000000e-08 -5.857864376270e-02 2.275000000000e-08 -3.496605762665e-01 2.300000000000e-08 -1.137978600241e-15 2.325000000000e-08 3.363572758386e-02 2.350000000000e-08 -2.585786437627e-01 2.375000000000e-08 -2.198912367380e-01 2.400000000000e-08 3.275157922644e-15 2.425000000000e-08 -1.397824734759e-01 2.450000000000e-08 -3.414213562373e-01 2.475000000000e-08 -1.331821362081e-01 2.500000000000e-08 2.040034807749e-15 2.525000000000e-08 -3.993211525331e-01 2.550000000000e-08 -5.414213562373e-01 2.575000000000e-08 3.027339492126e-01 2.600000000000e-08 1.200000000000e+00 2.625000000000e-08 9.054678984252e-01 2.650000000000e-08 -5.857864376270e-02 2.675000000000e-08 -3.496605762665e-01 2.700000000000e-08 -2.775557561563e-15 2.725000000000e-08 3.363572758386e-02 2.750000000000e-08 -2.585786437627e-01 2.775000000000e-08 -2.198912367380e-01 2.800000000000e-08 2.442490654175e-15 2.825000000000e-08 -1.397824734759e-01 2.850000000000e-08 -3.414213562373e-01 2.875000000000e-08 -1.331821362081e-01 2.900000000000e-08 4.260480856999e-15 2.925000000000e-08 -3.993211525331e-01 2.950000000000e-08 -5.414213562373e-01 2.975000000000e-08 3.027339492126e-01 3.000000000000e-08 1.200000000000e+00 3.025000000000e-08 9.054678984252e-01 3.050000000000e-08 -5.857864376269e-02 3.075000000000e-08 -3.496605762665e-01 3.100000000000e-08 -5.065392549852e-15 3.125000000000e-08 3.363572758385e-02 3.150000000000e-08 -2.585786437627e-01 3.175000000000e-08 -2.198912367380e-01 3.200000000000e-08 3.219646771413e-15 3.225000000000e-08 -1.397824734759e-01 3.250000000000e-08 -3.414213562373e-01 3.275000000000e-08 -1.331821362081e-01 3.300000000000e-08 1.471045507628e-15 3.325000000000e-08 -3.993211525331e-01 3.350000000000e-08 -5.414213562373e-01 3.375000000000e-08 3.027339492126e-01 3.400000000000e-08 1.200000000000e+00 3.425000000000e-08 9.054678984252e-01 3.450000000000e-08 -5.857864376270e-02 3.475000000000e-08 -3.496605762665e-01 3.500000000000e-08 4.440892098501e-16 3.525000000000e-08 3.363572758385e-02 3.550000000000e-08 -2.585786437627e-01 3.575000000000e-08 -2.198912367380e-01 3.600000000000e-08 9.992007221626e-16 3.625000000000e-08 -1.397824734759e-01 3.650000000000e-08 -3.414213562373e-01 3.675000000000e-08 -1.331821362081e-01 3.700000000000e-08 8.701372955500e-15 3.725000000000e-08 -3.993211525331e-01 3.750000000000e-08 -5.414213562373e-01 3.775000000000e-08 3.027339492126e-01 3.800000000000e-08 1.200000000000e+00 3.825000000000e-08 9.054678984252e-01 3.850000000000e-08 -5.857864376268e-02 3.875000000000e-08 -3.496605762666e-01 3.900000000000e-08 -2.622901895677e-15 3.925000000000e-08 3.363572758385e-02 3.950000000000e-08 -2.585786437627e-01 3.975000000000e-08 -2.198912367380e-01 4.000000000000e-08 8.881784197001e-16 4.025000000000e-08 -1.397824734759e-01 4.050000000000e-08 -3.414213562373e-01 4.075000000000e-08 -1.331821362081e-01 4.100000000000e-08 5.981326545168e-15 4.125000000000e-08 -3.993211525331e-01 4.150000000000e-08 -5.414213562373e-01 4.175000000000e-08 3.027339492126e-01 4.200000000000e-08 1.200000000000e+00 4.225000000000e-08 9.054678984252e-01 4.250000000000e-08 -5.857864376269e-02 4.275000000000e-08 -3.496605762666e-01 4.300000000000e-08 -3.538835890993e-15 4.325000000000e-08 3.363572758386e-02 4.350000000000e-08 -2.585786437627e-01 4.375000000000e-08 -2.198912367380e-01 4.400000000000e-08 2.331468351713e-15 4.425000000000e-08 -1.397824734759e-01 4.450000000000e-08 -3.414213562373e-01 4.475000000000e-08 -1.331821362081e-01 4.500000000000e-08 3.191891195797e-15 4.525000000000e-08 -3.993211525331e-01 4.550000000000e-08 -5.414213562373e-01 4.575000000000e-08 3.027339492126e-01 4.600000000000e-08 1.200000000000e+00 4.625000000000e-08 9.054678984252e-01 4.650000000000e-08 -5.857864376270e-02 4.675000000000e-08 -3.496605762665e-01 4.700000000000e-08 1.970645868710e-15 4.725000000000e-08 3.363572758386e-02 4.750000000000e-08 -2.585786437627e-01 4.775000000000e-08 -2.198912367380e-01 4.800000000000e-08 6.550315845288e-15 4.825000000000e-08 -1.397824734759e-01 4.850000000000e-08 -3.414213562373e-01 4.875000000000e-08 -1.331821362081e-01 4.900000000000e-08 1.042221864367e-14 4.925000000000e-08 -3.993211525331e-01 4.950000000000e-08 -5.414213562373e-01 4.975000000000e-08 3.027339492126e-01 5.000000000000e-08 1.200000000000e+00 5.025000000000e-08 9.054678984252e-01 5.050000000000e-08 -5.857864376268e-02 5.075000000000e-08 -3.496605762666e-01 5.100000000000e-08 -8.146261443187e-15 5.125000000000e-08 3.363572758385e-02 5.150000000000e-08 -2.585786437627e-01 5.175000000000e-08 -2.198912367380e-01 5.200000000000e-08 3.608224830032e-15 5.225000000000e-08 -1.397824734759e-01 5.250000000000e-08 -3.414213562373e-01 5.275000000000e-08 -1.331821362081e-01 5.300000000000e-08 7.688294445529e-15 5.325000000000e-08 -3.993211525331e-01 5.350000000000e-08 -5.414213562373e-01 5.375000000000e-08 3.027339492126e-01 5.400000000000e-08 1.200000000000e+00 5.425000000000e-08 9.054678984252e-01 5.450000000000e-08 -5.857864376270e-02 5.475000000000e-08 -3.496605762665e-01 5.500000000000e-08 -1.121325254871e-14 5.525000000000e-08 3.363572758385e-02 5.550000000000e-08 -2.585786437627e-01 5.575000000000e-08 -2.198912367379e-01 5.600000000000e-08 5.051514762044e-15 5.625000000000e-08 -1.397824734759e-01 5.650000000000e-08 -3.414213562373e-01 5.675000000000e-08 -1.331821362081e-01 5.700000000000e-08 6.411537967210e-15 5.725000000000e-08 -3.993211525331e-01 5.750000000000e-08 -5.414213562373e-01 5.775000000000e-08 3.027339492126e-01 5.800000000000e-08 1.200000000000e+00 5.825000000000e-08 9.054678984252e-01 5.850000000000e-08 -5.857864376269e-02 5.875000000000e-08 -3.496605762665e-01 5.900000000000e-08 2.803313137179e-15 5.925000000000e-08 3.363572758384e-02 5.950000000000e-08 -2.585786437627e-01 5.975000000000e-08 -2.198912367380e-01 6.000000000000e-08 9.214851104389e-15 6.025000000000e-08 -1.397824734759e-01 6.050000000000e-08 -3.414213562373e-01 6.075000000000e-08 -1.331821362081e-01 6.100000000000e-08 5.051514762044e-15 6.125000000000e-08 -3.993211525331e-01 6.150000000000e-08 -5.414213562373e-01 6.175000000000e-08 3.027339492126e-01 6.200000000000e-08 1.200000000000e+00 6.225000000000e-08 9.054678984252e-01 6.250000000000e-08 -5.857864376272e-02 6.275000000000e-08 -3.496605762665e-01 6.300000000000e-08 -2.775557561563e-16 6.325000000000e-08 3.363572758385e-02 6.350000000000e-08 -2.585786437627e-01 6.375000000000e-08 -2.198912367380e-01 6.400000000000e-08 6.272760089132e-15 6.425000000000e-08 -1.397824734759e-01 6.450000000000e-08 -3.414213562373e-01 6.475000000000e-08 -1.331821362081e-01 6.500000000000e-08 1.079691891448e-14 6.525000000000e-08 -3.993211525331e-01 6.550000000000e-08 -5.414213562373e-01 6.575000000000e-08 3.027339492126e-01 6.600000000000e-08 1.200000000000e+00 6.625000000000e-08 9.054678984252e-01 6.650000000000e-08 -5.857864376270e-02 6.675000000000e-08 -3.496605762666e-01 6.700000000000e-08 -1.859623566247e-15 6.725000000000e-08 3.363572758384e-02 6.750000000000e-08 -2.585786437627e-01 6.775000000000e-08 -2.198912367380e-01 6.800000000000e-08 3.441691376338e-15 6.825000000000e-08 -1.397824734759e-01 6.850000000000e-08 -3.414213562373e-01 6.875000000000e-08 -1.331821362081e-01 6.900000000000e-08 -4.163336342344e-16 6.925000000000e-08 -3.993211525331e-01 6.950000000000e-08 -5.414213562373e-01 6.975000000000e-08 3.027339492126e-01 7.000000000000e-08 1.200000000000e+00 7.025000000000e-08 9.054678984251e-01 7.050000000000e-08 -5.857864376269e-02 7.075000000000e-08 -3.496605762665e-01 7.100000000000e-08 -3.511080315377e-15 7.125000000000e-08 3.363572758384e-02 7.150000000000e-08 -2.585786437627e-01 7.175000000000e-08 -2.198912367379e-01 7.200000000000e-08 1.942890293094e-15 7.225000000000e-08 -1.397824734759e-01 7.250000000000e-08 -3.414213562373e-01 7.275000000000e-08 -1.331821362081e-01 7.300000000000e-08 -1.762479051592e-15 7.325000000000e-08 -3.993211525331e-01 7.350000000000e-08 -5.414213562373e-01 7.375000000000e-08 3.027339492126e-01 7.400000000000e-08 1.200000000000e+00 7.425000000000e-08 9.054678984251e-01 7.450000000000e-08 -5.857864376268e-02 7.475000000000e-08 -3.496605762665e-01 7.500000000000e-08 -6.480926906249e-15 7.525000000000e-08 3.363572758385e-02 7.550000000000e-08 -2.585786437627e-01 7.575000000000e-08 -2.198912367379e-01 7.600000000000e-08 4.829470157119e-15 7.625000000000e-08 -1.397824734759e-01 7.650000000000e-08 -3.414213562373e-01 7.675000000000e-08 -1.331821362081e-01 7.700000000000e-08 1.398881011028e-14 7.725000000000e-08 -3.993211525331e-01 7.750000000000e-08 -5.414213562373e-01 7.775000000000e-08 3.027339492126e-01 7.800000000000e-08 1.200000000000e+00 7.825000000000e-08 9.054678984252e-01 7.850000000000e-08 -5.857864376271e-02 7.875000000000e-08 -3.496605762665e-01 7.900000000000e-08 -9.561795799584e-15 7.925000000000e-08 3.363572758385e-02 7.950000000000e-08 -2.585786437627e-01 7.975000000000e-08 -2.198912367380e-01 8.000000000000e-08 1.887379141863e-15 ]
VWL001 (wl001 0) vsource type=pwl wave=[ 0.000000000000e+00 0.000000000000e+00 2.500000000000e-10 -1.801087632620e-01 5.000000000000e-10 2.426406871193e-02 7.500000000000e-10 2.336357275839e-01 1.000000000000e-09 -9.714451465470e-17 1.250000000000e-09 -5.033942373345e-02 1.500000000000e-09 6.242640687119e-01 1.750000000000e-09 1.105467898425e+00 2.000000000000e-09 4.000000000000e-01 2.250000000000e-09 -7.027339492126e-01 2.500000000000e-09 -8.242640687119e-01 2.750000000000e-09 -1.993211525331e-01 3.000000000000e-09 -5.412337245048e-16 3.250000000000e-09 -2.668178637919e-01 3.500000000000e-09 -2.242640687119e-01 3.750000000000e-09 6.021752652407e-02 4.000000000000e-09 -1.193489751472e-15 4.250000000000e-09 -1.801087632620e-01 4.500000000000e-09 2.426406871193e-02 4.750000000000e-09 2.336357275839e-01 5.000000000000e-09 4.024558464266e-16 5.250000000000e-09 -5.033942373345e-02 5.500000000000e-09 6.242640687119e-01 5.750000000000e-09 1.105467898425e+00 6.000000000000e-09 4.000000000000e-01 6.250000000000e-09 -7.027339492126e-01 6.500000000000e-09 -8.242640687119e-01 6.750000000000e-09 -1.993211525331e-01 7.000000000000e-09 -8.743006318923e-16 7.250000000000e-09 -2.668178637919e-01 7.500000000000e-09 -2.242640687119e-01 7.750000000000e-09 6.021752652407e-02 8.000000000000e-09 -2.373101715136e-15 8.250000000000e-09 -1.801087632620e-01 8.500000000000e-09 2.426406871193e-02 8.750000000000e-09 2.336357275839e-01 9.000000000000e-09 -1.013078509970e-15 9.250000000000e-09 -5.033942373345e-02 9.500000000000e-09 6.242640687119e-01 9.750000000000e-09 1.105467898425e+00 1.000000000000e-08 4.000000000000e-01 1.025000000000e-08 -7.027339492126e-01 1.050000000000e-08 -8.242640687119e-01 1.075000000000e-08 -1.993211525331e-01 1.100000000000e-08 -7.632783294298e-16 1.125000000000e-08 -2.668178637919e-01 1.150000000000e-08 -2.242640687119e-01 1.175000000000e-08 6.021752652407e-02 1.200000000000e-08 -4.898859096159e-15 1.225000000000e-08 -1.801087632620e-01 1.250000000000e-08 2.426406871193e-02 1.275000000000e-08 2.336357275839e-01 1.300000000000e-08 -4.163336342344e-17 1.325000000000e-08 -5.033942373345e-02 1.350000000000e-08 6.242640687119e-01 1.375000000000e-08 1.105467898425e+00 1.400000000000e-08 4.000000000000e-01 1.425000000000e-08 -7.027339492126e-01 1.450000000000e-08 -8.242640687119e-01 1.475000000000e-08 -1.993211525331e-01 1.500000000000e-08 -3.191891195797e-15 1.525000000000e-08 -2.668178637919e-01 1.550000000000e-08 -2.242640687119e-01 1.575000000000e-08 6.021752652407e-02 1.600000000000e-08 -4.732325642465e-15 1.625000000000e-08 -1.801087632620e-01 1.650000000000e-08 2.426406871193e-02 1.675000000000e-08 2.336357275839e-01 1.700000000000e-08 1.110223024625e-16 1.725000000000e-08 -5.033942373345e-02 1.750000000000e-08 6.242640687119e-01 1.775000000000e-08 1.105467898425e+00 1.800000000000e-08 4.000000000000e-01 1.825000000000e-08 -7.027339492126e-01 1.850000000000e-08 -8.242640687119e-01 1.875000000000e-08 -1.993211525331e-01 1.900000000000e-08 -1.304512053935e-15 1.925000000000e-08 -2.668178637919e-01 1.950000000000e-08 -2.242640687119e-01 1.975000000000e-08 6.021752652407e-02 2.000000000000e-08 -1.387778780781e-15 2.025000000000e-08 -1.801087632620e-01 2.050000000000e-08 2.426406871193e-02 2.075000000000e-08 2.336357275839e-01 2.100000000000e-08 -4.024558464266e-16 2.125000000000e-08 -5.033942373345e-02 2.150000000000e-08 6.242640687119e-01 2.175000000000e-08 1.105467898425e+00 2.200000000000e-08 4.000000000000e-01 2.225000000000e-08 -7.027339492126e-01 2.250000000000e-08 -8.242640687119e-01 2.275000000000e-08 -1.993211525331e-01 2.300000000000e-08 -2.955968803064e-15 2.325000000000e-08 -2.668178637919e-01 2.350000000000e-08 -2.242640687119e-01 2.375000000000e-08 6.021752652407e-02 2.400000000000e-08 -9.769962616701e-15 2.425000000000e-08 -1.801087632620e-01 2.450000000000e-08 2.426406871193e-02 2.475000000000e-08 2.336357275839e-01 2.500000000000e-08 4.718447854657e-16 2.525000000000e-08 -5.033942373345e-02 2.550000000000e-08 6.242640687119e-01 2.575000000000e-08 1.105467898425e+00 2.600000000000e-08 4.000000000000e-01 2.625000000000e-08 -7.027339492126e-01 2.650000000000e-08 -8.242640687119e-01 2.675000000000e-08 -1.993211525331e-01 2.700000000000e-08 1.346145417358e-15 2.725000000000e-08 -2.668178637919e-01 2.750000000000e-08 -2.242640687119e-01 2.775000000000e-08 6.021752652407e-02 2.800000000000e-08 -7.494005416220e-15 2.825000000000e-08 -1.801087632620e-01 2.850000000000e-08 2.426406871193e-02 2.875000000000e-08 2.336357275839e-01 2.900000000000e-08 1.443289932013e-15 2.925000000000e-08 -5.033942373345e-02 2.950000000000e-08 6.242640687119e-01 2.975000000000e-08 1.105467898425e+00 3.000000000000e-08 4.000000000000e-01 3.025000000000e-08 -7.027339492126e-01 3.050000000000e-08 -8.242640687119e-01 3.075000000000e-08 -1.993211525331e-01 3.100000000000e-08 7.632783294298e-16 3.125000000000e-08 -2.668178637919e-01 3.150000000000e-08 -2.242640687119e-01 3.175000000000e-08 6.021752652407e-02 3.200000000000e-08 -9.478529072737e-15 3.225000000000e-08 -1.801087632620e-01 3.250000000000e-08 2.426406871193e-02 3.275000000000e-08 2.336357275839e-01 3.300000000000e-08 -4.052314039882e-15 3.325000000000e-08 -5.033942373345e-02 3.350000000000e-08 6.242640687119e-01 3.375000000000e-08 1.105467898425e+00 3.400000000000e-08 4.000000000000e-01 3.425000000000e-08 -7.027339492126e-01 3.450000000000e-08 -8.242640687119e-01 3.475000000000e-08 -1.993211525331e-01 3.500000000000e-08 -2.012279232133e-15 3.525000000000e-08 -2.668178637919e-01 3.550000000000e-08 -2.242640687119e-01 3.575000000000e-08 6.021752652407e-02 3.600000000000e-08 -2.942091015257e-15 3.625000000000e-08 -1.801087632620e-01 3.650000000000e-08 2.426406871193e-02 3.675000000000e-08 2.336357275839e-01 3.700000000000e-08 3.233524559221e-15 3.725000000000e-08 -5.033942373346e-02 3.750000000000e-08 6.242640687119e-01 3.775000000000e-08 1.105467898425e+00 3.800000000000e-08 4.000000000000e-01 3.825000000000e-08 -7.027339492126e-01 3.850000000000e-08 -8.242640687119e-01 3.875000000000e-08 -1.993211525331e-01 3.900000000000e-08 -7.591149930875e-15 3.925000000000e-08 -2.668178637919e-01 3.950000000000e-08 -2.242640687119e-01 3.975000000000e-08 6.021752652407e-02 4.000000000000e-08 -2.789435349371e-15 4.025000000000e-08 -1.801087632620e-01 4.050000000000e-08 2.426406871194e-02 4.075000000000e-08 2.336357275839e-01 4.100000000000e-08 -2.275957200482e-15 4.125000000000e-08 -5.033942373345e-02 4.150000000000e-08 6.242640687119e-01 4.175000000000e-08 1.105467898425e+00 4.200000000000e-08 4.000000000000e-01 4.225000000000e-08 -7.027339492126e-01 4.250000000000e-08 -8.242640687119e-01 4.275000000000e-08 -1.993211525331e-01 4.300000000000e-08 1.748601263785e-15 4.325000000000e-08 -2.668178637919e-01 4.350000000000e-08 -2.242640687119e-01 4.375000000000e-08 6.021752652407e-02 4.400000000000e-08 -6.911138328292e-15 4.425000000000e-08 -1.801087632620e-01 4.450000000000e-08 2.426406871193e-02 4.475000000000e-08 2.336357275839e-01 4.500000000000e-08 -7.716050021145e-15 4.525000000000e-08 -5.033942373345e-02 4.550000000000e-08 6.242640687119e-01 4.575000000000e-08 1.105467898425e+00 4.600000000000e-08 4.000000000000e-01 4.625000000000e-08 -7.027339492126e-01 4.650000000000e-08 -8.242640687119e-01 4.675000000000e-08 -1.993211525331e-01 4.700000000000e-08 -9.714451465470e-16 4.725000000000e-08 -2.668178637919e-01 4.750000000000e-08 -2.242640687119e-01 4.775000000000e-08 6.021752652407e-02 4.800000000000e-08 -1.955380302121e-14 4.825000000000e-08 -1.801087632620e-01 4.850000000000e-08 2.426406871194e-02 4.875000000000e-08 2.336357275839e-01 4.900000000000e-08 -4.302114220422e-16 4.925000000000e-08 -5.033942373345e-02 4.950000000000e-08 6.242640687119e-01 4.975000000000e-08 1.105467898425e+00 5.000000000000e-08 4.000000000000e-01 5.025000000000e-08 -7.027339492126e-01 5.050000000000e-08 -8.242640687119e-01 5.075000000000e-08 -1.993211525331e-01 5.100000000000e-08 5.551115123126e-16 5.125000000000e-08 -2.668178637919e-01 5.150000000000e-08 -2.242640687119e-01 5.175000000000e-08 6.021752652407e-02 5.200000000000e-08 -1.088018564133e-14 5.225000000000e-08 -1.801087632620e-01 5.250000000000e-08 2.426406871193e-02 5.275000000000e-08 2.336357275839e-01 5.300000000000e-08 -5.925815393937e-15 5.325000000000e-08 -5.033942373345e-02 5.350000000000e-08 6.242640687119e-01 5.375000000000e-08 1.105467898425e+00 5.400000000000e-08 4.000000000000e-01 5.425000000000e-08 -7.027339492126e-01 5.450000000000e-08 -8.242640687119e-01 5.475000000000e-08 -1.993211525331e-01 5.500000000000e-08 -5.065392549852e-15 5.525000000000e-08 -2.668178637919e-01 5.550000000000e-08 -2.242640687119e-01 5.575000000000e-08 6.021752652407e-02 5.600000000000e-08 -1.498801083244e-14 5.625000000000e-08 -1.801087632620e-01 5.650000000000e-08 2.426406871194e-02 5.675000000000e-08 2.336357275839e-01 5.700000000000e-08 -1.457167719821e-15 5.725000000000e-08 -5.033942373345e-02 5.750000000000e-08 6.242640687119e-01 5.775000000000e-08 1.105467898425e+00 5.800000000000e-08 4.000000000000e-01 5.825000000000e-08 -7.027339492126e-01 5.850000000000e-08 -8.242640687119e-01 5.875000000000e-08 -1.993211525331e-01 5.900000000000e-08 -4.968248035198e-15 5.925000000000e-08 -2.668178637919e-01 5.950000000000e-08 -2.242640687119e-01 5.975000000000e-08 6.021752652407e-02 6.000000000000e-08 -2.765843110097e-14 6.025000000000e-08 -1.801087632620e-01 6.050000000000e-08 2.426406871195e-02 6.075000000000e-08 2.336357275839e-01 6.100000000000e-08 2.942091015257e-15 6.125000000000e-08 -5.033942373345e-02 6.150000000000e-08 6.242640687119e-01 6.175000000000e-08 1.105467898425e+00 6.200000000000e-08 4.000000000000e-01 6.225000000000e-08 -7.027339492126e-01 6.250000000000e-08 -8.242640687119e-01 6.275000000000e-08 -1.993211525331e-01 6.300000000000e-08 -1.051936315832e-14 6.325000000000e-08 -2.668178637919e-01 6.350000000000e-08 -2.242640687119e-01 6.375000000000e-08 6.021752652407e-02 6.400000000000e-08 -1.897093593328e-14 6.425000000000e-08 -1.801087632620e-01 6.450000000000e-08 2.426406871195e-02 6.475000000000e-08 2.336357275839e-01 6.500000000000e-08 3.330669073875e-16 6.525000000000e-08 -5.033942373345e-02 6.550000000000e-08 6.242640687119e-01 6.575000000000e-08 1.105467898425e+00 6.600000000000e-08 4.000000000000e-01 6.625000000000e-08 -7.027339492126e-01 6.650000000000e-08 -8.242640687119e-01 6.675000000000e-08 -1.993211525331e-01 6.700000000000e-08 -6.161737786670e-15 6.725000000000e-08 -2.668178637919e-01 6.750000000000e-08 -2.242640687119e-01 6.775000000000e-08 6.021752652407e-02 6.800000000000e-08 -1.028344076559e-14 6.825000000000e-08 -1.801087632620e-01 6.850000000000e-08 2.426406871194e-02 6.875000000000e-08 2.336357275839e-01 6.900000000000e-08 -7.993605777301e-15 6.925000000000e-08 -5.033942373346e-02 6.950000000000e-08 6.242640687119e-01 6.975000000000e-08 1.105467898425e+00 7.000000000000e-08 4.000000000000e-01 7.025000000000e-08 -7.027339492126e-01 7.050000000000e-08 -8.242640687119e-01 7.075000000000e-08 -1.993211525331e-01 7.100000000000e-08 -1.817990202824e-15 7.125000000000e-08 -2.668178637919e-01 7.150000000000e-08 -2.242640687119e-01 7.175000000000e-08 6.021752652407e-02 7.200000000000e-08 -5.884182030513e-15 7.225000000000e-08 -1.801087632620e-01 7.250000000000e-08 2.426406871194e-02 7.275000000000e-08 2.336357275839e-01 7.300000000000e-08 -3.524958103185e-15 7.325000000000e-08 -5.033942373344e-02 7.350000000000e-08 6.242640687119e-01 7.375000000000e-08 1.105467898425e+00 7.400000000000e-08 4.000000000000e-01 7.425000000000e-08 -7.027339492126e-01 7.450000000000e-08 -8.242640687119e-01 7.475000000000e-08 -1.993211525331e-01 7.500000000000e-08 -7.369105325949e-15 7.525000000000e-08 -2.668178637919e-01 7.550000000000e-08 -2.242640687119e-01 7.575000000000e-08 6.021752652407e-02 7.600000000000e-08 -1.426636586643e-14 7.625000000000e-08 -1.801087632620e-01 7.650000000000e-08 2.426406871193e-02 7.675000000000e-08 2.336357275839e-01 7.700000000000e-08 6.647460359943e-15 7.725000000000e-08 -5.033942373345e-02 7.750000000000e-08 6.242640687119e-01 7.775000000000e-08 1.105467898425e+00 7.800000000000e-08 4.000000000000e-01 7.825000000000e-08 -7.027339492126e-01 7.850000000000e-08 -8.242640687119e-01 7.875000000000e-08 -1.993211525331e-01 7.900000000000e-08 -1.297573160031e-14 7.925000000000e-08 -2.668178637919e-01 7.950000000000e-08 -2.242640687119e-01 7.975000000000e-08 6.021752652407e-02 8.000000000000e-08 -5.578870698741e-15 ]
VWL002 (wl002 0) vsource type=pwl wave=[ 0.000000000000e+00 0.000000000000e+00 2.500000000000e-10 1.397824734759e-01 5.000000000000e-10 3.414213562373e-01 7.500000000000e-10 1.331821362081e-01 1.000000000000e-09 -9.714451465470e-17 1.250000000000e-09 3.993211525331e-01 1.500000000000e-09 5.414213562373e-01 1.750000000000e-09 -3.027339492126e-01 2.000000000000e-09 -1.200000000000e+00 2.250000000000e-09 -9.054678984252e-01 2.500000000000e-09 5.857864376269e-02 2.750000000000e-09 3.496605762665e-01 3.000000000000e-09 2.636779683485e-16 3.250000000000e-09 -3.363572758386e-02 3.500000000000e-09 2.585786437627e-01 3.750000000000e-09 2.198912367380e-01 4.000000000000e-09 -3.885780586188e-16 4.250000000000e-09 1.397824734759e-01 4.500000000000e-09 3.414213562373e-01 4.750000000000e-09 1.331821362081e-01 5.000000000000e-09 -6.522560269673e-16 5.250000000000e-09 3.993211525331e-01 5.500000000000e-09 5.414213562373e-01 5.750000000000e-09 -3.027339492126e-01 6.000000000000e-09 -1.200000000000e+00 6.250000000000e-09 -9.054678984252e-01 6.500000000000e-09 5.857864376269e-02 6.750000000000e-09 3.496605762665e-01 7.000000000000e-09 -2.775557561563e-17 7.250000000000e-09 -3.363572758386e-02 7.500000000000e-09 2.585786437627e-01 7.750000000000e-09 2.198912367380e-01 8.000000000000e-09 -8.326672684689e-16 8.250000000000e-09 1.397824734759e-01 8.500000000000e-09 3.414213562373e-01 8.750000000000e-09 1.331821362081e-01 9.000000000000e-09 4.579669976579e-16 9.250000000000e-09 3.993211525331e-01 9.500000000000e-09 5.414213562373e-01 9.750000000000e-09 -3.027339492126e-01 1.000000000000e-08 -1.200000000000e+00 1.025000000000e-08 -9.054678984252e-01 1.050000000000e-08 5.857864376269e-02 1.075000000000e-08 3.496605762665e-01 1.100000000000e-08 1.804112415016e-16 1.125000000000e-08 -3.363572758386e-02 1.150000000000e-08 2.585786437627e-01 1.175000000000e-08 2.198912367380e-01 1.200000000000e-08 -1.609823385706e-15 1.225000000000e-08 1.397824734759e-01 1.250000000000e-08 3.414213562373e-01 1.275000000000e-08 1.331821362081e-01 1.300000000000e-08 -1.706967900361e-15 1.325000000000e-08 3.993211525331e-01 1.350000000000e-08 5.414213562373e-01 1.375000000000e-08 -3.027339492126e-01 1.400000000000e-08 -1.200000000000e+00 1.425000000000e-08 -9.054678984252e-01 1.450000000000e-08 5.857864376269e-02 1.475000000000e-08 3.496605762665e-01 1.500000000000e-08 7.216449660064e-16 1.525000000000e-08 -3.363572758386e-02 1.550000000000e-08 2.585786437627e-01 1.575000000000e-08 2.198912367380e-01 1.600000000000e-08 -1.554312234475e-15 1.625000000000e-08 1.397824734759e-01 1.650000000000e-08 3.414213562373e-01 1.675000000000e-08 1.331821362081e-01 1.700000000000e-08 -1.804112415016e-15 1.725000000000e-08 3.993211525331e-01 1.750000000000e-08 5.414213562373e-01 1.775000000000e-08 -3.027339492126e-01 1.800000000000e-08 -1.200000000000e+00 1.825000000000e-08 -9.054678984252e-01 1.850000000000e-08 5.857864376269e-02 1.875000000000e-08 3.496605762665e-01 1.900000000000e-08 2.720046410332e-15 1.925000000000e-08 -3.363572758386e-02 1.950000000000e-08 2.585786437627e-01 1.975000000000e-08 2.198912367380e-01 2.000000000000e-08 -4.440892098501e-16 2.025000000000e-08 1.397824734759e-01 2.050000000000e-08 3.414213562373e-01 2.075000000000e-08 1.331821362081e-01 2.100000000000e-08 1.804112415016e-16 2.125000000000e-08 3.993211525331e-01 2.150000000000e-08 5.414213562373e-01 2.175000000000e-08 -3.027339492126e-01 2.200000000000e-08 -1.200000000000e+00 2.225000000000e-08 -9.054678984252e-01 2.250000000000e-08 5.857864376270e-02 2.275000000000e-08 3.496605762665e-01 2.300000000000e-08 1.137978600241e-15 2.325000000000e-08 -3.363572758386e-02 2.350000000000e-08 2.585786437627e-01 2.375000000000e-08 2.198912367380e-01 2.400000000000e-08 -3.275157922644e-15 2.425000000000e-08 1.397824734759e-01 2.450000000000e-08 3.414213562373e-01 2.475000000000e-08 1.331821362081e-01 2.500000000000e-08 -2.040034807749e-15 2.525000000000e-08 3.993211525331e-01 2.550000000000e-08 5.414213562373e-01 2.575000000000e-08 -3.027339492126e-01 2.600000000000e-08 -1.200000000000e+00 2.625000000000e-08 -9.054678984252e-01 2.650000000000e-08 5.857864376270e-02 2.675000000000e-08 3.496605762665e-01 2.700000000000e-08 2.775557561563e-15 2.725000000000e-08 -3.363572758386e-02 2.750000000000e-08 2.585786437627e-01 2.775000000000e-08 2.198912367380e-01 2.800000000000e-08 -2.442490654175e-15 2.825000000000e-08 1.397824734759e-01 2.850000000000e-08 3.414213562373e-01 2.875000000000e-08 1.331821362081e-01 2.900000000000e-08 -4.260480856999e-15 2.925000000000e-08 3.993211525331e-01 2.950000000000e-08 5.414213562373e-01 2.975000000000e-08 -3.027339492126e-01 3.000000000000e-08 -1.200000000000e+00 3.025000000000e-08 -9.054678984252e-01 3.050000000000e-08 5.857864376269e-02 3.075000000000e-08 3.496605762665e-01 3.100000000000e-08 5.065392549852e-15 3.125000000000e-08 -3.363572758385e-02 3.150000000000e-08 2.585786437627e-01 3.175000000000e-08 2.198912367380e-01 3.200000000000e-08 -3.219646771413e-15 3.225000000000e-08 1.397824734759e-01 3.250000000000e-08 3.414213562373e-01 3.275000000000e-08 1.331821362081e-01 3.300000000000e-08 -1.471045507628e-15 3.325000000000e-08 3.993211525331e-01 3.350000000000e-08 5.414213562373e-01 3.375000000000e-08 -3.027339492126e-01 3.400000000000e-08 -1.200000000000e+00 3.425000000000e-08 -9.054678984252e-01 3.450000000000e-08 5.857864376270e-02 3.475000000000e-08 3.496605762665e-01 3.500000000000e-08 -4.440892098501e-16 3.525000000000e-08 -3.363572758385e-02 3.550000000000e-08 2.585786437627e-01 3.575000000000e-08 2.198912367380e-01 3.600000000000e-08 -9.992007221626e-16 3.625000000000e-08 1.397824734759e-01 3.650000000000e-08 3.414213562373e-01 3.675000000000e-08 1.331821362081e-01 3.700000000000e-08 -8.701372955500e-15 3.725000000000e-08 3.993211525331e-01 3.750000000000e-08 5.414213562373e-01 3.775000000000e-08 -3.027339492126e-01 3.800000000000e-08 -1.200000000000e+00 3.825000000000e-08 -9.054678984252e-01 3.850000000000e-08 5.857864376268e-02 3.875000000000e-08 3.496605762666e-01 3.900000000000e-08 2.622901895677e-15 3.925000000000e-08 -3.363572758385e-02 3.950000000000e-08 2.585786437627e-01 3.975000000000e-08 2.198912367380e-01 4.000000000000e-08 -8.881784197001e-16 4.025000000000e-08 1.397824734759e-01 4.050000000000e-08 3.414213562373e-01 4.075000000000e-08 1.331821362081e-01 4.100000000000e-08 -5.981326545168e-15 4.125000000000e-08 3.993211525331e-01 4.150000000000e-08 5.414213562373e-01 4.175000000000e-08 -3.027339492126e-01 4.200000000000e-08 -1.200000000000e+00 4.225000000000e-08 -9.054678984252e-01 4.250000000000e-08 5.857864376269e-02 4.275000000000e-08 3.496605762666e-01 4.300000000000e-08 3.538835890993e-15 4.325000000000e-08 -3.363572758386e-02 4.350000000000e-08 2.585786437627e-01 4.375000000000e-08 2.198912367380e-01 4.400000000000e-08 -2.331468351713e-15 4.425000000000e-08 1.397824734759e-01 4.450000000000e-08 3.414213562373e-01 4.475000000000e-08 1.331821362081e-01 4.500000000000e-08 -3.191891195797e-15 4.525000000000e-08 3.993211525331e-01 4.550000000000e-08 5.414213562373e-01 4.575000000000e-08 -3.027339492126e-01 4.600000000000e-08 -1.200000000000e+00 4.625000000000e-08 -9.054678984252e-01 4.650000000000e-08 5.857864376270e-02 4.675000000000e-08 3.496605762665e-01 4.700000000000e-08 -1.970645868710e-15 4.725000000000e-08 -3.363572758386e-02 4.750000000000e-08 2.585786437627e-01 4.775000000000e-08 2.198912367380e-01 4.800000000000e-08 -6.550315845288e-15 4.825000000000e-08 1.397824734759e-01 4.850000000000e-08 3.414213562373e-01 4.875000000000e-08 1.331821362081e-01 4.900000000000e-08 -1.042221864367e-14 4.925000000000e-08 3.993211525331e-01 4.950000000000e-08 5.414213562373e-01 4.975000000000e-08 -3.027339492126e-01 5.000000000000e-08 -1.200000000000e+00 5.025000000000e-08 -9.054678984252e-01 5.050000000000e-08 5.857864376268e-02 5.075000000000e-08 3.496605762666e-01 5.100000000000e-08 8.146261443187e-15 5.125000000000e-08 -3.363572758385e-02 5.150000000000e-08 2.585786437627e-01 5.175000000000e-08 2.198912367380e-01 5.200000000000e-08 -3.608224830032e-15 5.225000000000e-08 1.397824734759e-01 5.250000000000e-08 3.414213562373e-01 5.275000000000e-08 1.331821362081e-01 5.300000000000e-08 -7.688294445529e-15 5.325000000000e-08 3.993211525331e-01 5.350000000000e-08 5.414213562373e-01 5.375000000000e-08 -3.027339492126e-01 5.400000000000e-08 -1.200000000000e+00 5.425000000000e-08 -9.054678984252e-01 5.450000000000e-08 5.857864376270e-02 5.475000000000e-08 3.496605762665e-01 5.500000000000e-08 1.121325254871e-14 5.525000000000e-08 -3.363572758385e-02 5.550000000000e-08 2.585786437627e-01 5.575000000000e-08 2.198912367379e-01 5.600000000000e-08 -5.051514762044e-15 5.625000000000e-08 1.397824734759e-01 5.650000000000e-08 3.414213562373e-01 5.675000000000e-08 1.331821362081e-01 5.700000000000e-08 -6.411537967210e-15 5.725000000000e-08 3.993211525331e-01 5.750000000000e-08 5.414213562373e-01 5.775000000000e-08 -3.027339492126e-01 5.800000000000e-08 -1.200000000000e+00 5.825000000000e-08 -9.054678984252e-01 5.850000000000e-08 5.857864376269e-02 5.875000000000e-08 3.496605762665e-01 5.900000000000e-08 -2.803313137179e-15 5.925000000000e-08 -3.363572758384e-02 5.950000000000e-08 2.585786437627e-01 5.975000000000e-08 2.198912367380e-01 6.000000000000e-08 -9.214851104389e-15 6.025000000000e-08 1.397824734759e-01 6.050000000000e-08 3.414213562373e-01 6.075000000000e-08 1.331821362081e-01 6.100000000000e-08 -5.051514762044e-15 6.125000000000e-08 3.993211525331e-01 6.150000000000e-08 5.414213562373e-01 6.175000000000e-08 -3.027339492126e-01 6.200000000000e-08 -1.200000000000e+00 6.225000000000e-08 -9.054678984252e-01 6.250000000000e-08 5.857864376272e-02 6.275000000000e-08 3.496605762665e-01 6.300000000000e-08 2.775557561563e-16 6.325000000000e-08 -3.363572758385e-02 6.350000000000e-08 2.585786437627e-01 6.375000000000e-08 2.198912367380e-01 6.400000000000e-08 -6.272760089132e-15 6.425000000000e-08 1.397824734759e-01 6.450000000000e-08 3.414213562373e-01 6.475000000000e-08 1.331821362081e-01 6.500000000000e-08 -1.079691891448e-14 6.525000000000e-08 3.993211525331e-01 6.550000000000e-08 5.414213562373e-01 6.575000000000e-08 -3.027339492126e-01 6.600000000000e-08 -1.200000000000e+00 6.625000000000e-08 -9.054678984252e-01 6.650000000000e-08 5.857864376270e-02 6.675000000000e-08 3.496605762666e-01 6.700000000000e-08 1.859623566247e-15 6.725000000000e-08 -3.363572758384e-02 6.750000000000e-08 2.585786437627e-01 6.775000000000e-08 2.198912367380e-01 6.800000000000e-08 -3.441691376338e-15 6.825000000000e-08 1.397824734759e-01 6.850000000000e-08 3.414213562373e-01 6.875000000000e-08 1.331821362081e-01 6.900000000000e-08 4.163336342344e-16 6.925000000000e-08 3.993211525331e-01 6.950000000000e-08 5.414213562373e-01 6.975000000000e-08 -3.027339492126e-01 7.000000000000e-08 -1.200000000000e+00 7.025000000000e-08 -9.054678984251e-01 7.050000000000e-08 5.857864376269e-02 7.075000000000e-08 3.496605762665e-01 7.100000000000e-08 3.511080315377e-15 7.125000000000e-08 -3.363572758384e-02 7.150000000000e-08 2.585786437627e-01 7.175000000000e-08 2.198912367379e-01 7.200000000000e-08 -1.942890293094e-15 7.225000000000e-08 1.397824734759e-01 7.250000000000e-08 3.414213562373e-01 7.275000000000e-08 1.331821362081e-01 7.300000000000e-08 1.762479051592e-15 7.325000000000e-08 3.993211525331e-01 7.350000000000e-08 5.414213562373e-01 7.375000000000e-08 -3.027339492126e-01 7.400000000000e-08 -1.200000000000e+00 7.425000000000e-08 -9.054678984251e-01 7.450000000000e-08 5.857864376268e-02 7.475000000000e-08 3.496605762665e-01 7.500000000000e-08 6.480926906249e-15 7.525000000000e-08 -3.363572758385e-02 7.550000000000e-08 2.585786437627e-01 7.575000000000e-08 2.198912367379e-01 7.600000000000e-08 -4.829470157119e-15 7.625000000000e-08 1.397824734759e-01 7.650000000000e-08 3.414213562373e-01 7.675000000000e-08 1.331821362081e-01 7.700000000000e-08 -1.398881011028e-14 7.725000000000e-08 3.993211525331e-01 7.750000000000e-08 5.414213562373e-01 7.775000000000e-08 -3.027339492126e-01 7.800000000000e-08 -1.200000000000e+00 7.825000000000e-08 -9.054678984252e-01 7.850000000000e-08 5.857864376271e-02 7.875000000000e-08 3.496605762665e-01 7.900000000000e-08 9.561795799584e-15 7.925000000000e-08 -3.363572758385e-02 7.950000000000e-08 2.585786437627e-01 7.975000000000e-08 2.198912367380e-01 8.000000000000e-08 -1.887379141863e-15 ]
VWL003 (wl003 0) vsource type=pwl wave=[ 0.000000000000e+00 0.000000000000e+00 2.500000000000e-10 1.801087632620e-01 5.000000000000e-10 -2.426406871193e-02 7.500000000000e-10 -2.336357275839e-01 1.000000000000e-09 9.714451465470e-17 1.250000000000e-09 5.033942373345e-02 1.500000000000e-09 -6.242640687119e-01 1.750000000000e-09 -1.105467898425e+00 2.000000000000e-09 -4.000000000000e-01 2.250000000000e-09 7.027339492126e-01 2.500000000000e-09 8.242640687119e-01 2.750000000000e-09 1.993211525331e-01 3.000000000000e-09 5.412337245048e-16 3.250000000000e-09 2.668178637919e-01 3.500000000000e-09 2.242640687119e-01 3.750000000000e-09 -6.021752652407e-02 4.000000000000e-09 1.193489751472e-15 4.250000000000e-09 1.801087632620e-01 4.500000000000e-09 -2.426406871193e-02 4.750000000000e-09 -2.336357275839e-01 5.000000000000e-09 -4.024558464266e-16 5.250000000000e-09 5.033942373345e-02 5.500000000000e-09 -6.242640687119e-01 5.750000000000e-09 -1.105467898425e+00 6.000000000000e-09 -4.000000000000e-01 6.250000000000e-09 7.027339492126e-01 6.500000000000e-09 8.242640687119e-01 6.750000000000e-09 1.993211525331e-01 7.000000000000e-09 8.743006318923e-16 7.250000000000e-09 2.668178637919e-01 7.500000000000e-09 2.242640687119e-01 7.750000000000e-09 -6.021752652407e-02 8.000000000000e-09 2.373101715136e-15 8.250000000000e-09 1.801087632620e-01 8.500000000000e-09 -2.426406871193e-02 8.750000000000e-09 -2.336357275839e-01 9.000000000000e-09 1.013078509970e-15 9.250000000000e-09 5.033942373345e-02 9.500000000000e-09 -6.242640687119e-01 9.750000000000e-09 -1.105467898425e+00 1.000000000000e-08 -4.000000000000e-01 1.025000000000e-08 7.027339492126e-01 1.050000000000e-08 8.242640687119e-01 1.075000000000e-08 1.993211525331e-01 1.100000000000e-08 7.632783294298e-16 1.125000000000e-08 2.668178637919e-01 1.150000000000e-08 2.242640687119e-01 1.175000000000e-08 -6.021752652407e-02 1.200000000000e-08 4.898859096159e-15 1.225000000000e-08 1.801087632620e-01 1.250000000000e-08 -2.426406871193e-02 1.275000000000e-08 -2.336357275839e-01 1.300000000000e-08 4.163336342344e-17 1.325000000000e-08 5.033942373345e-02 1.350000000000e-08 -6.242640687119e-01 1.375000000000e-08 -1.105467898425e+00 1.400000000000e-08 -4.000000000000e-01 1.425000000000e-08 7.027339492126e-01 1.450000000000e-08 8.242640687119e-01 1.475000000000e-08 1.993211525331e-01 1.500000000000e-08 3.191891195797e-15 1.525000000000e-08 2.668178637919e-01 1.550000000000e-08 2.242640687119e-01 1.575000000000e-08 -6.021752652407e-02 1.600000000000e-08 4.732325642465e-15 1.625000000000e-08 1.801087632620e-01 1.650000000000e-08 -2.426406871193e-02 1.675000000000e-08 -2.336357275839e-01 1.700000000000e-08 -1.110223024625e-16 1.725000000000e-08 5.033942373345e-02 1.750000000000e-08 -6.242640687119e-01 1.775000000000e-08 -1.105467898425e+00 1.800000000000e-08 -4.000000000000e-01 1.825000000000e-08 7.027339492126e-01 1.850000000000e-08 8.242640687119e-01 1.875000000000e-08 1.993211525331e-01 1.900000000000e-08 1.304512053935e-15 1.925000000000e-08 2.668178637919e-01 1.950000000000e-08 2.242640687119e-01 1.975000000000e-08 -6.021752652407e-02 2.000000000000e-08 1.387778780781e-15 2.025000000000e-08 1.801087632620e-01 2.050000000000e-08 -2.426406871193e-02 2.075000000000e-08 -2.336357275839e-01 2.100000000000e-08 4.024558464266e-16 2.125000000000e-08 5.033942373345e-02 2.150000000000e-08 -6.242640687119e-01 2.175000000000e-08 -1.105467898425e+00 2.200000000000e-08 -4.000000000000e-01 2.225000000000e-08 7.027339492126e-01 2.250000000000e-08 8.242640687119e-01 2.275000000000e-08 1.993211525331e-01 2.300000000000e-08 2.955968803064e-15 2.325000000000e-08 2.668178637919e-01 2.350000000000e-08 2.242640687119e-01 2.375000000000e-08 -6.021752652407e-02 2.400000000000e-08 9.769962616701e-15 2.425000000000e-08 1.801087632620e-01 2.450000000000e-08 -2.426406871193e-02 2.475000000000e-08 -2.336357275839e-01 2.500000000000e-08 -4.718447854657e-16 2.525000000000e-08 5.033942373345e-02 2.550000000000e-08 -6.242640687119e-01 2.575000000000e-08 -1.105467898425e+00 2.600000000000e-08 -4.000000000000e-01 2.625000000000e-08 7.027339492126e-01 2.650000000000e-08 8.242640687119e-01 2.675000000000e-08 1.993211525331e-01 2.700000000000e-08 -1.346145417358e-15 2.725000000000e-08 2.668178637919e-01 2.750000000000e-08 2.242640687119e-01 2.775000000000e-08 -6.021752652407e-02 2.800000000000e-08 7.494005416220e-15 2.825000000000e-08 1.801087632620e-01 2.850000000000e-08 -2.426406871193e-02 2.875000000000e-08 -2.336357275839e-01 2.900000000000e-08 -1.443289932013e-15 2.925000000000e-08 5.033942373345e-02 2.950000000000e-08 -6.242640687119e-01 2.975000000000e-08 -1.105467898425e+00 3.000000000000e-08 -4.000000000000e-01 3.025000000000e-08 7.027339492126e-01 3.050000000000e-08 8.242640687119e-01 3.075000000000e-08 1.993211525331e-01 3.100000000000e-08 -7.632783294298e-16 3.125000000000e-08 2.668178637919e-01 3.150000000000e-08 2.242640687119e-01 3.175000000000e-08 -6.021752652407e-02 3.200000000000e-08 9.478529072737e-15 3.225000000000e-08 1.801087632620e-01 3.250000000000e-08 -2.426406871193e-02 3.275000000000e-08 -2.336357275839e-01 3.300000000000e-08 4.052314039882e-15 3.325000000000e-08 5.033942373345e-02 3.350000000000e-08 -6.242640687119e-01 3.375000000000e-08 -1.105467898425e+00 3.400000000000e-08 -4.000000000000e-01 3.425000000000e-08 7.027339492126e-01 3.450000000000e-08 8.242640687119e-01 3.475000000000e-08 1.993211525331e-01 3.500000000000e-08 2.012279232133e-15 3.525000000000e-08 2.668178637919e-01 3.550000000000e-08 2.242640687119e-01 3.575000000000e-08 -6.021752652407e-02 3.600000000000e-08 2.942091015257e-15 3.625000000000e-08 1.801087632620e-01 3.650000000000e-08 -2.426406871193e-02 3.675000000000e-08 -2.336357275839e-01 3.700000000000e-08 -3.233524559221e-15 3.725000000000e-08 5.033942373346e-02 3.750000000000e-08 -6.242640687119e-01 3.775000000000e-08 -1.105467898425e+00 3.800000000000e-08 -4.000000000000e-01 3.825000000000e-08 7.027339492126e-01 3.850000000000e-08 8.242640687119e-01 3.875000000000e-08 1.993211525331e-01 3.900000000000e-08 7.591149930875e-15 3.925000000000e-08 2.668178637919e-01 3.950000000000e-08 2.242640687119e-01 3.975000000000e-08 -6.021752652407e-02 4.000000000000e-08 2.789435349371e-15 4.025000000000e-08 1.801087632620e-01 4.050000000000e-08 -2.426406871194e-02 4.075000000000e-08 -2.336357275839e-01 4.100000000000e-08 2.275957200482e-15 4.125000000000e-08 5.033942373345e-02 4.150000000000e-08 -6.242640687119e-01 4.175000000000e-08 -1.105467898425e+00 4.200000000000e-08 -4.000000000000e-01 4.225000000000e-08 7.027339492126e-01 4.250000000000e-08 8.242640687119e-01 4.275000000000e-08 1.993211525331e-01 4.300000000000e-08 -1.748601263785e-15 4.325000000000e-08 2.668178637919e-01 4.350000000000e-08 2.242640687119e-01 4.375000000000e-08 -6.021752652407e-02 4.400000000000e-08 6.911138328292e-15 4.425000000000e-08 1.801087632620e-01 4.450000000000e-08 -2.426406871193e-02 4.475000000000e-08 -2.336357275839e-01 4.500000000000e-08 7.716050021145e-15 4.525000000000e-08 5.033942373345e-02 4.550000000000e-08 -6.242640687119e-01 4.575000000000e-08 -1.105467898425e+00 4.600000000000e-08 -4.000000000000e-01 4.625000000000e-08 7.027339492126e-01 4.650000000000e-08 8.242640687119e-01 4.675000000000e-08 1.993211525331e-01 4.700000000000e-08 9.714451465470e-16 4.725000000000e-08 2.668178637919e-01 4.750000000000e-08 2.242640687119e-01 4.775000000000e-08 -6.021752652407e-02 4.800000000000e-08 1.955380302121e-14 4.825000000000e-08 1.801087632620e-01 4.850000000000e-08 -2.426406871194e-02 4.875000000000e-08 -2.336357275839e-01 4.900000000000e-08 4.302114220422e-16 4.925000000000e-08 5.033942373345e-02 4.950000000000e-08 -6.242640687119e-01 4.975000000000e-08 -1.105467898425e+00 5.000000000000e-08 -4.000000000000e-01 5.025000000000e-08 7.027339492126e-01 5.050000000000e-08 8.242640687119e-01 5.075000000000e-08 1.993211525331e-01 5.100000000000e-08 -5.551115123126e-16 5.125000000000e-08 2.668178637919e-01 5.150000000000e-08 2.242640687119e-01 5.175000000000e-08 -6.021752652407e-02 5.200000000000e-08 1.088018564133e-14 5.225000000000e-08 1.801087632620e-01 5.250000000000e-08 -2.426406871193e-02 5.275000000000e-08 -2.336357275839e-01 5.300000000000e-08 5.925815393937e-15 5.325000000000e-08 5.033942373345e-02 5.350000000000e-08 -6.242640687119e-01 5.375000000000e-08 -1.105467898425e+00 5.400000000000e-08 -4.000000000000e-01 5.425000000000e-08 7.027339492126e-01 5.450000000000e-08 8.242640687119e-01 5.475000000000e-08 1.993211525331e-01 5.500000000000e-08 5.065392549852e-15 5.525000000000e-08 2.668178637919e-01 5.550000000000e-08 2.242640687119e-01 5.575000000000e-08 -6.021752652407e-02 5.600000000000e-08 1.498801083244e-14 5.625000000000e-08 1.801087632620e-01 5.650000000000e-08 -2.426406871194e-02 5.675000000000e-08 -2.336357275839e-01 5.700000000000e-08 1.457167719821e-15 5.725000000000e-08 5.033942373345e-02 5.750000000000e-08 -6.242640687119e-01 5.775000000000e-08 -1.105467898425e+00 5.800000000000e-08 -4.000000000000e-01 5.825000000000e-08 7.027339492126e-01 5.850000000000e-08 8.242640687119e-01 5.875000000000e-08 1.993211525331e-01 5.900000000000e-08 4.968248035198e-15 5.925000000000e-08 2.668178637919e-01 5.950000000000e-08 2.242640687119e-01 5.975000000000e-08 -6.021752652407e-02 6.000000000000e-08 2.765843110097e-14 6.025000000000e-08 1.801087632620e-01 6.050000000000e-08 -2.426406871195e-02 6.075000000000e-08 -2.336357275839e-01 6.100000000000e-08 -2.942091015257e-15 6.125000000000e-08 5.033942373345e-02 6.150000000000e-08 -6.242640687119e-01 6.175000000000e-08 -1.105467898425e+00 6.200000000000e-08 -4.000000000000e-01 6.225000000000e-08 7.027339492126e-01 6.250000000000e-08 8.242640687119e-01 6.275000000000e-08 1.993211525331e-01 6.300000000000e-08 1.051936315832e-14 6.325000000000e-08 2.668178637919e-01 6.350000000000e-08 2.242640687119e-01 6.375000000000e-08 -6.021752652407e-02 6.400000000000e-08 1.897093593328e-14 6.425000000000e-08 1.801087632620e-01 6.450000000000e-08 -2.426406871195e-02 6.475000000000e-08 -2.336357275839e-01 6.500000000000e-08 -3.330669073875e-16 6.525000000000e-08 5.033942373345e-02 6.550000000000e-08 -6.242640687119e-01 6.575000000000e-08 -1.105467898425e+00 6.600000000000e-08 -4.000000000000e-01 6.625000000000e-08 7.027339492126e-01 6.650000000000e-08 8.242640687119e-01 6.675000000000e-08 1.993211525331e-01 6.700000000000e-08 6.161737786670e-15 6.725000000000e-08 2.668178637919e-01 6.750000000000e-08 2.242640687119e-01 6.775000000000e-08 -6.021752652407e-02 6.800000000000e-08 1.028344076559e-14 6.825000000000e-08 1.801087632620e-01 6.850000000000e-08 -2.426406871194e-02 6.875000000000e-08 -2.336357275839e-01 6.900000000000e-08 7.993605777301e-15 6.925000000000e-08 5.033942373346e-02 6.950000000000e-08 -6.242640687119e-01 6.975000000000e-08 -1.105467898425e+00 7.000000000000e-08 -4.000000000000e-01 7.025000000000e-08 7.027339492126e-01 7.050000000000e-08 8.242640687119e-01 7.075000000000e-08 1.993211525331e-01 7.100000000000e-08 1.817990202824e-15 7.125000000000e-08 2.668178637919e-01 7.150000000000e-08 2.242640687119e-01 7.175000000000e-08 -6.021752652407e-02 7.200000000000e-08 5.884182030513e-15 7.225000000000e-08 1.801087632620e-01 7.250000000000e-08 -2.426406871194e-02 7.275000000000e-08 -2.336357275839e-01 7.300000000000e-08 3.524958103185e-15 7.325000000000e-08 5.033942373344e-02 7.350000000000e-08 -6.242640687119e-01 7.375000000000e-08 -1.105467898425e+00 7.400000000000e-08 -4.000000000000e-01 7.425000000000e-08 7.027339492126e-01 7.450000000000e-08 8.242640687119e-01 7.475000000000e-08 1.993211525331e-01 7.500000000000e-08 7.369105325949e-15 7.525000000000e-08 2.668178637919e-01 7.550000000000e-08 2.242640687119e-01 7.575000000000e-08 -6.021752652407e-02 7.600000000000e-08 1.426636586643e-14 7.625000000000e-08 1.801087632620e-01 7.650000000000e-08 -2.426406871193e-02 7.675000000000e-08 -2.336357275839e-01 7.700000000000e-08 -6.647460359943e-15 7.725000000000e-08 5.033942373345e-02 7.750000000000e-08 -6.242640687119e-01 7.775000000000e-08 -1.105467898425e+00 7.800000000000e-08 -4.000000000000e-01 7.825000000000e-08 7.027339492126e-01 7.850000000000e-08 8.242640687119e-01 7.875000000000e-08 1.993211525331e-01 7.900000000000e-08 1.297573160031e-14 7.925000000000e-08 2.668178637919e-01 7.950000000000e-08 2.242640687119e-01 7.975000000000e-08 -6.021752652407e-02 8.000000000000e-08 5.578870698741e-15 ]
VWL004 (wl004 0) vsource type=pwl wave=[ 0.000000000000e+00 0.000000000000e+00 2.500000000000e-10 -1.397824734759e-01 5.000000000000e-10 -3.414213562373e-01 7.500000000000e-10 -1.331821362081e-01 1.000000000000e-09 9.714451465470e-17 1.250000000000e-09 -3.993211525331e-01 1.500000000000e-09 -5.414213562373e-01 1.750000000000e-09 3.027339492126e-01 2.000000000000e-09 1.200000000000e+00 2.250000000000e-09 9.054678984252e-01 2.500000000000e-09 -5.857864376269e-02 2.750000000000e-09 -3.496605762665e-01 3.000000000000e-09 -2.636779683485e-16 3.250000000000e-09 3.363572758386e-02 3.500000000000e-09 -2.585786437627e-01 3.750000000000e-09 -2.198912367380e-01 4.000000000000e-09 3.885780586188e-16 4.250000000000e-09 -1.397824734759e-01 4.500000000000e-09 -3.414213562373e-01 4.750000000000e-09 -1.331821362081e-01 5.000000000000e-09 6.522560269673e-16 5.250000000000e-09 -3.993211525331e-01 5.500000000000e-09 -5.414213562373e-01 5.750000000000e-09 3.027339492126e-01 6.000000000000e-09 1.200000000000e+00 6.250000000000e-09 9.054678984252e-01 6.500000000000e-09 -5.857864376269e-02 6.750000000000e-09 -3.496605762665e-01 7.000000000000e-09 2.775557561563e-17 7.250000000000e-09 3.363572758386e-02 7.500000000000e-09 -2.585786437627e-01 7.750000000000e-09 -2.198912367380e-01 8.000000000000e-09 8.326672684689e-16 8.250000000000e-09 -1.397824734759e-01 8.500000000000e-09 -3.414213562373e-01 8.750000000000e-09 -1.331821362081e-01 9.000000000000e-09 -4.579669976579e-16 9.250000000000e-09 -3.993211525331e-01 9.500000000000e-09 -5.414213562373e-01 9.750000000000e-09 3.027339492126e-01 1.000000000000e-08 1.200000000000e+00 1.025000000000e-08 9.054678984252e-01 1.050000000000e-08 -5.857864376269e-02 1.075000000000e-08 -3.496605762665e-01 1.100000000000e-08 -1.804112415016e-16 1.125000000000e-08 3.363572758386e-02 1.150000000000e-08 -2.585786437627e-01 1.175000000000e-08 -2.198912367380e-01 1.200000000000e-08 1.609823385706e-15 1.225000000000e-08 -1.397824734759e-01 1.250000000000e-08 -3.414213562373e-01 1.275000000000e-08 -1.331821362081e-01 1.300000000000e-08 1.706967900361e-15 1.325000000000e-08 -3.993211525331e-01 1.350000000000e-08 -5.414213562373e-01 1.375000000000e-08 3.027339492126e-01 1.400000000000e-08 1.200000000000e+00 1.425000000000e-08 9.054678984252e-01 1.450000000000e-08 -5.857864376269e-02 1.475000000000e-08 -3.496605762665e-01 1.500000000000e-08 -7.216449660064e-16 1.525000000000e-08 3.363572758386e-02 1.550000000000e-08 -2.585786437627e-01 1.575000000000e-08 -2.198912367380e-01 1.600000000000e-08 1.554312234475e-15 1.625000000000e-08 -1.397824734759e-01 1.650000000000e-08 -3.414213562373e-01 1.675000000000e-08 -1.331821362081e-01 1.700000000000e-08 1.804112415016e-15 1.725000000000e-08 -3.993211525331e-01 1.750000000000e-08 -5.414213562373e-01 1.775000000000e-08 3.027339492126e-01 1.800000000000e-08 1.200000000000e+00 1.825000000000e-08 9.054678984252e-01 1.850000000000e-08 -5.857864376269e-02 1.875000000000e-08 -3.496605762665e-01 1.900000000000e-08 -2.720046410332e-15 1.925000000000e-08 3.363572758386e-02 1.950000000000e-08 -2.585786437627e-01 1.975000000000e-08 -2.198912367380e-01 2.000000000000e-08 4.440892098501e-16 2.025000000000e-08 -1.397824734759e-01 2.050000000000e-08 -3.414213562373e-01 2.075000000000e-08 -1.331821362081e-01 2.100000000000e-08 -1.804112415016e-16 2.125000000000e-08 -3.993211525331e-01 2.150000000000e-08 -5.414213562373e-01 2.175000000000e-08 3.027339492126e-01 2.200000000000e-08 1.200000000000e+00 2.225000000000e-08 9.054678984252e-01 2.250000000000e-08 -5.857864376270e-02 2.275000000000e-08 -3.496605762665e-01 2.300000000000e-08 -1.137978600241e-15 2.325000000000e-08 3.363572758386e-02 2.350000000000e-08 -2.585786437627e-01 2.375000000000e-08 -2.198912367380e-01 2.400000000000e-08 3.275157922644e-15 2.425000000000e-08 -1.397824734759e-01 2.450000000000e-08 -3.414213562373e-01 2.475000000000e-08 -1.331821362081e-01 2.500000000000e-08 2.040034807749e-15 2.525000000000e-08 -3.993211525331e-01 2.550000000000e-08 -5.414213562373e-01 2.575000000000e-08 3.027339492126e-01 2.600000000000e-08 1.200000000000e+00 2.625000000000e-08 9.054678984252e-01 2.650000000000e-08 -5.857864376270e-02 2.675000000000e-08 -3.496605762665e-01 2.700000000000e-08 -2.775557561563e-15 2.725000000000e-08 3.363572758386e-02 2.750000000000e-08 -2.585786437627e-01 2.775000000000e-08 -2.198912367380e-01 2.800000000000e-08 2.442490654175e-15 2.825000000000e-08 -1.397824734759e-01 2.850000000000e-08 -3.414213562373e-01 2.875000000000e-08 -1.331821362081e-01 2.900000000000e-08 4.260480856999e-15 2.925000000000e-08 -3.993211525331e-01 2.950000000000e-08 -5.414213562373e-01 2.975000000000e-08 3.027339492126e-01 3.000000000000e-08 1.200000000000e+00 3.025000000000e-08 9.054678984252e-01 3.050000000000e-08 -5.857864376269e-02 3.075000000000e-08 -3.496605762665e-01 3.100000000000e-08 -5.065392549852e-15 3.125000000000e-08 3.363572758385e-02 3.150000000000e-08 -2.585786437627e-01 3.175000000000e-08 -2.198912367380e-01 3.200000000000e-08 3.219646771413e-15 3.225000000000e-08 -1.397824734759e-01 3.250000000000e-08 -3.414213562373e-01 3.275000000000e-08 -1.331821362081e-01 3.300000000000e-08 1.471045507628e-15 3.325000000000e-08 -3.993211525331e-01 3.350000000000e-08 -5.414213562373e-01 3.375000000000e-08 3.027339492126e-01 3.400000000000e-08 1.200000000000e+00 3.425000000000e-08 9.054678984252e-01 3.450000000000e-08 -5.857864376270e-02 3.475000000000e-08 -3.496605762665e-01 3.500000000000e-08 4.440892098501e-16 3.525000000000e-08 3.363572758385e-02 3.550000000000e-08 -2.585786437627e-01 3.575000000000e-08 -2.198912367380e-01 3.600000000000e-08 9.992007221626e-16 3.625000000000e-08 -1.397824734759e-01 3.650000000000e-08 -3.414213562373e-01 3.675000000000e-08 -1.331821362081e-01 3.700000000000e-08 8.701372955500e-15 3.725000000000e-08 -3.993211525331e-01 3.750000000000e-08 -5.414213562373e-01 3.775000000000e-08 3.027339492126e-01 3.800000000000e-08 1.200000000000e+00 3.825000000000e-08 9.054678984252e-01 3.850000000000e-08 -5.857864376268e-02 3.875000000000e-08 -3.496605762666e-01 3.900000000000e-08 -2.622901895677e-15 3.925000000000e-08 3.363572758385e-02 3.950000000000e-08 -2.585786437627e-01 3.975000000000e-08 -2.198912367380e-01 4.000000000000e-08 8.881784197001e-16 4.025000000000e-08 -1.397824734759e-01 4.050000000000e-08 -3.414213562373e-01 4.075000000000e-08 -1.331821362081e-01 4.100000000000e-08 5.981326545168e-15 4.125000000000e-08 -3.993211525331e-01 4.150000000000e-08 -5.414213562373e-01 4.175000000000e-08 3.027339492126e-01 4.200000000000e-08 1.200000000000e+00 4.225000000000e-08 9.054678984252e-01 4.250000000000e-08 -5.857864376269e-02 4.275000000000e-08 -3.496605762666e-01 4.300000000000e-08 -3.538835890993e-15 4.325000000000e-08 3.363572758386e-02 4.350000000000e-08 -2.585786437627e-01 4.375000000000e-08 -2.198912367380e-01 4.400000000000e-08 2.331468351713e-15 4.425000000000e-08 -1.397824734759e-01 4.450000000000e-08 -3.414213562373e-01 4.475000000000e-08 -1.331821362081e-01 4.500000000000e-08 3.191891195797e-15 4.525000000000e-08 -3.993211525331e-01 4.550000000000e-08 -5.414213562373e-01 4.575000000000e-08 3.027339492126e-01 4.600000000000e-08 1.200000000000e+00 4.625000000000e-08 9.054678984252e-01 4.650000000000e-08 -5.857864376270e-02 4.675000000000e-08 -3.496605762665e-01 4.700000000000e-08 1.970645868710e-15 4.725000000000e-08 3.363572758386e-02 4.750000000000e-08 -2.585786437627e-01 4.775000000000e-08 -2.198912367380e-01 4.800000000000e-08 6.550315845288e-15 4.825000000000e-08 -1.397824734759e-01 4.850000000000e-08 -3.414213562373e-01 4.875000000000e-08 -1.331821362081e-01 4.900000000000e-08 1.042221864367e-14 4.925000000000e-08 -3.993211525331e-01 4.950000000000e-08 -5.414213562373e-01 4.975000000000e-08 3.027339492126e-01 5.000000000000e-08 1.200000000000e+00 5.025000000000e-08 9.054678984252e-01 5.050000000000e-08 -5.857864376268e-02 5.075000000000e-08 -3.496605762666e-01 5.100000000000e-08 -8.146261443187e-15 5.125000000000e-08 3.363572758385e-02 5.150000000000e-08 -2.585786437627e-01 5.175000000000e-08 -2.198912367380e-01 5.200000000000e-08 3.608224830032e-15 5.225000000000e-08 -1.397824734759e-01 5.250000000000e-08 -3.414213562373e-01 5.275000000000e-08 -1.331821362081e-01 5.300000000000e-08 7.688294445529e-15 5.325000000000e-08 -3.993211525331e-01 5.350000000000e-08 -5.414213562373e-01 5.375000000000e-08 3.027339492126e-01 5.400000000000e-08 1.200000000000e+00 5.425000000000e-08 9.054678984252e-01 5.450000000000e-08 -5.857864376270e-02 5.475000000000e-08 -3.496605762665e-01 5.500000000000e-08 -1.121325254871e-14 5.525000000000e-08 3.363572758385e-02 5.550000000000e-08 -2.585786437627e-01 5.575000000000e-08 -2.198912367379e-01 5.600000000000e-08 5.051514762044e-15 5.625000000000e-08 -1.397824734759e-01 5.650000000000e-08 -3.414213562373e-01 5.675000000000e-08 -1.331821362081e-01 5.700000000000e-08 6.411537967210e-15 5.725000000000e-08 -3.993211525331e-01 5.750000000000e-08 -5.414213562373e-01 5.775000000000e-08 3.027339492126e-01 5.800000000000e-08 1.200000000000e+00 5.825000000000e-08 9.054678984252e-01 5.850000000000e-08 -5.857864376269e-02 5.875000000000e-08 -3.496605762665e-01 5.900000000000e-08 2.803313137179e-15 5.925000000000e-08 3.363572758384e-02 5.950000000000e-08 -2.585786437627e-01 5.975000000000e-08 -2.198912367380e-01 6.000000000000e-08 9.214851104389e-15 6.025000000000e-08 -1.397824734759e-01 6.050000000000e-08 -3.414213562373e-01 6.075000000000e-08 -1.331821362081e-01 6.100000000000e-08 5.051514762044e-15 6.125000000000e-08 -3.993211525331e-01 6.150000000000e-08 -5.414213562373e-01 6.175000000000e-08 3.027339492126e-01 6.200000000000e-08 1.200000000000e+00 6.225000000000e-08 9.054678984252e-01 6.250000000000e-08 -5.857864376272e-02 6.275000000000e-08 -3.496605762665e-01 6.300000000000e-08 -2.775557561563e-16 6.325000000000e-08 3.363572758385e-02 6.350000000000e-08 -2.585786437627e-01 6.375000000000e-08 -2.198912367380e-01 6.400000000000e-08 6.272760089132e-15 6.425000000000e-08 -1.397824734759e-01 6.450000000000e-08 -3.414213562373e-01 6.475000000000e-08 -1.331821362081e-01 6.500000000000e-08 1.079691891448e-14 6.525000000000e-08 -3.993211525331e-01 6.550000000000e-08 -5.414213562373e-01 6.575000000000e-08 3.027339492126e-01 6.600000000000e-08 1.200000000000e+00 6.625000000000e-08 9.054678984252e-01 6.650000000000e-08 -5.857864376270e-02 6.675000000000e-08 -3.496605762666e-01 6.700000000000e-08 -1.859623566247e-15 6.725000000000e-08 3.363572758384e-02 6.750000000000e-08 -2.585786437627e-01 6.775000000000e-08 -2.198912367380e-01 6.800000000000e-08 3.441691376338e-15 6.825000000000e-08 -1.397824734759e-01 6.850000000000e-08 -3.414213562373e-01 6.875000000000e-08 -1.331821362081e-01 6.900000000000e-08 -4.163336342344e-16 6.925000000000e-08 -3.993211525331e-01 6.950000000000e-08 -5.414213562373e-01 6.975000000000e-08 3.027339492126e-01 7.000000000000e-08 1.200000000000e+00 7.025000000000e-08 9.054678984251e-01 7.050000000000e-08 -5.857864376269e-02 7.075000000000e-08 -3.496605762665e-01 7.100000000000e-08 -3.511080315377e-15 7.125000000000e-08 3.363572758384e-02 7.150000000000e-08 -2.585786437627e-01 7.175000000000e-08 -2.198912367379e-01 7.200000000000e-08 1.942890293094e-15 7.225000000000e-08 -1.397824734759e-01 7.250000000000e-08 -3.414213562373e-01 7.275000000000e-08 -1.331821362081e-01 7.300000000000e-08 -1.762479051592e-15 7.325000000000e-08 -3.993211525331e-01 7.350000000000e-08 -5.414213562373e-01 7.375000000000e-08 3.027339492126e-01 7.400000000000e-08 1.200000000000e+00 7.425000000000e-08 9.054678984251e-01 7.450000000000e-08 -5.857864376268e-02 7.475000000000e-08 -3.496605762665e-01 7.500000000000e-08 -6.480926906249e-15 7.525000000000e-08 3.363572758385e-02 7.550000000000e-08 -2.585786437627e-01 7.575000000000e-08 -2.198912367379e-01 7.600000000000e-08 4.829470157119e-15 7.625000000000e-08 -1.397824734759e-01 7.650000000000e-08 -3.414213562373e-01 7.675000000000e-08 -1.331821362081e-01 7.700000000000e-08 1.398881011028e-14 7.725000000000e-08 -3.993211525331e-01 7.750000000000e-08 -5.414213562373e-01 7.775000000000e-08 3.027339492126e-01 7.800000000000e-08 1.200000000000e+00 7.825000000000e-08 9.054678984252e-01 7.850000000000e-08 -5.857864376271e-02 7.875000000000e-08 -3.496605762665e-01 7.900000000000e-08 -9.561795799584e-15 7.925000000000e-08 3.363572758385e-02 7.950000000000e-08 -2.585786437627e-01 7.975000000000e-08 -2.198912367380e-01 8.000000000000e-08 1.887379141863e-15 ]
VWL005 (wl005 0) vsource type=pwl wave=[ 0.000000000000e+00 0.000000000000e+00 2.500000000000e-10 -1.801087632620e-01 5.000000000000e-10 2.426406871193e-02 7.500000000000e-10 2.336357275839e-01 1.000000000000e-09 -9.714451465470e-17 1.250000000000e-09 -5.033942373345e-02 1.500000000000e-09 6.242640687119e-01 1.750000000000e-09 1.105467898425e+00 2.000000000000e-09 4.000000000000e-01 2.250000000000e-09 -7.027339492126e-01 2.500000000000e-09 -8.242640687119e-01 2.750000000000e-09 -1.993211525331e-01 3.000000000000e-09 -5.412337245048e-16 3.250000000000e-09 -2.668178637919e-01 3.500000000000e-09 -2.242640687119e-01 3.750000000000e-09 6.021752652407e-02 4.000000000000e-09 -1.193489751472e-15 4.250000000000e-09 -1.801087632620e-01 4.500000000000e-09 2.426406871193e-02 4.750000000000e-09 2.336357275839e-01 5.000000000000e-09 4.024558464266e-16 5.250000000000e-09 -5.033942373345e-02 5.500000000000e-09 6.242640687119e-01 5.750000000000e-09 1.105467898425e+00 6.000000000000e-09 4.000000000000e-01 6.250000000000e-09 -7.027339492126e-01 6.500000000000e-09 -8.242640687119e-01 6.750000000000e-09 -1.993211525331e-01 7.000000000000e-09 -8.743006318923e-16 7.250000000000e-09 -2.668178637919e-01 7.500000000000e-09 -2.242640687119e-01 7.750000000000e-09 6.021752652407e-02 8.000000000000e-09 -2.373101715136e-15 8.250000000000e-09 -1.801087632620e-01 8.500000000000e-09 2.426406871193e-02 8.750000000000e-09 2.336357275839e-01 9.000000000000e-09 -1.013078509970e-15 9.250000000000e-09 -5.033942373345e-02 9.500000000000e-09 6.242640687119e-01 9.750000000000e-09 1.105467898425e+00 1.000000000000e-08 4.000000000000e-01 1.025000000000e-08 -7.027339492126e-01 1.050000000000e-08 -8.242640687119e-01 1.075000000000e-08 -1.993211525331e-01 1.100000000000e-08 -7.632783294298e-16 1.125000000000e-08 -2.668178637919e-01 1.150000000000e-08 -2.242640687119e-01 1.175000000000e-08 6.021752652407e-02 1.200000000000e-08 -4.898859096159e-15 1.225000000000e-08 -1.801087632620e-01 1.250000000000e-08 2.426406871193e-02 1.275000000000e-08 2.336357275839e-01 1.300000000000e-08 -4.163336342344e-17 1.325000000000e-08 -5.033942373345e-02 1.350000000000e-08 6.242640687119e-01 1.375000000000e-08 1.105467898425e+00 1.400000000000e-08 4.000000000000e-01 1.425000000000e-08 -7.027339492126e-01 1.450000000000e-08 -8.242640687119e-01 1.475000000000e-08 -1.993211525331e-01 1.500000000000e-08 -3.191891195797e-15 1.525000000000e-08 -2.668178637919e-01 1.550000000000e-08 -2.242640687119e-01 1.575000000000e-08 6.021752652407e-02 1.600000000000e-08 -4.732325642465e-15 1.625000000000e-08 -1.801087632620e-01 1.650000000000e-08 2.426406871193e-02 1.675000000000e-08 2.336357275839e-01 1.700000000000e-08 1.110223024625e-16 1.725000000000e-08 -5.033942373345e-02 1.750000000000e-08 6.242640687119e-01 1.775000000000e-08 1.105467898425e+00 1.800000000000e-08 4.000000000000e-01 1.825000000000e-08 -7.027339492126e-01 1.850000000000e-08 -8.242640687119e-01 1.875000000000e-08 -1.993211525331e-01 1.900000000000e-08 -1.304512053935e-15 1.925000000000e-08 -2.668178637919e-01 1.950000000000e-08 -2.242640687119e-01 1.975000000000e-08 6.021752652407e-02 2.000000000000e-08 -1.387778780781e-15 2.025000000000e-08 -1.801087632620e-01 2.050000000000e-08 2.426406871193e-02 2.075000000000e-08 2.336357275839e-01 2.100000000000e-08 -4.024558464266e-16 2.125000000000e-08 -5.033942373345e-02 2.150000000000e-08 6.242640687119e-01 2.175000000000e-08 1.105467898425e+00 2.200000000000e-08 4.000000000000e-01 2.225000000000e-08 -7.027339492126e-01 2.250000000000e-08 -8.242640687119e-01 2.275000000000e-08 -1.993211525331e-01 2.300000000000e-08 -2.955968803064e-15 2.325000000000e-08 -2.668178637919e-01 2.350000000000e-08 -2.242640687119e-01 2.375000000000e-08 6.021752652407e-02 2.400000000000e-08 -9.769962616701e-15 2.425000000000e-08 -1.801087632620e-01 2.450000000000e-08 2.426406871193e-02 2.475000000000e-08 2.336357275839e-01 2.500000000000e-08 4.718447854657e-16 2.525000000000e-08 -5.033942373345e-02 2.550000000000e-08 6.242640687119e-01 2.575000000000e-08 1.105467898425e+00 2.600000000000e-08 4.000000000000e-01 2.625000000000e-08 -7.027339492126e-01 2.650000000000e-08 -8.242640687119e-01 2.675000000000e-08 -1.993211525331e-01 2.700000000000e-08 1.346145417358e-15 2.725000000000e-08 -2.668178637919e-01 2.750000000000e-08 -2.242640687119e-01 2.775000000000e-08 6.021752652407e-02 2.800000000000e-08 -7.494005416220e-15 2.825000000000e-08 -1.801087632620e-01 2.850000000000e-08 2.426406871193e-02 2.875000000000e-08 2.336357275839e-01 2.900000000000e-08 1.443289932013e-15 2.925000000000e-08 -5.033942373345e-02 2.950000000000e-08 6.242640687119e-01 2.975000000000e-08 1.105467898425e+00 3.000000000000e-08 4.000000000000e-01 3.025000000000e-08 -7.027339492126e-01 3.050000000000e-08 -8.242640687119e-01 3.075000000000e-08 -1.993211525331e-01 3.100000000000e-08 7.632783294298e-16 3.125000000000e-08 -2.668178637919e-01 3.150000000000e-08 -2.242640687119e-01 3.175000000000e-08 6.021752652407e-02 3.200000000000e-08 -9.478529072737e-15 3.225000000000e-08 -1.801087632620e-01 3.250000000000e-08 2.426406871193e-02 3.275000000000e-08 2.336357275839e-01 3.300000000000e-08 -4.052314039882e-15 3.325000000000e-08 -5.033942373345e-02 3.350000000000e-08 6.242640687119e-01 3.375000000000e-08 1.105467898425e+00 3.400000000000e-08 4.000000000000e-01 3.425000000000e-08 -7.027339492126e-01 3.450000000000e-08 -8.242640687119e-01 3.475000000000e-08 -1.993211525331e-01 3.500000000000e-08 -2.012279232133e-15 3.525000000000e-08 -2.668178637919e-01 3.550000000000e-08 -2.242640687119e-01 3.575000000000e-08 6.021752652407e-02 3.600000000000e-08 -2.942091015257e-15 3.625000000000e-08 -1.801087632620e-01 3.650000000000e-08 2.426406871193e-02 3.675000000000e-08 2.336357275839e-01 3.700000000000e-08 3.233524559221e-15 3.725000000000e-08 -5.033942373346e-02 3.750000000000e-08 6.242640687119e-01 3.775000000000e-08 1.105467898425e+00 3.800000000000e-08 4.000000000000e-01 3.825000000000e-08 -7.027339492126e-01 3.850000000000e-08 -8.242640687119e-01 3.875000000000e-08 -1.993211525331e-01 3.900000000000e-08 -7.591149930875e-15 3.925000000000e-08 -2.668178637919e-01 3.950000000000e-08 -2.242640687119e-01 3.975000000000e-08 6.021752652407e-02 4.000000000000e-08 -2.789435349371e-15 4.025000000000e-08 -1.801087632620e-01 4.050000000000e-08 2.426406871194e-02 4.075000000000e-08 2.336357275839e-01 4.100000000000e-08 -2.275957200482e-15 4.125000000000e-08 -5.033942373345e-02 4.150000000000e-08 6.242640687119e-01 4.175000000000e-08 1.105467898425e+00 4.200000000000e-08 4.000000000000e-01 4.225000000000e-08 -7.027339492126e-01 4.250000000000e-08 -8.242640687119e-01 4.275000000000e-08 -1.993211525331e-01 4.300000000000e-08 1.748601263785e-15 4.325000000000e-08 -2.668178637919e-01 4.350000000000e-08 -2.242640687119e-01 4.375000000000e-08 6.021752652407e-02 4.400000000000e-08 -6.911138328292e-15 4.425000000000e-08 -1.801087632620e-01 4.450000000000e-08 2.426406871193e-02 4.475000000000e-08 2.336357275839e-01 4.500000000000e-08 -7.716050021145e-15 4.525000000000e-08 -5.033942373345e-02 4.550000000000e-08 6.242640687119e-01 4.575000000000e-08 1.105467898425e+00 4.600000000000e-08 4.000000000000e-01 4.625000000000e-08 -7.027339492126e-01 4.650000000000e-08 -8.242640687119e-01 4.675000000000e-08 -1.993211525331e-01 4.700000000000e-08 -9.714451465470e-16 4.725000000000e-08 -2.668178637919e-01 4.750000000000e-08 -2.242640687119e-01 4.775000000000e-08 6.021752652407e-02 4.800000000000e-08 -1.955380302121e-14 4.825000000000e-08 -1.801087632620e-01 4.850000000000e-08 2.426406871194e-02 4.875000000000e-08 2.336357275839e-01 4.900000000000e-08 -4.302114220422e-16 4.925000000000e-08 -5.033942373345e-02 4.950000000000e-08 6.242640687119e-01 4.975000000000e-08 1.105467898425e+00 5.000000000000e-08 4.000000000000e-01 5.025000000000e-08 -7.027339492126e-01 5.050000000000e-08 -8.242640687119e-01 5.075000000000e-08 -1.993211525331e-01 5.100000000000e-08 5.551115123126e-16 5.125000000000e-08 -2.668178637919e-01 5.150000000000e-08 -2.242640687119e-01 5.175000000000e-08 6.021752652407e-02 5.200000000000e-08 -1.088018564133e-14 5.225000000000e-08 -1.801087632620e-01 5.250000000000e-08 2.426406871193e-02 5.275000000000e-08 2.336357275839e-01 5.300000000000e-08 -5.925815393937e-15 5.325000000000e-08 -5.033942373345e-02 5.350000000000e-08 6.242640687119e-01 5.375000000000e-08 1.105467898425e+00 5.400000000000e-08 4.000000000000e-01 5.425000000000e-08 -7.027339492126e-01 5.450000000000e-08 -8.242640687119e-01 5.475000000000e-08 -1.993211525331e-01 5.500000000000e-08 -5.065392549852e-15 5.525000000000e-08 -2.668178637919e-01 5.550000000000e-08 -2.242640687119e-01 5.575000000000e-08 6.021752652407e-02 5.600000000000e-08 -1.498801083244e-14 5.625000000000e-08 -1.801087632620e-01 5.650000000000e-08 2.426406871194e-02 5.675000000000e-08 2.336357275839e-01 5.700000000000e-08 -1.457167719821e-15 5.725000000000e-08 -5.033942373345e-02 5.750000000000e-08 6.242640687119e-01 5.775000000000e-08 1.105467898425e+00 5.800000000000e-08 4.000000000000e-01 5.825000000000e-08 -7.027339492126e-01 5.850000000000e-08 -8.242640687119e-01 5.875000000000e-08 -1.993211525331e-01 5.900000000000e-08 -4.968248035198e-15 5.925000000000e-08 -2.668178637919e-01 5.950000000000e-08 -2.242640687119e-01 5.975000000000e-08 6.021752652407e-02 6.000000000000e-08 -2.765843110097e-14 6.025000000000e-08 -1.801087632620e-01 6.050000000000e-08 2.426406871195e-02 6.075000000000e-08 2.336357275839e-01 6.100000000000e-08 2.942091015257e-15 6.125000000000e-08 -5.033942373345e-02 6.150000000000e-08 6.242640687119e-01 6.175000000000e-08 1.105467898425e+00 6.200000000000e-08 4.000000000000e-01 6.225000000000e-08 -7.027339492126e-01 6.250000000000e-08 -8.242640687119e-01 6.275000000000e-08 -1.993211525331e-01 6.300000000000e-08 -1.051936315832e-14 6.325000000000e-08 -2.668178637919e-01 6.350000000000e-08 -2.242640687119e-01 6.375000000000e-08 6.021752652407e-02 6.400000000000e-08 -1.897093593328e-14 6.425000000000e-08 -1.801087632620e-01 6.450000000000e-08 2.426406871195e-02 6.475000000000e-08 2.336357275839e-01 6.500000000000e-08 3.330669073875e-16 6.525000000000e-08 -5.033942373345e-02 6.550000000000e-08 6.242640687119e-01 6.575000000000e-08 1.105467898425e+00 6.600000000000e-08 4.000000000000e-01 6.625000000000e-08 -7.027339492126e-01 6.650000000000e-08 -8.242640687119e-01 6.675000000000e-08 -1.993211525331e-01 6.700000000000e-08 -6.161737786670e-15 6.725000000000e-08 -2.668178637919e-01 6.750000000000e-08 -2.242640687119e-01 6.775000000000e-08 6.021752652407e-02 6.800000000000e-08 -1.028344076559e-14 6.825000000000e-08 -1.801087632620e-01 6.850000000000e-08 2.426406871194e-02 6.875000000000e-08 2.336357275839e-01 6.900000000000e-08 -7.993605777301e-15 6.925000000000e-08 -5.033942373346e-02 6.950000000000e-08 6.242640687119e-01 6.975000000000e-08 1.105467898425e+00 7.000000000000e-08 4.000000000000e-01 7.025000000000e-08 -7.027339492126e-01 7.050000000000e-08 -8.242640687119e-01 7.075000000000e-08 -1.993211525331e-01 7.100000000000e-08 -1.817990202824e-15 7.125000000000e-08 -2.668178637919e-01 7.150000000000e-08 -2.242640687119e-01 7.175000000000e-08 6.021752652407e-02 7.200000000000e-08 -5.884182030513e-15 7.225000000000e-08 -1.801087632620e-01 7.250000000000e-08 2.426406871194e-02 7.275000000000e-08 2.336357275839e-01 7.300000000000e-08 -3.524958103185e-15 7.325000000000e-08 -5.033942373344e-02 7.350000000000e-08 6.242640687119e-01 7.375000000000e-08 1.105467898425e+00 7.400000000000e-08 4.000000000000e-01 7.425000000000e-08 -7.027339492126e-01 7.450000000000e-08 -8.242640687119e-01 7.475000000000e-08 -1.993211525331e-01 7.500000000000e-08 -7.369105325949e-15 7.525000000000e-08 -2.668178637919e-01 7.550000000000e-08 -2.242640687119e-01 7.575000000000e-08 6.021752652407e-02 7.600000000000e-08 -1.426636586643e-14 7.625000000000e-08 -1.801087632620e-01 7.650000000000e-08 2.426406871193e-02 7.675000000000e-08 2.336357275839e-01 7.700000000000e-08 6.647460359943e-15 7.725000000000e-08 -5.033942373345e-02 7.750000000000e-08 6.242640687119e-01 7.775000000000e-08 1.105467898425e+00 7.800000000000e-08 4.000000000000e-01 7.825000000000e-08 -7.027339492126e-01 7.850000000000e-08 -8.242640687119e-01 7.875000000000e-08 -1.993211525331e-01 7.900000000000e-08 -1.297573160031e-14 7.925000000000e-08 -2.668178637919e-01 7.950000000000e-08 -2.242640687119e-01 7.975000000000e-08 6.021752652407e-02 8.000000000000e-08 -5.578870698741e-15 ]
VWL006 (wl006 0) vsource type=pwl wave=[ 0.000000000000e+00 0.000000000000e+00 2.500000000000e-10 1.397824734759e-01 5.000000000000e-10 3.414213562373e-01 7.500000000000e-10 1.331821362081e-01 1.000000000000e-09 -9.714451465470e-17 1.250000000000e-09 3.993211525331e-01 1.500000000000e-09 5.414213562373e-01 1.750000000000e-09 -3.027339492126e-01 2.000000000000e-09 -1.200000000000e+00 2.250000000000e-09 -9.054678984252e-01 2.500000000000e-09 5.857864376269e-02 2.750000000000e-09 3.496605762665e-01 3.000000000000e-09 2.636779683485e-16 3.250000000000e-09 -3.363572758386e-02 3.500000000000e-09 2.585786437627e-01 3.750000000000e-09 2.198912367380e-01 4.000000000000e-09 -3.885780586188e-16 4.250000000000e-09 1.397824734759e-01 4.500000000000e-09 3.414213562373e-01 4.750000000000e-09 1.331821362081e-01 5.000000000000e-09 -6.522560269673e-16 5.250000000000e-09 3.993211525331e-01 5.500000000000e-09 5.414213562373e-01 5.750000000000e-09 -3.027339492126e-01 6.000000000000e-09 -1.200000000000e+00 6.250000000000e-09 -9.054678984252e-01 6.500000000000e-09 5.857864376269e-02 6.750000000000e-09 3.496605762665e-01 7.000000000000e-09 -2.775557561563e-17 7.250000000000e-09 -3.363572758386e-02 7.500000000000e-09 2.585786437627e-01 7.750000000000e-09 2.198912367380e-01 8.000000000000e-09 -8.326672684689e-16 8.250000000000e-09 1.397824734759e-01 8.500000000000e-09 3.414213562373e-01 8.750000000000e-09 1.331821362081e-01 9.000000000000e-09 4.579669976579e-16 9.250000000000e-09 3.993211525331e-01 9.500000000000e-09 5.414213562373e-01 9.750000000000e-09 -3.027339492126e-01 1.000000000000e-08 -1.200000000000e+00 1.025000000000e-08 -9.054678984252e-01 1.050000000000e-08 5.857864376269e-02 1.075000000000e-08 3.496605762665e-01 1.100000000000e-08 1.804112415016e-16 1.125000000000e-08 -3.363572758386e-02 1.150000000000e-08 2.585786437627e-01 1.175000000000e-08 2.198912367380e-01 1.200000000000e-08 -1.609823385706e-15 1.225000000000e-08 1.397824734759e-01 1.250000000000e-08 3.414213562373e-01 1.275000000000e-08 1.331821362081e-01 1.300000000000e-08 -1.706967900361e-15 1.325000000000e-08 3.993211525331e-01 1.350000000000e-08 5.414213562373e-01 1.375000000000e-08 -3.027339492126e-01 1.400000000000e-08 -1.200000000000e+00 1.425000000000e-08 -9.054678984252e-01 1.450000000000e-08 5.857864376269e-02 1.475000000000e-08 3.496605762665e-01 1.500000000000e-08 7.216449660064e-16 1.525000000000e-08 -3.363572758386e-02 1.550000000000e-08 2.585786437627e-01 1.575000000000e-08 2.198912367380e-01 1.600000000000e-08 -1.554312234475e-15 1.625000000000e-08 1.397824734759e-01 1.650000000000e-08 3.414213562373e-01 1.675000000000e-08 1.331821362081e-01 1.700000000000e-08 -1.804112415016e-15 1.725000000000e-08 3.993211525331e-01 1.750000000000e-08 5.414213562373e-01 1.775000000000e-08 -3.027339492126e-01 1.800000000000e-08 -1.200000000000e+00 1.825000000000e-08 -9.054678984252e-01 1.850000000000e-08 5.857864376269e-02 1.875000000000e-08 3.496605762665e-01 1.900000000000e-08 2.720046410332e-15 1.925000000000e-08 -3.363572758386e-02 1.950000000000e-08 2.585786437627e-01 1.975000000000e-08 2.198912367380e-01 2.000000000000e-08 -4.440892098501e-16 2.025000000000e-08 1.397824734759e-01 2.050000000000e-08 3.414213562373e-01 2.075000000000e-08 1.331821362081e-01 2.100000000000e-08 1.804112415016e-16 2.125000000000e-08 3.993211525331e-01 2.150000000000e-08 5.414213562373e-01 2.175000000000e-08 -3.027339492126e-01 2.200000000000e-08 -1.200000000000e+00 2.225000000000e-08 -9.054678984252e-01 2.250000000000e-08 5.857864376270e-02 2.275000000000e-08 3.496605762665e-01 2.300000000000e-08 1.137978600241e-15 2.325000000000e-08 -3.363572758386e-02 2.350000000000e-08 2.585786437627e-01 2.375000000000e-08 2.198912367380e-01 2.400000000000e-08 -3.275157922644e-15 2.425000000000e-08 1.397824734759e-01 2.450000000000e-08 3.414213562373e-01 2.475000000000e-08 1.331821362081e-01 2.500000000000e-08 -2.040034807749e-15 2.525000000000e-08 3.993211525331e-01 2.550000000000e-08 5.414213562373e-01 2.575000000000e-08 -3.027339492126e-01 2.600000000000e-08 -1.200000000000e+00 2.625000000000e-08 -9.054678984252e-01 2.650000000000e-08 5.857864376270e-02 2.675000000000e-08 3.496605762665e-01 2.700000000000e-08 2.775557561563e-15 2.725000000000e-08 -3.363572758386e-02 2.750000000000e-08 2.585786437627e-01 2.775000000000e-08 2.198912367380e-01 2.800000000000e-08 -2.442490654175e-15 2.825000000000e-08 1.397824734759e-01 2.850000000000e-08 3.414213562373e-01 2.875000000000e-08 1.331821362081e-01 2.900000000000e-08 -4.260480856999e-15 2.925000000000e-08 3.993211525331e-01 2.950000000000e-08 5.414213562373e-01 2.975000000000e-08 -3.027339492126e-01 3.000000000000e-08 -1.200000000000e+00 3.025000000000e-08 -9.054678984252e-01 3.050000000000e-08 5.857864376269e-02 3.075000000000e-08 3.496605762665e-01 3.100000000000e-08 5.065392549852e-15 3.125000000000e-08 -3.363572758385e-02 3.150000000000e-08 2.585786437627e-01 3.175000000000e-08 2.198912367380e-01 3.200000000000e-08 -3.219646771413e-15 3.225000000000e-08 1.397824734759e-01 3.250000000000e-08 3.414213562373e-01 3.275000000000e-08 1.331821362081e-01 3.300000000000e-08 -1.471045507628e-15 3.325000000000e-08 3.993211525331e-01 3.350000000000e-08 5.414213562373e-01 3.375000000000e-08 -3.027339492126e-01 3.400000000000e-08 -1.200000000000e+00 3.425000000000e-08 -9.054678984252e-01 3.450000000000e-08 5.857864376270e-02 3.475000000000e-08 3.496605762665e-01 3.500000000000e-08 -4.440892098501e-16 3.525000000000e-08 -3.363572758385e-02 3.550000000000e-08 2.585786437627e-01 3.575000000000e-08 2.198912367380e-01 3.600000000000e-08 -9.992007221626e-16 3.625000000000e-08 1.397824734759e-01 3.650000000000e-08 3.414213562373e-01 3.675000000000e-08 1.331821362081e-01 3.700000000000e-08 -8.701372955500e-15 3.725000000000e-08 3.993211525331e-01 3.750000000000e-08 5.414213562373e-01 3.775000000000e-08 -3.027339492126e-01 3.800000000000e-08 -1.200000000000e+00 3.825000000000e-08 -9.054678984252e-01 3.850000000000e-08 5.857864376268e-02 3.875000000000e-08 3.496605762666e-01 3.900000000000e-08 2.622901895677e-15 3.925000000000e-08 -3.363572758385e-02 3.950000000000e-08 2.585786437627e-01 3.975000000000e-08 2.198912367380e-01 4.000000000000e-08 -8.881784197001e-16 4.025000000000e-08 1.397824734759e-01 4.050000000000e-08 3.414213562373e-01 4.075000000000e-08 1.331821362081e-01 4.100000000000e-08 -5.981326545168e-15 4.125000000000e-08 3.993211525331e-01 4.150000000000e-08 5.414213562373e-01 4.175000000000e-08 -3.027339492126e-01 4.200000000000e-08 -1.200000000000e+00 4.225000000000e-08 -9.054678984252e-01 4.250000000000e-08 5.857864376269e-02 4.275000000000e-08 3.496605762666e-01 4.300000000000e-08 3.538835890993e-15 4.325000000000e-08 -3.363572758386e-02 4.350000000000e-08 2.585786437627e-01 4.375000000000e-08 2.198912367380e-01 4.400000000000e-08 -2.331468351713e-15 4.425000000000e-08 1.397824734759e-01 4.450000000000e-08 3.414213562373e-01 4.475000000000e-08 1.331821362081e-01 4.500000000000e-08 -3.191891195797e-15 4.525000000000e-08 3.993211525331e-01 4.550000000000e-08 5.414213562373e-01 4.575000000000e-08 -3.027339492126e-01 4.600000000000e-08 -1.200000000000e+00 4.625000000000e-08 -9.054678984252e-01 4.650000000000e-08 5.857864376270e-02 4.675000000000e-08 3.496605762665e-01 4.700000000000e-08 -1.970645868710e-15 4.725000000000e-08 -3.363572758386e-02 4.750000000000e-08 2.585786437627e-01 4.775000000000e-08 2.198912367380e-01 4.800000000000e-08 -6.550315845288e-15 4.825000000000e-08 1.397824734759e-01 4.850000000000e-08 3.414213562373e-01 4.875000000000e-08 1.331821362081e-01 4.900000000000e-08 -1.042221864367e-14 4.925000000000e-08 3.993211525331e-01 4.950000000000e-08 5.414213562373e-01 4.975000000000e-08 -3.027339492126e-01 5.000000000000e-08 -1.200000000000e+00 5.025000000000e-08 -9.054678984252e-01 5.050000000000e-08 5.857864376268e-02 5.075000000000e-08 3.496605762666e-01 5.100000000000e-08 8.146261443187e-15 5.125000000000e-08 -3.363572758385e-02 5.150000000000e-08 2.585786437627e-01 5.175000000000e-08 2.198912367380e-01 5.200000000000e-08 -3.608224830032e-15 5.225000000000e-08 1.397824734759e-01 5.250000000000e-08 3.414213562373e-01 5.275000000000e-08 1.331821362081e-01 5.300000000000e-08 -7.688294445529e-15 5.325000000000e-08 3.993211525331e-01 5.350000000000e-08 5.414213562373e-01 5.375000000000e-08 -3.027339492126e-01 5.400000000000e-08 -1.200000000000e+00 5.425000000000e-08 -9.054678984252e-01 5.450000000000e-08 5.857864376270e-02 5.475000000000e-08 3.496605762665e-01 5.500000000000e-08 1.121325254871e-14 5.525000000000e-08 -3.363572758385e-02 5.550000000000e-08 2.585786437627e-01 5.575000000000e-08 2.198912367379e-01 5.600000000000e-08 -5.051514762044e-15 5.625000000000e-08 1.397824734759e-01 5.650000000000e-08 3.414213562373e-01 5.675000000000e-08 1.331821362081e-01 5.700000000000e-08 -6.411537967210e-15 5.725000000000e-08 3.993211525331e-01 5.750000000000e-08 5.414213562373e-01 5.775000000000e-08 -3.027339492126e-01 5.800000000000e-08 -1.200000000000e+00 5.825000000000e-08 -9.054678984252e-01 5.850000000000e-08 5.857864376269e-02 5.875000000000e-08 3.496605762665e-01 5.900000000000e-08 -2.803313137179e-15 5.925000000000e-08 -3.363572758384e-02 5.950000000000e-08 2.585786437627e-01 5.975000000000e-08 2.198912367380e-01 6.000000000000e-08 -9.214851104389e-15 6.025000000000e-08 1.397824734759e-01 6.050000000000e-08 3.414213562373e-01 6.075000000000e-08 1.331821362081e-01 6.100000000000e-08 -5.051514762044e-15 6.125000000000e-08 3.993211525331e-01 6.150000000000e-08 5.414213562373e-01 6.175000000000e-08 -3.027339492126e-01 6.200000000000e-08 -1.200000000000e+00 6.225000000000e-08 -9.054678984252e-01 6.250000000000e-08 5.857864376272e-02 6.275000000000e-08 3.496605762665e-01 6.300000000000e-08 2.775557561563e-16 6.325000000000e-08 -3.363572758385e-02 6.350000000000e-08 2.585786437627e-01 6.375000000000e-08 2.198912367380e-01 6.400000000000e-08 -6.272760089132e-15 6.425000000000e-08 1.397824734759e-01 6.450000000000e-08 3.414213562373e-01 6.475000000000e-08 1.331821362081e-01 6.500000000000e-08 -1.079691891448e-14 6.525000000000e-08 3.993211525331e-01 6.550000000000e-08 5.414213562373e-01 6.575000000000e-08 -3.027339492126e-01 6.600000000000e-08 -1.200000000000e+00 6.625000000000e-08 -9.054678984252e-01 6.650000000000e-08 5.857864376270e-02 6.675000000000e-08 3.496605762666e-01 6.700000000000e-08 1.859623566247e-15 6.725000000000e-08 -3.363572758384e-02 6.750000000000e-08 2.585786437627e-01 6.775000000000e-08 2.198912367380e-01 6.800000000000e-08 -3.441691376338e-15 6.825000000000e-08 1.397824734759e-01 6.850000000000e-08 3.414213562373e-01 6.875000000000e-08 1.331821362081e-01 6.900000000000e-08 4.163336342344e-16 6.925000000000e-08 3.993211525331e-01 6.950000000000e-08 5.414213562373e-01 6.975000000000e-08 -3.027339492126e-01 7.000000000000e-08 -1.200000000000e+00 7.025000000000e-08 -9.054678984251e-01 7.050000000000e-08 5.857864376269e-02 7.075000000000e-08 3.496605762665e-01 7.100000000000e-08 3.511080315377e-15 7.125000000000e-08 -3.363572758384e-02 7.150000000000e-08 2.585786437627e-01 7.175000000000e-08 2.198912367379e-01 7.200000000000e-08 -1.942890293094e-15 7.225000000000e-08 1.397824734759e-01 7.250000000000e-08 3.414213562373e-01 7.275000000000e-08 1.331821362081e-01 7.300000000000e-08 1.762479051592e-15 7.325000000000e-08 3.993211525331e-01 7.350000000000e-08 5.414213562373e-01 7.375000000000e-08 -3.027339492126e-01 7.400000000000e-08 -1.200000000000e+00 7.425000000000e-08 -9.054678984251e-01 7.450000000000e-08 5.857864376268e-02 7.475000000000e-08 3.496605762665e-01 7.500000000000e-08 6.480926906249e-15 7.525000000000e-08 -3.363572758385e-02 7.550000000000e-08 2.585786437627e-01 7.575000000000e-08 2.198912367379e-01 7.600000000000e-08 -4.829470157119e-15 7.625000000000e-08 1.397824734759e-01 7.650000000000e-08 3.414213562373e-01 7.675000000000e-08 1.331821362081e-01 7.700000000000e-08 -1.398881011028e-14 7.725000000000e-08 3.993211525331e-01 7.750000000000e-08 5.414213562373e-01 7.775000000000e-08 -3.027339492126e-01 7.800000000000e-08 -1.200000000000e+00 7.825000000000e-08 -9.054678984252e-01 7.850000000000e-08 5.857864376271e-02 7.875000000000e-08 3.496605762665e-01 7.900000000000e-08 9.561795799584e-15 7.925000000000e-08 -3.363572758385e-02 7.950000000000e-08 2.585786437627e-01 7.975000000000e-08 2.198912367380e-01 8.000000000000e-08 -1.887379141863e-15 ]
VWL007 (wl007 0) vsource type=pwl wave=[ 0.000000000000e+00 0.000000000000e+00 2.500000000000e-10 1.801087632620e-01 5.000000000000e-10 -2.426406871193e-02 7.500000000000e-10 -2.336357275839e-01 1.000000000000e-09 9.714451465470e-17 1.250000000000e-09 5.033942373345e-02 1.500000000000e-09 -6.242640687119e-01 1.750000000000e-09 -1.105467898425e+00 2.000000000000e-09 -4.000000000000e-01 2.250000000000e-09 7.027339492126e-01 2.500000000000e-09 8.242640687119e-01 2.750000000000e-09 1.993211525331e-01 3.000000000000e-09 5.412337245048e-16 3.250000000000e-09 2.668178637919e-01 3.500000000000e-09 2.242640687119e-01 3.750000000000e-09 -6.021752652407e-02 4.000000000000e-09 1.193489751472e-15 4.250000000000e-09 1.801087632620e-01 4.500000000000e-09 -2.426406871193e-02 4.750000000000e-09 -2.336357275839e-01 5.000000000000e-09 -4.024558464266e-16 5.250000000000e-09 5.033942373345e-02 5.500000000000e-09 -6.242640687119e-01 5.750000000000e-09 -1.105467898425e+00 6.000000000000e-09 -4.000000000000e-01 6.250000000000e-09 7.027339492126e-01 6.500000000000e-09 8.242640687119e-01 6.750000000000e-09 1.993211525331e-01 7.000000000000e-09 8.743006318923e-16 7.250000000000e-09 2.668178637919e-01 7.500000000000e-09 2.242640687119e-01 7.750000000000e-09 -6.021752652407e-02 8.000000000000e-09 2.373101715136e-15 8.250000000000e-09 1.801087632620e-01 8.500000000000e-09 -2.426406871193e-02 8.750000000000e-09 -2.336357275839e-01 9.000000000000e-09 1.013078509970e-15 9.250000000000e-09 5.033942373345e-02 9.500000000000e-09 -6.242640687119e-01 9.750000000000e-09 -1.105467898425e+00 1.000000000000e-08 -4.000000000000e-01 1.025000000000e-08 7.027339492126e-01 1.050000000000e-08 8.242640687119e-01 1.075000000000e-08 1.993211525331e-01 1.100000000000e-08 7.632783294298e-16 1.125000000000e-08 2.668178637919e-01 1.150000000000e-08 2.242640687119e-01 1.175000000000e-08 -6.021752652407e-02 1.200000000000e-08 4.898859096159e-15 1.225000000000e-08 1.801087632620e-01 1.250000000000e-08 -2.426406871193e-02 1.275000000000e-08 -2.336357275839e-01 1.300000000000e-08 4.163336342344e-17 1.325000000000e-08 5.033942373345e-02 1.350000000000e-08 -6.242640687119e-01 1.375000000000e-08 -1.105467898425e+00 1.400000000000e-08 -4.000000000000e-01 1.425000000000e-08 7.027339492126e-01 1.450000000000e-08 8.242640687119e-01 1.475000000000e-08 1.993211525331e-01 1.500000000000e-08 3.191891195797e-15 1.525000000000e-08 2.668178637919e-01 1.550000000000e-08 2.242640687119e-01 1.575000000000e-08 -6.021752652407e-02 1.600000000000e-08 4.732325642465e-15 1.625000000000e-08 1.801087632620e-01 1.650000000000e-08 -2.426406871193e-02 1.675000000000e-08 -2.336357275839e-01 1.700000000000e-08 -1.110223024625e-16 1.725000000000e-08 5.033942373345e-02 1.750000000000e-08 -6.242640687119e-01 1.775000000000e-08 -1.105467898425e+00 1.800000000000e-08 -4.000000000000e-01 1.825000000000e-08 7.027339492126e-01 1.850000000000e-08 8.242640687119e-01 1.875000000000e-08 1.993211525331e-01 1.900000000000e-08 1.304512053935e-15 1.925000000000e-08 2.668178637919e-01 1.950000000000e-08 2.242640687119e-01 1.975000000000e-08 -6.021752652407e-02 2.000000000000e-08 1.387778780781e-15 2.025000000000e-08 1.801087632620e-01 2.050000000000e-08 -2.426406871193e-02 2.075000000000e-08 -2.336357275839e-01 2.100000000000e-08 4.024558464266e-16 2.125000000000e-08 5.033942373345e-02 2.150000000000e-08 -6.242640687119e-01 2.175000000000e-08 -1.105467898425e+00 2.200000000000e-08 -4.000000000000e-01 2.225000000000e-08 7.027339492126e-01 2.250000000000e-08 8.242640687119e-01 2.275000000000e-08 1.993211525331e-01 2.300000000000e-08 2.955968803064e-15 2.325000000000e-08 2.668178637919e-01 2.350000000000e-08 2.242640687119e-01 2.375000000000e-08 -6.021752652407e-02 2.400000000000e-08 9.769962616701e-15 2.425000000000e-08 1.801087632620e-01 2.450000000000e-08 -2.426406871193e-02 2.475000000000e-08 -2.336357275839e-01 2.500000000000e-08 -4.718447854657e-16 2.525000000000e-08 5.033942373345e-02 2.550000000000e-08 -6.242640687119e-01 2.575000000000e-08 -1.105467898425e+00 2.600000000000e-08 -4.000000000000e-01 2.625000000000e-08 7.027339492126e-01 2.650000000000e-08 8.242640687119e-01 2.675000000000e-08 1.993211525331e-01 2.700000000000e-08 -1.346145417358e-15 2.725000000000e-08 2.668178637919e-01 2.750000000000e-08 2.242640687119e-01 2.775000000000e-08 -6.021752652407e-02 2.800000000000e-08 7.494005416220e-15 2.825000000000e-08 1.801087632620e-01 2.850000000000e-08 -2.426406871193e-02 2.875000000000e-08 -2.336357275839e-01 2.900000000000e-08 -1.443289932013e-15 2.925000000000e-08 5.033942373345e-02 2.950000000000e-08 -6.242640687119e-01 2.975000000000e-08 -1.105467898425e+00 3.000000000000e-08 -4.000000000000e-01 3.025000000000e-08 7.027339492126e-01 3.050000000000e-08 8.242640687119e-01 3.075000000000e-08 1.993211525331e-01 3.100000000000e-08 -7.632783294298e-16 3.125000000000e-08 2.668178637919e-01 3.150000000000e-08 2.242640687119e-01 3.175000000000e-08 -6.021752652407e-02 3.200000000000e-08 9.478529072737e-15 3.225000000000e-08 1.801087632620e-01 3.250000000000e-08 -2.426406871193e-02 3.275000000000e-08 -2.336357275839e-01 3.300000000000e-08 4.052314039882e-15 3.325000000000e-08 5.033942373345e-02 3.350000000000e-08 -6.242640687119e-01 3.375000000000e-08 -1.105467898425e+00 3.400000000000e-08 -4.000000000000e-01 3.425000000000e-08 7.027339492126e-01 3.450000000000e-08 8.242640687119e-01 3.475000000000e-08 1.993211525331e-01 3.500000000000e-08 2.012279232133e-15 3.525000000000e-08 2.668178637919e-01 3.550000000000e-08 2.242640687119e-01 3.575000000000e-08 -6.021752652407e-02 3.600000000000e-08 2.942091015257e-15 3.625000000000e-08 1.801087632620e-01 3.650000000000e-08 -2.426406871193e-02 3.675000000000e-08 -2.336357275839e-01 3.700000000000e-08 -3.233524559221e-15 3.725000000000e-08 5.033942373346e-02 3.750000000000e-08 -6.242640687119e-01 3.775000000000e-08 -1.105467898425e+00 3.800000000000e-08 -4.000000000000e-01 3.825000000000e-08 7.027339492126e-01 3.850000000000e-08 8.242640687119e-01 3.875000000000e-08 1.993211525331e-01 3.900000000000e-08 7.591149930875e-15 3.925000000000e-08 2.668178637919e-01 3.950000000000e-08 2.242640687119e-01 3.975000000000e-08 -6.021752652407e-02 4.000000000000e-08 2.789435349371e-15 4.025000000000e-08 1.801087632620e-01 4.050000000000e-08 -2.426406871194e-02 4.075000000000e-08 -2.336357275839e-01 4.100000000000e-08 2.275957200482e-15 4.125000000000e-08 5.033942373345e-02 4.150000000000e-08 -6.242640687119e-01 4.175000000000e-08 -1.105467898425e+00 4.200000000000e-08 -4.000000000000e-01 4.225000000000e-08 7.027339492126e-01 4.250000000000e-08 8.242640687119e-01 4.275000000000e-08 1.993211525331e-01 4.300000000000e-08 -1.748601263785e-15 4.325000000000e-08 2.668178637919e-01 4.350000000000e-08 2.242640687119e-01 4.375000000000e-08 -6.021752652407e-02 4.400000000000e-08 6.911138328292e-15 4.425000000000e-08 1.801087632620e-01 4.450000000000e-08 -2.426406871193e-02 4.475000000000e-08 -2.336357275839e-01 4.500000000000e-08 7.716050021145e-15 4.525000000000e-08 5.033942373345e-02 4.550000000000e-08 -6.242640687119e-01 4.575000000000e-08 -1.105467898425e+00 4.600000000000e-08 -4.000000000000e-01 4.625000000000e-08 7.027339492126e-01 4.650000000000e-08 8.242640687119e-01 4.675000000000e-08 1.993211525331e-01 4.700000000000e-08 9.714451465470e-16 4.725000000000e-08 2.668178637919e-01 4.750000000000e-08 2.242640687119e-01 4.775000000000e-08 -6.021752652407e-02 4.800000000000e-08 1.955380302121e-14 4.825000000000e-08 1.801087632620e-01 4.850000000000e-08 -2.426406871194e-02 4.875000000000e-08 -2.336357275839e-01 4.900000000000e-08 4.302114220422e-16 4.925000000000e-08 5.033942373345e-02 4.950000000000e-08 -6.242640687119e-01 4.975000000000e-08 -1.105467898425e+00 5.000000000000e-08 -4.000000000000e-01 5.025000000000e-08 7.027339492126e-01 5.050000000000e-08 8.242640687119e-01 5.075000000000e-08 1.993211525331e-01 5.100000000000e-08 -5.551115123126e-16 5.125000000000e-08 2.668178637919e-01 5.150000000000e-08 2.242640687119e-01 5.175000000000e-08 -6.021752652407e-02 5.200000000000e-08 1.088018564133e-14 5.225000000000e-08 1.801087632620e-01 5.250000000000e-08 -2.426406871193e-02 5.275000000000e-08 -2.336357275839e-01 5.300000000000e-08 5.925815393937e-15 5.325000000000e-08 5.033942373345e-02 5.350000000000e-08 -6.242640687119e-01 5.375000000000e-08 -1.105467898425e+00 5.400000000000e-08 -4.000000000000e-01 5.425000000000e-08 7.027339492126e-01 5.450000000000e-08 8.242640687119e-01 5.475000000000e-08 1.993211525331e-01 5.500000000000e-08 5.065392549852e-15 5.525000000000e-08 2.668178637919e-01 5.550000000000e-08 2.242640687119e-01 5.575000000000e-08 -6.021752652407e-02 5.600000000000e-08 1.498801083244e-14 5.625000000000e-08 1.801087632620e-01 5.650000000000e-08 -2.426406871194e-02 5.675000000000e-08 -2.336357275839e-01 5.700000000000e-08 1.457167719821e-15 5.725000000000e-08 5.033942373345e-02 5.750000000000e-08 -6.242640687119e-01 5.775000000000e-08 -1.105467898425e+00 5.800000000000e-08 -4.000000000000e-01 5.825000000000e-08 7.027339492126e-01 5.850000000000e-08 8.242640687119e-01 5.875000000000e-08 1.993211525331e-01 5.900000000000e-08 4.968248035198e-15 5.925000000000e-08 2.668178637919e-01 5.950000000000e-08 2.242640687119e-01 5.975000000000e-08 -6.021752652407e-02 6.000000000000e-08 2.765843110097e-14 6.025000000000e-08 1.801087632620e-01 6.050000000000e-08 -2.426406871195e-02 6.075000000000e-08 -2.336357275839e-01 6.100000000000e-08 -2.942091015257e-15 6.125000000000e-08 5.033942373345e-02 6.150000000000e-08 -6.242640687119e-01 6.175000000000e-08 -1.105467898425e+00 6.200000000000e-08 -4.000000000000e-01 6.225000000000e-08 7.027339492126e-01 6.250000000000e-08 8.242640687119e-01 6.275000000000e-08 1.993211525331e-01 6.300000000000e-08 1.051936315832e-14 6.325000000000e-08 2.668178637919e-01 6.350000000000e-08 2.242640687119e-01 6.375000000000e-08 -6.021752652407e-02 6.400000000000e-08 1.897093593328e-14 6.425000000000e-08 1.801087632620e-01 6.450000000000e-08 -2.426406871195e-02 6.475000000000e-08 -2.336357275839e-01 6.500000000000e-08 -3.330669073875e-16 6.525000000000e-08 5.033942373345e-02 6.550000000000e-08 -6.242640687119e-01 6.575000000000e-08 -1.105467898425e+00 6.600000000000e-08 -4.000000000000e-01 6.625000000000e-08 7.027339492126e-01 6.650000000000e-08 8.242640687119e-01 6.675000000000e-08 1.993211525331e-01 6.700000000000e-08 6.161737786670e-15 6.725000000000e-08 2.668178637919e-01 6.750000000000e-08 2.242640687119e-01 6.775000000000e-08 -6.021752652407e-02 6.800000000000e-08 1.028344076559e-14 6.825000000000e-08 1.801087632620e-01 6.850000000000e-08 -2.426406871194e-02 6.875000000000e-08 -2.336357275839e-01 6.900000000000e-08 7.993605777301e-15 6.925000000000e-08 5.033942373346e-02 6.950000000000e-08 -6.242640687119e-01 6.975000000000e-08 -1.105467898425e+00 7.000000000000e-08 -4.000000000000e-01 7.025000000000e-08 7.027339492126e-01 7.050000000000e-08 8.242640687119e-01 7.075000000000e-08 1.993211525331e-01 7.100000000000e-08 1.817990202824e-15 7.125000000000e-08 2.668178637919e-01 7.150000000000e-08 2.242640687119e-01 7.175000000000e-08 -6.021752652407e-02 7.200000000000e-08 5.884182030513e-15 7.225000000000e-08 1.801087632620e-01 7.250000000000e-08 -2.426406871194e-02 7.275000000000e-08 -2.336357275839e-01 7.300000000000e-08 3.524958103185e-15 7.325000000000e-08 5.033942373344e-02 7.350000000000e-08 -6.242640687119e-01 7.375000000000e-08 -1.105467898425e+00 7.400000000000e-08 -4.000000000000e-01 7.425000000000e-08 7.027339492126e-01 7.450000000000e-08 8.242640687119e-01 7.475000000000e-08 1.993211525331e-01 7.500000000000e-08 7.369105325949e-15 7.525000000000e-08 2.668178637919e-01 7.550000000000e-08 2.242640687119e-01 7.575000000000e-08 -6.021752652407e-02 7.600000000000e-08 1.426636586643e-14 7.625000000000e-08 1.801087632620e-01 7.650000000000e-08 -2.426406871193e-02 7.675000000000e-08 -2.336357275839e-01 7.700000000000e-08 -6.647460359943e-15 7.725000000000e-08 5.033942373345e-02 7.750000000000e-08 -6.242640687119e-01 7.775000000000e-08 -1.105467898425e+00 7.800000000000e-08 -4.000000000000e-01 7.825000000000e-08 7.027339492126e-01 7.850000000000e-08 8.242640687119e-01 7.875000000000e-08 1.993211525331e-01 7.900000000000e-08 1.297573160031e-14 7.925000000000e-08 2.668178637919e-01 7.950000000000e-08 2.242640687119e-01 7.975000000000e-08 -6.021752652407e-02 8.000000000000e-08 5.578870698741e-15 ]
VWL008 (wl008 0) vsource type=pwl wave=[ 0.000000000000e+00 0.000000000000e+00 2.500000000000e-10 -1.397824734759e-01 5.000000000000e-10 -3.414213562373e-01 7.500000000000e-10 -1.331821362081e-01 1.000000000000e-09 9.714451465470e-17 1.250000000000e-09 -3.993211525331e-01 1.500000000000e-09 -5.414213562373e-01 1.750000000000e-09 3.027339492126e-01 2.000000000000e-09 1.200000000000e+00 2.250000000000e-09 9.054678984252e-01 2.500000000000e-09 -5.857864376269e-02 2.750000000000e-09 -3.496605762665e-01 3.000000000000e-09 -2.636779683485e-16 3.250000000000e-09 3.363572758386e-02 3.500000000000e-09 -2.585786437627e-01 3.750000000000e-09 -2.198912367380e-01 4.000000000000e-09 3.885780586188e-16 4.250000000000e-09 -1.397824734759e-01 4.500000000000e-09 -3.414213562373e-01 4.750000000000e-09 -1.331821362081e-01 5.000000000000e-09 6.522560269673e-16 5.250000000000e-09 -3.993211525331e-01 5.500000000000e-09 -5.414213562373e-01 5.750000000000e-09 3.027339492126e-01 6.000000000000e-09 1.200000000000e+00 6.250000000000e-09 9.054678984252e-01 6.500000000000e-09 -5.857864376269e-02 6.750000000000e-09 -3.496605762665e-01 7.000000000000e-09 2.775557561563e-17 7.250000000000e-09 3.363572758386e-02 7.500000000000e-09 -2.585786437627e-01 7.750000000000e-09 -2.198912367380e-01 8.000000000000e-09 8.326672684689e-16 8.250000000000e-09 -1.397824734759e-01 8.500000000000e-09 -3.414213562373e-01 8.750000000000e-09 -1.331821362081e-01 9.000000000000e-09 -4.579669976579e-16 9.250000000000e-09 -3.993211525331e-01 9.500000000000e-09 -5.414213562373e-01 9.750000000000e-09 3.027339492126e-01 1.000000000000e-08 1.200000000000e+00 1.025000000000e-08 9.054678984252e-01 1.050000000000e-08 -5.857864376269e-02 1.075000000000e-08 -3.496605762665e-01 1.100000000000e-08 -1.804112415016e-16 1.125000000000e-08 3.363572758386e-02 1.150000000000e-08 -2.585786437627e-01 1.175000000000e-08 -2.198912367380e-01 1.200000000000e-08 1.609823385706e-15 1.225000000000e-08 -1.397824734759e-01 1.250000000000e-08 -3.414213562373e-01 1.275000000000e-08 -1.331821362081e-01 1.300000000000e-08 1.706967900361e-15 1.325000000000e-08 -3.993211525331e-01 1.350000000000e-08 -5.414213562373e-01 1.375000000000e-08 3.027339492126e-01 1.400000000000e-08 1.200000000000e+00 1.425000000000e-08 9.054678984252e-01 1.450000000000e-08 -5.857864376269e-02 1.475000000000e-08 -3.496605762665e-01 1.500000000000e-08 -7.216449660064e-16 1.525000000000e-08 3.363572758386e-02 1.550000000000e-08 -2.585786437627e-01 1.575000000000e-08 -2.198912367380e-01 1.600000000000e-08 1.554312234475e-15 1.625000000000e-08 -1.397824734759e-01 1.650000000000e-08 -3.414213562373e-01 1.675000000000e-08 -1.331821362081e-01 1.700000000000e-08 1.804112415016e-15 1.725000000000e-08 -3.993211525331e-01 1.750000000000e-08 -5.414213562373e-01 1.775000000000e-08 3.027339492126e-01 1.800000000000e-08 1.200000000000e+00 1.825000000000e-08 9.054678984252e-01 1.850000000000e-08 -5.857864376269e-02 1.875000000000e-08 -3.496605762665e-01 1.900000000000e-08 -2.720046410332e-15 1.925000000000e-08 3.363572758386e-02 1.950000000000e-08 -2.585786437627e-01 1.975000000000e-08 -2.198912367380e-01 2.000000000000e-08 4.440892098501e-16 2.025000000000e-08 -1.397824734759e-01 2.050000000000e-08 -3.414213562373e-01 2.075000000000e-08 -1.331821362081e-01 2.100000000000e-08 -1.804112415016e-16 2.125000000000e-08 -3.993211525331e-01 2.150000000000e-08 -5.414213562373e-01 2.175000000000e-08 3.027339492126e-01 2.200000000000e-08 1.200000000000e+00 2.225000000000e-08 9.054678984252e-01 2.250000000000e-08 -5.857864376270e-02 2.275000000000e-08 -3.496605762665e-01 2.300000000000e-08 -1.137978600241e-15 2.325000000000e-08 3.363572758386e-02 2.350000000000e-08 -2.585786437627e-01 2.375000000000e-08 -2.198912367380e-01 2.400000000000e-08 3.275157922644e-15 2.425000000000e-08 -1.397824734759e-01 2.450000000000e-08 -3.414213562373e-01 2.475000000000e-08 -1.331821362081e-01 2.500000000000e-08 2.040034807749e-15 2.525000000000e-08 -3.993211525331e-01 2.550000000000e-08 -5.414213562373e-01 2.575000000000e-08 3.027339492126e-01 2.600000000000e-08 1.200000000000e+00 2.625000000000e-08 9.054678984252e-01 2.650000000000e-08 -5.857864376270e-02 2.675000000000e-08 -3.496605762665e-01 2.700000000000e-08 -2.775557561563e-15 2.725000000000e-08 3.363572758386e-02 2.750000000000e-08 -2.585786437627e-01 2.775000000000e-08 -2.198912367380e-01 2.800000000000e-08 2.442490654175e-15 2.825000000000e-08 -1.397824734759e-01 2.850000000000e-08 -3.414213562373e-01 2.875000000000e-08 -1.331821362081e-01 2.900000000000e-08 4.260480856999e-15 2.925000000000e-08 -3.993211525331e-01 2.950000000000e-08 -5.414213562373e-01 2.975000000000e-08 3.027339492126e-01 3.000000000000e-08 1.200000000000e+00 3.025000000000e-08 9.054678984252e-01 3.050000000000e-08 -5.857864376269e-02 3.075000000000e-08 -3.496605762665e-01 3.100000000000e-08 -5.065392549852e-15 3.125000000000e-08 3.363572758385e-02 3.150000000000e-08 -2.585786437627e-01 3.175000000000e-08 -2.198912367380e-01 3.200000000000e-08 3.219646771413e-15 3.225000000000e-08 -1.397824734759e-01 3.250000000000e-08 -3.414213562373e-01 3.275000000000e-08 -1.331821362081e-01 3.300000000000e-08 1.471045507628e-15 3.325000000000e-08 -3.993211525331e-01 3.350000000000e-08 -5.414213562373e-01 3.375000000000e-08 3.027339492126e-01 3.400000000000e-08 1.200000000000e+00 3.425000000000e-08 9.054678984252e-01 3.450000000000e-08 -5.857864376270e-02 3.475000000000e-08 -3.496605762665e-01 3.500000000000e-08 4.440892098501e-16 3.525000000000e-08 3.363572758385e-02 3.550000000000e-08 -2.585786437627e-01 3.575000000000e-08 -2.198912367380e-01 3.600000000000e-08 9.992007221626e-16 3.625000000000e-08 -1.397824734759e-01 3.650000000000e-08 -3.414213562373e-01 3.675000000000e-08 -1.331821362081e-01 3.700000000000e-08 8.701372955500e-15 3.725000000000e-08 -3.993211525331e-01 3.750000000000e-08 -5.414213562373e-01 3.775000000000e-08 3.027339492126e-01 3.800000000000e-08 1.200000000000e+00 3.825000000000e-08 9.054678984252e-01 3.850000000000e-08 -5.857864376268e-02 3.875000000000e-08 -3.496605762666e-01 3.900000000000e-08 -2.622901895677e-15 3.925000000000e-08 3.363572758385e-02 3.950000000000e-08 -2.585786437627e-01 3.975000000000e-08 -2.198912367380e-01 4.000000000000e-08 8.881784197001e-16 4.025000000000e-08 -1.397824734759e-01 4.050000000000e-08 -3.414213562373e-01 4.075000000000e-08 -1.331821362081e-01 4.100000000000e-08 5.981326545168e-15 4.125000000000e-08 -3.993211525331e-01 4.150000000000e-08 -5.414213562373e-01 4.175000000000e-08 3.027339492126e-01 4.200000000000e-08 1.200000000000e+00 4.225000000000e-08 9.054678984252e-01 4.250000000000e-08 -5.857864376269e-02 4.275000000000e-08 -3.496605762666e-01 4.300000000000e-08 -3.538835890993e-15 4.325000000000e-08 3.363572758386e-02 4.350000000000e-08 -2.585786437627e-01 4.375000000000e-08 -2.198912367380e-01 4.400000000000e-08 2.331468351713e-15 4.425000000000e-08 -1.397824734759e-01 4.450000000000e-08 -3.414213562373e-01 4.475000000000e-08 -1.331821362081e-01 4.500000000000e-08 3.191891195797e-15 4.525000000000e-08 -3.993211525331e-01 4.550000000000e-08 -5.414213562373e-01 4.575000000000e-08 3.027339492126e-01 4.600000000000e-08 1.200000000000e+00 4.625000000000e-08 9.054678984252e-01 4.650000000000e-08 -5.857864376270e-02 4.675000000000e-08 -3.496605762665e-01 4.700000000000e-08 1.970645868710e-15 4.725000000000e-08 3.363572758386e-02 4.750000000000e-08 -2.585786437627e-01 4.775000000000e-08 -2.198912367380e-01 4.800000000000e-08 6.550315845288e-15 4.825000000000e-08 -1.397824734759e-01 4.850000000000e-08 -3.414213562373e-01 4.875000000000e-08 -1.331821362081e-01 4.900000000000e-08 1.042221864367e-14 4.925000000000e-08 -3.993211525331e-01 4.950000000000e-08 -5.414213562373e-01 4.975000000000e-08 3.027339492126e-01 5.000000000000e-08 1.200000000000e+00 5.025000000000e-08 9.054678984252e-01 5.050000000000e-08 -5.857864376268e-02 5.075000000000e-08 -3.496605762666e-01 5.100000000000e-08 -8.146261443187e-15 5.125000000000e-08 3.363572758385e-02 5.150000000000e-08 -2.585786437627e-01 5.175000000000e-08 -2.198912367380e-01 5.200000000000e-08 3.608224830032e-15 5.225000000000e-08 -1.397824734759e-01 5.250000000000e-08 -3.414213562373e-01 5.275000000000e-08 -1.331821362081e-01 5.300000000000e-08 7.688294445529e-15 5.325000000000e-08 -3.993211525331e-01 5.350000000000e-08 -5.414213562373e-01 5.375000000000e-08 3.027339492126e-01 5.400000000000e-08 1.200000000000e+00 5.425000000000e-08 9.054678984252e-01 5.450000000000e-08 -5.857864376270e-02 5.475000000000e-08 -3.496605762665e-01 5.500000000000e-08 -1.121325254871e-14 5.525000000000e-08 3.363572758385e-02 5.550000000000e-08 -2.585786437627e-01 5.575000000000e-08 -2.198912367379e-01 5.600000000000e-08 5.051514762044e-15 5.625000000000e-08 -1.397824734759e-01 5.650000000000e-08 -3.414213562373e-01 5.675000000000e-08 -1.331821362081e-01 5.700000000000e-08 6.411537967210e-15 5.725000000000e-08 -3.993211525331e-01 5.750000000000e-08 -5.414213562373e-01 5.775000000000e-08 3.027339492126e-01 5.800000000000e-08 1.200000000000e+00 5.825000000000e-08 9.054678984252e-01 5.850000000000e-08 -5.857864376269e-02 5.875000000000e-08 -3.496605762665e-01 5.900000000000e-08 2.803313137179e-15 5.925000000000e-08 3.363572758384e-02 5.950000000000e-08 -2.585786437627e-01 5.975000000000e-08 -2.198912367380e-01 6.000000000000e-08 9.214851104389e-15 6.025000000000e-08 -1.397824734759e-01 6.050000000000e-08 -3.414213562373e-01 6.075000000000e-08 -1.331821362081e-01 6.100000000000e-08 5.051514762044e-15 6.125000000000e-08 -3.993211525331e-01 6.150000000000e-08 -5.414213562373e-01 6.175000000000e-08 3.027339492126e-01 6.200000000000e-08 1.200000000000e+00 6.225000000000e-08 9.054678984252e-01 6.250000000000e-08 -5.857864376272e-02 6.275000000000e-08 -3.496605762665e-01 6.300000000000e-08 -2.775557561563e-16 6.325000000000e-08 3.363572758385e-02 6.350000000000e-08 -2.585786437627e-01 6.375000000000e-08 -2.198912367380e-01 6.400000000000e-08 6.272760089132e-15 6.425000000000e-08 -1.397824734759e-01 6.450000000000e-08 -3.414213562373e-01 6.475000000000e-08 -1.331821362081e-01 6.500000000000e-08 1.079691891448e-14 6.525000000000e-08 -3.993211525331e-01 6.550000000000e-08 -5.414213562373e-01 6.575000000000e-08 3.027339492126e-01 6.600000000000e-08 1.200000000000e+00 6.625000000000e-08 9.054678984252e-01 6.650000000000e-08 -5.857864376270e-02 6.675000000000e-08 -3.496605762666e-01 6.700000000000e-08 -1.859623566247e-15 6.725000000000e-08 3.363572758384e-02 6.750000000000e-08 -2.585786437627e-01 6.775000000000e-08 -2.198912367380e-01 6.800000000000e-08 3.441691376338e-15 6.825000000000e-08 -1.397824734759e-01 6.850000000000e-08 -3.414213562373e-01 6.875000000000e-08 -1.331821362081e-01 6.900000000000e-08 -4.163336342344e-16 6.925000000000e-08 -3.993211525331e-01 6.950000000000e-08 -5.414213562373e-01 6.975000000000e-08 3.027339492126e-01 7.000000000000e-08 1.200000000000e+00 7.025000000000e-08 9.054678984251e-01 7.050000000000e-08 -5.857864376269e-02 7.075000000000e-08 -3.496605762665e-01 7.100000000000e-08 -3.511080315377e-15 7.125000000000e-08 3.363572758384e-02 7.150000000000e-08 -2.585786437627e-01 7.175000000000e-08 -2.198912367379e-01 7.200000000000e-08 1.942890293094e-15 7.225000000000e-08 -1.397824734759e-01 7.250000000000e-08 -3.414213562373e-01 7.275000000000e-08 -1.331821362081e-01 7.300000000000e-08 -1.762479051592e-15 7.325000000000e-08 -3.993211525331e-01 7.350000000000e-08 -5.414213562373e-01 7.375000000000e-08 3.027339492126e-01 7.400000000000e-08 1.200000000000e+00 7.425000000000e-08 9.054678984251e-01 7.450000000000e-08 -5.857864376268e-02 7.475000000000e-08 -3.496605762665e-01 7.500000000000e-08 -6.480926906249e-15 7.525000000000e-08 3.363572758385e-02 7.550000000000e-08 -2.585786437627e-01 7.575000000000e-08 -2.198912367379e-01 7.600000000000e-08 4.829470157119e-15 7.625000000000e-08 -1.397824734759e-01 7.650000000000e-08 -3.414213562373e-01 7.675000000000e-08 -1.331821362081e-01 7.700000000000e-08 1.398881011028e-14 7.725000000000e-08 -3.993211525331e-01 7.750000000000e-08 -5.414213562373e-01 7.775000000000e-08 3.027339492126e-01 7.800000000000e-08 1.200000000000e+00 7.825000000000e-08 9.054678984252e-01 7.850000000000e-08 -5.857864376271e-02 7.875000000000e-08 -3.496605762665e-01 7.900000000000e-08 -9.561795799584e-15 7.925000000000e-08 3.363572758385e-02 7.950000000000e-08 -2.585786437627e-01 7.975000000000e-08 -2.198912367380e-01 8.000000000000e-08 1.887379141863e-15 ]
VWL009 (wl009 0) vsource type=pwl wave=[ 0.000000000000e+00 0.000000000000e+00 2.500000000000e-10 -1.801087632620e-01 5.000000000000e-10 2.426406871193e-02 7.500000000000e-10 2.336357275839e-01 1.000000000000e-09 -9.714451465470e-17 1.250000000000e-09 -5.033942373345e-02 1.500000000000e-09 6.242640687119e-01 1.750000000000e-09 1.105467898425e+00 2.000000000000e-09 4.000000000000e-01 2.250000000000e-09 -7.027339492126e-01 2.500000000000e-09 -8.242640687119e-01 2.750000000000e-09 -1.993211525331e-01 3.000000000000e-09 -5.412337245048e-16 3.250000000000e-09 -2.668178637919e-01 3.500000000000e-09 -2.242640687119e-01 3.750000000000e-09 6.021752652407e-02 4.000000000000e-09 -1.193489751472e-15 4.250000000000e-09 -1.801087632620e-01 4.500000000000e-09 2.426406871193e-02 4.750000000000e-09 2.336357275839e-01 5.000000000000e-09 4.024558464266e-16 5.250000000000e-09 -5.033942373345e-02 5.500000000000e-09 6.242640687119e-01 5.750000000000e-09 1.105467898425e+00 6.000000000000e-09 4.000000000000e-01 6.250000000000e-09 -7.027339492126e-01 6.500000000000e-09 -8.242640687119e-01 6.750000000000e-09 -1.993211525331e-01 7.000000000000e-09 -8.743006318923e-16 7.250000000000e-09 -2.668178637919e-01 7.500000000000e-09 -2.242640687119e-01 7.750000000000e-09 6.021752652407e-02 8.000000000000e-09 -2.373101715136e-15 8.250000000000e-09 -1.801087632620e-01 8.500000000000e-09 2.426406871193e-02 8.750000000000e-09 2.336357275839e-01 9.000000000000e-09 -1.013078509970e-15 9.250000000000e-09 -5.033942373345e-02 9.500000000000e-09 6.242640687119e-01 9.750000000000e-09 1.105467898425e+00 1.000000000000e-08 4.000000000000e-01 1.025000000000e-08 -7.027339492126e-01 1.050000000000e-08 -8.242640687119e-01 1.075000000000e-08 -1.993211525331e-01 1.100000000000e-08 -7.632783294298e-16 1.125000000000e-08 -2.668178637919e-01 1.150000000000e-08 -2.242640687119e-01 1.175000000000e-08 6.021752652407e-02 1.200000000000e-08 -4.898859096159e-15 1.225000000000e-08 -1.801087632620e-01 1.250000000000e-08 2.426406871193e-02 1.275000000000e-08 2.336357275839e-01 1.300000000000e-08 -4.163336342344e-17 1.325000000000e-08 -5.033942373345e-02 1.350000000000e-08 6.242640687119e-01 1.375000000000e-08 1.105467898425e+00 1.400000000000e-08 4.000000000000e-01 1.425000000000e-08 -7.027339492126e-01 1.450000000000e-08 -8.242640687119e-01 1.475000000000e-08 -1.993211525331e-01 1.500000000000e-08 -3.191891195797e-15 1.525000000000e-08 -2.668178637919e-01 1.550000000000e-08 -2.242640687119e-01 1.575000000000e-08 6.021752652407e-02 1.600000000000e-08 -4.732325642465e-15 1.625000000000e-08 -1.801087632620e-01 1.650000000000e-08 2.426406871193e-02 1.675000000000e-08 2.336357275839e-01 1.700000000000e-08 1.110223024625e-16 1.725000000000e-08 -5.033942373345e-02 1.750000000000e-08 6.242640687119e-01 1.775000000000e-08 1.105467898425e+00 1.800000000000e-08 4.000000000000e-01 1.825000000000e-08 -7.027339492126e-01 1.850000000000e-08 -8.242640687119e-01 1.875000000000e-08 -1.993211525331e-01 1.900000000000e-08 -1.304512053935e-15 1.925000000000e-08 -2.668178637919e-01 1.950000000000e-08 -2.242640687119e-01 1.975000000000e-08 6.021752652407e-02 2.000000000000e-08 -1.387778780781e-15 2.025000000000e-08 -1.801087632620e-01 2.050000000000e-08 2.426406871193e-02 2.075000000000e-08 2.336357275839e-01 2.100000000000e-08 -4.024558464266e-16 2.125000000000e-08 -5.033942373345e-02 2.150000000000e-08 6.242640687119e-01 2.175000000000e-08 1.105467898425e+00 2.200000000000e-08 4.000000000000e-01 2.225000000000e-08 -7.027339492126e-01 2.250000000000e-08 -8.242640687119e-01 2.275000000000e-08 -1.993211525331e-01 2.300000000000e-08 -2.955968803064e-15 2.325000000000e-08 -2.668178637919e-01 2.350000000000e-08 -2.242640687119e-01 2.375000000000e-08 6.021752652407e-02 2.400000000000e-08 -9.769962616701e-15 2.425000000000e-08 -1.801087632620e-01 2.450000000000e-08 2.426406871193e-02 2.475000000000e-08 2.336357275839e-01 2.500000000000e-08 4.718447854657e-16 2.525000000000e-08 -5.033942373345e-02 2.550000000000e-08 6.242640687119e-01 2.575000000000e-08 1.105467898425e+00 2.600000000000e-08 4.000000000000e-01 2.625000000000e-08 -7.027339492126e-01 2.650000000000e-08 -8.242640687119e-01 2.675000000000e-08 -1.993211525331e-01 2.700000000000e-08 1.346145417358e-15 2.725000000000e-08 -2.668178637919e-01 2.750000000000e-08 -2.242640687119e-01 2.775000000000e-08 6.021752652407e-02 2.800000000000e-08 -7.494005416220e-15 2.825000000000e-08 -1.801087632620e-01 2.850000000000e-08 2.426406871193e-02 2.875000000000e-08 2.336357275839e-01 2.900000000000e-08 1.443289932013e-15 2.925000000000e-08 -5.033942373345e-02 2.950000000000e-08 6.242640687119e-01 2.975000000000e-08 1.105467898425e+00 3.000000000000e-08 4.000000000000e-01 3.025000000000e-08 -7.027339492126e-01 3.050000000000e-08 -8.242640687119e-01 3.075000000000e-08 -1.993211525331e-01 3.100000000000e-08 7.632783294298e-16 3.125000000000e-08 -2.668178637919e-01 3.150000000000e-08 -2.242640687119e-01 3.175000000000e-08 6.021752652407e-02 3.200000000000e-08 -9.478529072737e-15 3.225000000000e-08 -1.801087632620e-01 3.250000000000e-08 2.426406871193e-02 3.275000000000e-08 2.336357275839e-01 3.300000000000e-08 -4.052314039882e-15 3.325000000000e-08 -5.033942373345e-02 3.350000000000e-08 6.242640687119e-01 3.375000000000e-08 1.105467898425e+00 3.400000000000e-08 4.000000000000e-01 3.425000000000e-08 -7.027339492126e-01 3.450000000000e-08 -8.242640687119e-01 3.475000000000e-08 -1.993211525331e-01 3.500000000000e-08 -2.012279232133e-15 3.525000000000e-08 -2.668178637919e-01 3.550000000000e-08 -2.242640687119e-01 3.575000000000e-08 6.021752652407e-02 3.600000000000e-08 -2.942091015257e-15 3.625000000000e-08 -1.801087632620e-01 3.650000000000e-08 2.426406871193e-02 3.675000000000e-08 2.336357275839e-01 3.700000000000e-08 3.233524559221e-15 3.725000000000e-08 -5.033942373346e-02 3.750000000000e-08 6.242640687119e-01 3.775000000000e-08 1.105467898425e+00 3.800000000000e-08 4.000000000000e-01 3.825000000000e-08 -7.027339492126e-01 3.850000000000e-08 -8.242640687119e-01 3.875000000000e-08 -1.993211525331e-01 3.900000000000e-08 -7.591149930875e-15 3.925000000000e-08 -2.668178637919e-01 3.950000000000e-08 -2.242640687119e-01 3.975000000000e-08 6.021752652407e-02 4.000000000000e-08 -2.789435349371e-15 4.025000000000e-08 -1.801087632620e-01 4.050000000000e-08 2.426406871194e-02 4.075000000000e-08 2.336357275839e-01 4.100000000000e-08 -2.275957200482e-15 4.125000000000e-08 -5.033942373345e-02 4.150000000000e-08 6.242640687119e-01 4.175000000000e-08 1.105467898425e+00 4.200000000000e-08 4.000000000000e-01 4.225000000000e-08 -7.027339492126e-01 4.250000000000e-08 -8.242640687119e-01 4.275000000000e-08 -1.993211525331e-01 4.300000000000e-08 1.748601263785e-15 4.325000000000e-08 -2.668178637919e-01 4.350000000000e-08 -2.242640687119e-01 4.375000000000e-08 6.021752652407e-02 4.400000000000e-08 -6.911138328292e-15 4.425000000000e-08 -1.801087632620e-01 4.450000000000e-08 2.426406871193e-02 4.475000000000e-08 2.336357275839e-01 4.500000000000e-08 -7.716050021145e-15 4.525000000000e-08 -5.033942373345e-02 4.550000000000e-08 6.242640687119e-01 4.575000000000e-08 1.105467898425e+00 4.600000000000e-08 4.000000000000e-01 4.625000000000e-08 -7.027339492126e-01 4.650000000000e-08 -8.242640687119e-01 4.675000000000e-08 -1.993211525331e-01 4.700000000000e-08 -9.714451465470e-16 4.725000000000e-08 -2.668178637919e-01 4.750000000000e-08 -2.242640687119e-01 4.775000000000e-08 6.021752652407e-02 4.800000000000e-08 -1.955380302121e-14 4.825000000000e-08 -1.801087632620e-01 4.850000000000e-08 2.426406871194e-02 4.875000000000e-08 2.336357275839e-01 4.900000000000e-08 -4.302114220422e-16 4.925000000000e-08 -5.033942373345e-02 4.950000000000e-08 6.242640687119e-01 4.975000000000e-08 1.105467898425e+00 5.000000000000e-08 4.000000000000e-01 5.025000000000e-08 -7.027339492126e-01 5.050000000000e-08 -8.242640687119e-01 5.075000000000e-08 -1.993211525331e-01 5.100000000000e-08 5.551115123126e-16 5.125000000000e-08 -2.668178637919e-01 5.150000000000e-08 -2.242640687119e-01 5.175000000000e-08 6.021752652407e-02 5.200000000000e-08 -1.088018564133e-14 5.225000000000e-08 -1.801087632620e-01 5.250000000000e-08 2.426406871193e-02 5.275000000000e-08 2.336357275839e-01 5.300000000000e-08 -5.925815393937e-15 5.325000000000e-08 -5.033942373345e-02 5.350000000000e-08 6.242640687119e-01 5.375000000000e-08 1.105467898425e+00 5.400000000000e-08 4.000000000000e-01 5.425000000000e-08 -7.027339492126e-01 5.450000000000e-08 -8.242640687119e-01 5.475000000000e-08 -1.993211525331e-01 5.500000000000e-08 -5.065392549852e-15 5.525000000000e-08 -2.668178637919e-01 5.550000000000e-08 -2.242640687119e-01 5.575000000000e-08 6.021752652407e-02 5.600000000000e-08 -1.498801083244e-14 5.625000000000e-08 -1.801087632620e-01 5.650000000000e-08 2.426406871194e-02 5.675000000000e-08 2.336357275839e-01 5.700000000000e-08 -1.457167719821e-15 5.725000000000e-08 -5.033942373345e-02 5.750000000000e-08 6.242640687119e-01 5.775000000000e-08 1.105467898425e+00 5.800000000000e-08 4.000000000000e-01 5.825000000000e-08 -7.027339492126e-01 5.850000000000e-08 -8.242640687119e-01 5.875000000000e-08 -1.993211525331e-01 5.900000000000e-08 -4.968248035198e-15 5.925000000000e-08 -2.668178637919e-01 5.950000000000e-08 -2.242640687119e-01 5.975000000000e-08 6.021752652407e-02 6.000000000000e-08 -2.765843110097e-14 6.025000000000e-08 -1.801087632620e-01 6.050000000000e-08 2.426406871195e-02 6.075000000000e-08 2.336357275839e-01 6.100000000000e-08 2.942091015257e-15 6.125000000000e-08 -5.033942373345e-02 6.150000000000e-08 6.242640687119e-01 6.175000000000e-08 1.105467898425e+00 6.200000000000e-08 4.000000000000e-01 6.225000000000e-08 -7.027339492126e-01 6.250000000000e-08 -8.242640687119e-01 6.275000000000e-08 -1.993211525331e-01 6.300000000000e-08 -1.051936315832e-14 6.325000000000e-08 -2.668178637919e-01 6.350000000000e-08 -2.242640687119e-01 6.375000000000e-08 6.021752652407e-02 6.400000000000e-08 -1.897093593328e-14 6.425000000000e-08 -1.801087632620e-01 6.450000000000e-08 2.426406871195e-02 6.475000000000e-08 2.336357275839e-01 6.500000000000e-08 3.330669073875e-16 6.525000000000e-08 -5.033942373345e-02 6.550000000000e-08 6.242640687119e-01 6.575000000000e-08 1.105467898425e+00 6.600000000000e-08 4.000000000000e-01 6.625000000000e-08 -7.027339492126e-01 6.650000000000e-08 -8.242640687119e-01 6.675000000000e-08 -1.993211525331e-01 6.700000000000e-08 -6.161737786670e-15 6.725000000000e-08 -2.668178637919e-01 6.750000000000e-08 -2.242640687119e-01 6.775000000000e-08 6.021752652407e-02 6.800000000000e-08 -1.028344076559e-14 6.825000000000e-08 -1.801087632620e-01 6.850000000000e-08 2.426406871194e-02 6.875000000000e-08 2.336357275839e-01 6.900000000000e-08 -7.993605777301e-15 6.925000000000e-08 -5.033942373346e-02 6.950000000000e-08 6.242640687119e-01 6.975000000000e-08 1.105467898425e+00 7.000000000000e-08 4.000000000000e-01 7.025000000000e-08 -7.027339492126e-01 7.050000000000e-08 -8.242640687119e-01 7.075000000000e-08 -1.993211525331e-01 7.100000000000e-08 -1.817990202824e-15 7.125000000000e-08 -2.668178637919e-01 7.150000000000e-08 -2.242640687119e-01 7.175000000000e-08 6.021752652407e-02 7.200000000000e-08 -5.884182030513e-15 7.225000000000e-08 -1.801087632620e-01 7.250000000000e-08 2.426406871194e-02 7.275000000000e-08 2.336357275839e-01 7.300000000000e-08 -3.524958103185e-15 7.325000000000e-08 -5.033942373344e-02 7.350000000000e-08 6.242640687119e-01 7.375000000000e-08 1.105467898425e+00 7.400000000000e-08 4.000000000000e-01 7.425000000000e-08 -7.027339492126e-01 7.450000000000e-08 -8.242640687119e-01 7.475000000000e-08 -1.993211525331e-01 7.500000000000e-08 -7.369105325949e-15 7.525000000000e-08 -2.668178637919e-01 7.550000000000e-08 -2.242640687119e-01 7.575000000000e-08 6.021752652407e-02 7.600000000000e-08 -1.426636586643e-14 7.625000000000e-08 -1.801087632620e-01 7.650000000000e-08 2.426406871193e-02 7.675000000000e-08 2.336357275839e-01 7.700000000000e-08 6.647460359943e-15 7.725000000000e-08 -5.033942373345e-02 7.750000000000e-08 6.242640687119e-01 7.775000000000e-08 1.105467898425e+00 7.800000000000e-08 4.000000000000e-01 7.825000000000e-08 -7.027339492126e-01 7.850000000000e-08 -8.242640687119e-01 7.875000000000e-08 -1.993211525331e-01 7.900000000000e-08 -1.297573160031e-14 7.925000000000e-08 -2.668178637919e-01 7.950000000000e-08 -2.242640687119e-01 7.975000000000e-08 6.021752652407e-02 8.000000000000e-08 -5.578870698741e-15 ]
VWL010 (wl010 0) vsource type=pwl wave=[ 0.000000000000e+00 0.000000000000e+00 2.500000000000e-10 1.397824734759e-01 5.000000000000e-10 3.414213562373e-01 7.500000000000e-10 1.331821362081e-01 1.000000000000e-09 -9.714451465470e-17 1.250000000000e-09 3.993211525331e-01 1.500000000000e-09 5.414213562373e-01 1.750000000000e-09 -3.027339492126e-01 2.000000000000e-09 -1.200000000000e+00 2.250000000000e-09 -9.054678984252e-01 2.500000000000e-09 5.857864376269e-02 2.750000000000e-09 3.496605762665e-01 3.000000000000e-09 2.636779683485e-16 3.250000000000e-09 -3.363572758386e-02 3.500000000000e-09 2.585786437627e-01 3.750000000000e-09 2.198912367380e-01 4.000000000000e-09 -3.885780586188e-16 4.250000000000e-09 1.397824734759e-01 4.500000000000e-09 3.414213562373e-01 4.750000000000e-09 1.331821362081e-01 5.000000000000e-09 -6.522560269673e-16 5.250000000000e-09 3.993211525331e-01 5.500000000000e-09 5.414213562373e-01 5.750000000000e-09 -3.027339492126e-01 6.000000000000e-09 -1.200000000000e+00 6.250000000000e-09 -9.054678984252e-01 6.500000000000e-09 5.857864376269e-02 6.750000000000e-09 3.496605762665e-01 7.000000000000e-09 -2.775557561563e-17 7.250000000000e-09 -3.363572758386e-02 7.500000000000e-09 2.585786437627e-01 7.750000000000e-09 2.198912367380e-01 8.000000000000e-09 -8.326672684689e-16 8.250000000000e-09 1.397824734759e-01 8.500000000000e-09 3.414213562373e-01 8.750000000000e-09 1.331821362081e-01 9.000000000000e-09 4.579669976579e-16 9.250000000000e-09 3.993211525331e-01 9.500000000000e-09 5.414213562373e-01 9.750000000000e-09 -3.027339492126e-01 1.000000000000e-08 -1.200000000000e+00 1.025000000000e-08 -9.054678984252e-01 1.050000000000e-08 5.857864376269e-02 1.075000000000e-08 3.496605762665e-01 1.100000000000e-08 1.804112415016e-16 1.125000000000e-08 -3.363572758386e-02 1.150000000000e-08 2.585786437627e-01 1.175000000000e-08 2.198912367380e-01 1.200000000000e-08 -1.609823385706e-15 1.225000000000e-08 1.397824734759e-01 1.250000000000e-08 3.414213562373e-01 1.275000000000e-08 1.331821362081e-01 1.300000000000e-08 -1.706967900361e-15 1.325000000000e-08 3.993211525331e-01 1.350000000000e-08 5.414213562373e-01 1.375000000000e-08 -3.027339492126e-01 1.400000000000e-08 -1.200000000000e+00 1.425000000000e-08 -9.054678984252e-01 1.450000000000e-08 5.857864376269e-02 1.475000000000e-08 3.496605762665e-01 1.500000000000e-08 7.216449660064e-16 1.525000000000e-08 -3.363572758386e-02 1.550000000000e-08 2.585786437627e-01 1.575000000000e-08 2.198912367380e-01 1.600000000000e-08 -1.554312234475e-15 1.625000000000e-08 1.397824734759e-01 1.650000000000e-08 3.414213562373e-01 1.675000000000e-08 1.331821362081e-01 1.700000000000e-08 -1.804112415016e-15 1.725000000000e-08 3.993211525331e-01 1.750000000000e-08 5.414213562373e-01 1.775000000000e-08 -3.027339492126e-01 1.800000000000e-08 -1.200000000000e+00 1.825000000000e-08 -9.054678984252e-01 1.850000000000e-08 5.857864376269e-02 1.875000000000e-08 3.496605762665e-01 1.900000000000e-08 2.720046410332e-15 1.925000000000e-08 -3.363572758386e-02 1.950000000000e-08 2.585786437627e-01 1.975000000000e-08 2.198912367380e-01 2.000000000000e-08 -4.440892098501e-16 2.025000000000e-08 1.397824734759e-01 2.050000000000e-08 3.414213562373e-01 2.075000000000e-08 1.331821362081e-01 2.100000000000e-08 1.804112415016e-16 2.125000000000e-08 3.993211525331e-01 2.150000000000e-08 5.414213562373e-01 2.175000000000e-08 -3.027339492126e-01 2.200000000000e-08 -1.200000000000e+00 2.225000000000e-08 -9.054678984252e-01 2.250000000000e-08 5.857864376270e-02 2.275000000000e-08 3.496605762665e-01 2.300000000000e-08 1.137978600241e-15 2.325000000000e-08 -3.363572758386e-02 2.350000000000e-08 2.585786437627e-01 2.375000000000e-08 2.198912367380e-01 2.400000000000e-08 -3.275157922644e-15 2.425000000000e-08 1.397824734759e-01 2.450000000000e-08 3.414213562373e-01 2.475000000000e-08 1.331821362081e-01 2.500000000000e-08 -2.040034807749e-15 2.525000000000e-08 3.993211525331e-01 2.550000000000e-08 5.414213562373e-01 2.575000000000e-08 -3.027339492126e-01 2.600000000000e-08 -1.200000000000e+00 2.625000000000e-08 -9.054678984252e-01 2.650000000000e-08 5.857864376270e-02 2.675000000000e-08 3.496605762665e-01 2.700000000000e-08 2.775557561563e-15 2.725000000000e-08 -3.363572758386e-02 2.750000000000e-08 2.585786437627e-01 2.775000000000e-08 2.198912367380e-01 2.800000000000e-08 -2.442490654175e-15 2.825000000000e-08 1.397824734759e-01 2.850000000000e-08 3.414213562373e-01 2.875000000000e-08 1.331821362081e-01 2.900000000000e-08 -4.260480856999e-15 2.925000000000e-08 3.993211525331e-01 2.950000000000e-08 5.414213562373e-01 2.975000000000e-08 -3.027339492126e-01 3.000000000000e-08 -1.200000000000e+00 3.025000000000e-08 -9.054678984252e-01 3.050000000000e-08 5.857864376269e-02 3.075000000000e-08 3.496605762665e-01 3.100000000000e-08 5.065392549852e-15 3.125000000000e-08 -3.363572758385e-02 3.150000000000e-08 2.585786437627e-01 3.175000000000e-08 2.198912367380e-01 3.200000000000e-08 -3.219646771413e-15 3.225000000000e-08 1.397824734759e-01 3.250000000000e-08 3.414213562373e-01 3.275000000000e-08 1.331821362081e-01 3.300000000000e-08 -1.471045507628e-15 3.325000000000e-08 3.993211525331e-01 3.350000000000e-08 5.414213562373e-01 3.375000000000e-08 -3.027339492126e-01 3.400000000000e-08 -1.200000000000e+00 3.425000000000e-08 -9.054678984252e-01 3.450000000000e-08 5.857864376270e-02 3.475000000000e-08 3.496605762665e-01 3.500000000000e-08 -4.440892098501e-16 3.525000000000e-08 -3.363572758385e-02 3.550000000000e-08 2.585786437627e-01 3.575000000000e-08 2.198912367380e-01 3.600000000000e-08 -9.992007221626e-16 3.625000000000e-08 1.397824734759e-01 3.650000000000e-08 3.414213562373e-01 3.675000000000e-08 1.331821362081e-01 3.700000000000e-08 -8.701372955500e-15 3.725000000000e-08 3.993211525331e-01 3.750000000000e-08 5.414213562373e-01 3.775000000000e-08 -3.027339492126e-01 3.800000000000e-08 -1.200000000000e+00 3.825000000000e-08 -9.054678984252e-01 3.850000000000e-08 5.857864376268e-02 3.875000000000e-08 3.496605762666e-01 3.900000000000e-08 2.622901895677e-15 3.925000000000e-08 -3.363572758385e-02 3.950000000000e-08 2.585786437627e-01 3.975000000000e-08 2.198912367380e-01 4.000000000000e-08 -8.881784197001e-16 4.025000000000e-08 1.397824734759e-01 4.050000000000e-08 3.414213562373e-01 4.075000000000e-08 1.331821362081e-01 4.100000000000e-08 -5.981326545168e-15 4.125000000000e-08 3.993211525331e-01 4.150000000000e-08 5.414213562373e-01 4.175000000000e-08 -3.027339492126e-01 4.200000000000e-08 -1.200000000000e+00 4.225000000000e-08 -9.054678984252e-01 4.250000000000e-08 5.857864376269e-02 4.275000000000e-08 3.496605762666e-01 4.300000000000e-08 3.538835890993e-15 4.325000000000e-08 -3.363572758386e-02 4.350000000000e-08 2.585786437627e-01 4.375000000000e-08 2.198912367380e-01 4.400000000000e-08 -2.331468351713e-15 4.425000000000e-08 1.397824734759e-01 4.450000000000e-08 3.414213562373e-01 4.475000000000e-08 1.331821362081e-01 4.500000000000e-08 -3.191891195797e-15 4.525000000000e-08 3.993211525331e-01 4.550000000000e-08 5.414213562373e-01 4.575000000000e-08 -3.027339492126e-01 4.600000000000e-08 -1.200000000000e+00 4.625000000000e-08 -9.054678984252e-01 4.650000000000e-08 5.857864376270e-02 4.675000000000e-08 3.496605762665e-01 4.700000000000e-08 -1.970645868710e-15 4.725000000000e-08 -3.363572758386e-02 4.750000000000e-08 2.585786437627e-01 4.775000000000e-08 2.198912367380e-01 4.800000000000e-08 -6.550315845288e-15 4.825000000000e-08 1.397824734759e-01 4.850000000000e-08 3.414213562373e-01 4.875000000000e-08 1.331821362081e-01 4.900000000000e-08 -1.042221864367e-14 4.925000000000e-08 3.993211525331e-01 4.950000000000e-08 5.414213562373e-01 4.975000000000e-08 -3.027339492126e-01 5.000000000000e-08 -1.200000000000e+00 5.025000000000e-08 -9.054678984252e-01 5.050000000000e-08 5.857864376268e-02 5.075000000000e-08 3.496605762666e-01 5.100000000000e-08 8.146261443187e-15 5.125000000000e-08 -3.363572758385e-02 5.150000000000e-08 2.585786437627e-01 5.175000000000e-08 2.198912367380e-01 5.200000000000e-08 -3.608224830032e-15 5.225000000000e-08 1.397824734759e-01 5.250000000000e-08 3.414213562373e-01 5.275000000000e-08 1.331821362081e-01 5.300000000000e-08 -7.688294445529e-15 5.325000000000e-08 3.993211525331e-01 5.350000000000e-08 5.414213562373e-01 5.375000000000e-08 -3.027339492126e-01 5.400000000000e-08 -1.200000000000e+00 5.425000000000e-08 -9.054678984252e-01 5.450000000000e-08 5.857864376270e-02 5.475000000000e-08 3.496605762665e-01 5.500000000000e-08 1.121325254871e-14 5.525000000000e-08 -3.363572758385e-02 5.550000000000e-08 2.585786437627e-01 5.575000000000e-08 2.198912367379e-01 5.600000000000e-08 -5.051514762044e-15 5.625000000000e-08 1.397824734759e-01 5.650000000000e-08 3.414213562373e-01 5.675000000000e-08 1.331821362081e-01 5.700000000000e-08 -6.411537967210e-15 5.725000000000e-08 3.993211525331e-01 5.750000000000e-08 5.414213562373e-01 5.775000000000e-08 -3.027339492126e-01 5.800000000000e-08 -1.200000000000e+00 5.825000000000e-08 -9.054678984252e-01 5.850000000000e-08 5.857864376269e-02 5.875000000000e-08 3.496605762665e-01 5.900000000000e-08 -2.803313137179e-15 5.925000000000e-08 -3.363572758384e-02 5.950000000000e-08 2.585786437627e-01 5.975000000000e-08 2.198912367380e-01 6.000000000000e-08 -9.214851104389e-15 6.025000000000e-08 1.397824734759e-01 6.050000000000e-08 3.414213562373e-01 6.075000000000e-08 1.331821362081e-01 6.100000000000e-08 -5.051514762044e-15 6.125000000000e-08 3.993211525331e-01 6.150000000000e-08 5.414213562373e-01 6.175000000000e-08 -3.027339492126e-01 6.200000000000e-08 -1.200000000000e+00 6.225000000000e-08 -9.054678984252e-01 6.250000000000e-08 5.857864376272e-02 6.275000000000e-08 3.496605762665e-01 6.300000000000e-08 2.775557561563e-16 6.325000000000e-08 -3.363572758385e-02 6.350000000000e-08 2.585786437627e-01 6.375000000000e-08 2.198912367380e-01 6.400000000000e-08 -6.272760089132e-15 6.425000000000e-08 1.397824734759e-01 6.450000000000e-08 3.414213562373e-01 6.475000000000e-08 1.331821362081e-01 6.500000000000e-08 -1.079691891448e-14 6.525000000000e-08 3.993211525331e-01 6.550000000000e-08 5.414213562373e-01 6.575000000000e-08 -3.027339492126e-01 6.600000000000e-08 -1.200000000000e+00 6.625000000000e-08 -9.054678984252e-01 6.650000000000e-08 5.857864376270e-02 6.675000000000e-08 3.496605762666e-01 6.700000000000e-08 1.859623566247e-15 6.725000000000e-08 -3.363572758384e-02 6.750000000000e-08 2.585786437627e-01 6.775000000000e-08 2.198912367380e-01 6.800000000000e-08 -3.441691376338e-15 6.825000000000e-08 1.397824734759e-01 6.850000000000e-08 3.414213562373e-01 6.875000000000e-08 1.331821362081e-01 6.900000000000e-08 4.163336342344e-16 6.925000000000e-08 3.993211525331e-01 6.950000000000e-08 5.414213562373e-01 6.975000000000e-08 -3.027339492126e-01 7.000000000000e-08 -1.200000000000e+00 7.025000000000e-08 -9.054678984251e-01 7.050000000000e-08 5.857864376269e-02 7.075000000000e-08 3.496605762665e-01 7.100000000000e-08 3.511080315377e-15 7.125000000000e-08 -3.363572758384e-02 7.150000000000e-08 2.585786437627e-01 7.175000000000e-08 2.198912367379e-01 7.200000000000e-08 -1.942890293094e-15 7.225000000000e-08 1.397824734759e-01 7.250000000000e-08 3.414213562373e-01 7.275000000000e-08 1.331821362081e-01 7.300000000000e-08 1.762479051592e-15 7.325000000000e-08 3.993211525331e-01 7.350000000000e-08 5.414213562373e-01 7.375000000000e-08 -3.027339492126e-01 7.400000000000e-08 -1.200000000000e+00 7.425000000000e-08 -9.054678984251e-01 7.450000000000e-08 5.857864376268e-02 7.475000000000e-08 3.496605762665e-01 7.500000000000e-08 6.480926906249e-15 7.525000000000e-08 -3.363572758385e-02 7.550000000000e-08 2.585786437627e-01 7.575000000000e-08 2.198912367379e-01 7.600000000000e-08 -4.829470157119e-15 7.625000000000e-08 1.397824734759e-01 7.650000000000e-08 3.414213562373e-01 7.675000000000e-08 1.331821362081e-01 7.700000000000e-08 -1.398881011028e-14 7.725000000000e-08 3.993211525331e-01 7.750000000000e-08 5.414213562373e-01 7.775000000000e-08 -3.027339492126e-01 7.800000000000e-08 -1.200000000000e+00 7.825000000000e-08 -9.054678984252e-01 7.850000000000e-08 5.857864376271e-02 7.875000000000e-08 3.496605762665e-01 7.900000000000e-08 9.561795799584e-15 7.925000000000e-08 -3.363572758385e-02 7.950000000000e-08 2.585786437627e-01 7.975000000000e-08 2.198912367380e-01 8.000000000000e-08 -1.887379141863e-15 ]
VWL011 (wl011 0) vsource type=pwl wave=[ 0.000000000000e+00 0.000000000000e+00 2.500000000000e-10 1.801087632620e-01 5.000000000000e-10 -2.426406871193e-02 7.500000000000e-10 -2.336357275839e-01 1.000000000000e-09 9.714451465470e-17 1.250000000000e-09 5.033942373345e-02 1.500000000000e-09 -6.242640687119e-01 1.750000000000e-09 -1.105467898425e+00 2.000000000000e-09 -4.000000000000e-01 2.250000000000e-09 7.027339492126e-01 2.500000000000e-09 8.242640687119e-01 2.750000000000e-09 1.993211525331e-01 3.000000000000e-09 5.412337245048e-16 3.250000000000e-09 2.668178637919e-01 3.500000000000e-09 2.242640687119e-01 3.750000000000e-09 -6.021752652407e-02 4.000000000000e-09 1.193489751472e-15 4.250000000000e-09 1.801087632620e-01 4.500000000000e-09 -2.426406871193e-02 4.750000000000e-09 -2.336357275839e-01 5.000000000000e-09 -4.024558464266e-16 5.250000000000e-09 5.033942373345e-02 5.500000000000e-09 -6.242640687119e-01 5.750000000000e-09 -1.105467898425e+00 6.000000000000e-09 -4.000000000000e-01 6.250000000000e-09 7.027339492126e-01 6.500000000000e-09 8.242640687119e-01 6.750000000000e-09 1.993211525331e-01 7.000000000000e-09 8.743006318923e-16 7.250000000000e-09 2.668178637919e-01 7.500000000000e-09 2.242640687119e-01 7.750000000000e-09 -6.021752652407e-02 8.000000000000e-09 2.373101715136e-15 8.250000000000e-09 1.801087632620e-01 8.500000000000e-09 -2.426406871193e-02 8.750000000000e-09 -2.336357275839e-01 9.000000000000e-09 1.013078509970e-15 9.250000000000e-09 5.033942373345e-02 9.500000000000e-09 -6.242640687119e-01 9.750000000000e-09 -1.105467898425e+00 1.000000000000e-08 -4.000000000000e-01 1.025000000000e-08 7.027339492126e-01 1.050000000000e-08 8.242640687119e-01 1.075000000000e-08 1.993211525331e-01 1.100000000000e-08 7.632783294298e-16 1.125000000000e-08 2.668178637919e-01 1.150000000000e-08 2.242640687119e-01 1.175000000000e-08 -6.021752652407e-02 1.200000000000e-08 4.898859096159e-15 1.225000000000e-08 1.801087632620e-01 1.250000000000e-08 -2.426406871193e-02 1.275000000000e-08 -2.336357275839e-01 1.300000000000e-08 4.163336342344e-17 1.325000000000e-08 5.033942373345e-02 1.350000000000e-08 -6.242640687119e-01 1.375000000000e-08 -1.105467898425e+00 1.400000000000e-08 -4.000000000000e-01 1.425000000000e-08 7.027339492126e-01 1.450000000000e-08 8.242640687119e-01 1.475000000000e-08 1.993211525331e-01 1.500000000000e-08 3.191891195797e-15 1.525000000000e-08 2.668178637919e-01 1.550000000000e-08 2.242640687119e-01 1.575000000000e-08 -6.021752652407e-02 1.600000000000e-08 4.732325642465e-15 1.625000000000e-08 1.801087632620e-01 1.650000000000e-08 -2.426406871193e-02 1.675000000000e-08 -2.336357275839e-01 1.700000000000e-08 -1.110223024625e-16 1.725000000000e-08 5.033942373345e-02 1.750000000000e-08 -6.242640687119e-01 1.775000000000e-08 -1.105467898425e+00 1.800000000000e-08 -4.000000000000e-01 1.825000000000e-08 7.027339492126e-01 1.850000000000e-08 8.242640687119e-01 1.875000000000e-08 1.993211525331e-01 1.900000000000e-08 1.304512053935e-15 1.925000000000e-08 2.668178637919e-01 1.950000000000e-08 2.242640687119e-01 1.975000000000e-08 -6.021752652407e-02 2.000000000000e-08 1.387778780781e-15 2.025000000000e-08 1.801087632620e-01 2.050000000000e-08 -2.426406871193e-02 2.075000000000e-08 -2.336357275839e-01 2.100000000000e-08 4.024558464266e-16 2.125000000000e-08 5.033942373345e-02 2.150000000000e-08 -6.242640687119e-01 2.175000000000e-08 -1.105467898425e+00 2.200000000000e-08 -4.000000000000e-01 2.225000000000e-08 7.027339492126e-01 2.250000000000e-08 8.242640687119e-01 2.275000000000e-08 1.993211525331e-01 2.300000000000e-08 2.955968803064e-15 2.325000000000e-08 2.668178637919e-01 2.350000000000e-08 2.242640687119e-01 2.375000000000e-08 -6.021752652407e-02 2.400000000000e-08 9.769962616701e-15 2.425000000000e-08 1.801087632620e-01 2.450000000000e-08 -2.426406871193e-02 2.475000000000e-08 -2.336357275839e-01 2.500000000000e-08 -4.718447854657e-16 2.525000000000e-08 5.033942373345e-02 2.550000000000e-08 -6.242640687119e-01 2.575000000000e-08 -1.105467898425e+00 2.600000000000e-08 -4.000000000000e-01 2.625000000000e-08 7.027339492126e-01 2.650000000000e-08 8.242640687119e-01 2.675000000000e-08 1.993211525331e-01 2.700000000000e-08 -1.346145417358e-15 2.725000000000e-08 2.668178637919e-01 2.750000000000e-08 2.242640687119e-01 2.775000000000e-08 -6.021752652407e-02 2.800000000000e-08 7.494005416220e-15 2.825000000000e-08 1.801087632620e-01 2.850000000000e-08 -2.426406871193e-02 2.875000000000e-08 -2.336357275839e-01 2.900000000000e-08 -1.443289932013e-15 2.925000000000e-08 5.033942373345e-02 2.950000000000e-08 -6.242640687119e-01 2.975000000000e-08 -1.105467898425e+00 3.000000000000e-08 -4.000000000000e-01 3.025000000000e-08 7.027339492126e-01 3.050000000000e-08 8.242640687119e-01 3.075000000000e-08 1.993211525331e-01 3.100000000000e-08 -7.632783294298e-16 3.125000000000e-08 2.668178637919e-01 3.150000000000e-08 2.242640687119e-01 3.175000000000e-08 -6.021752652407e-02 3.200000000000e-08 9.478529072737e-15 3.225000000000e-08 1.801087632620e-01 3.250000000000e-08 -2.426406871193e-02 3.275000000000e-08 -2.336357275839e-01 3.300000000000e-08 4.052314039882e-15 3.325000000000e-08 5.033942373345e-02 3.350000000000e-08 -6.242640687119e-01 3.375000000000e-08 -1.105467898425e+00 3.400000000000e-08 -4.000000000000e-01 3.425000000000e-08 7.027339492126e-01 3.450000000000e-08 8.242640687119e-01 3.475000000000e-08 1.993211525331e-01 3.500000000000e-08 2.012279232133e-15 3.525000000000e-08 2.668178637919e-01 3.550000000000e-08 2.242640687119e-01 3.575000000000e-08 -6.021752652407e-02 3.600000000000e-08 2.942091015257e-15 3.625000000000e-08 1.801087632620e-01 3.650000000000e-08 -2.426406871193e-02 3.675000000000e-08 -2.336357275839e-01 3.700000000000e-08 -3.233524559221e-15 3.725000000000e-08 5.033942373346e-02 3.750000000000e-08 -6.242640687119e-01 3.775000000000e-08 -1.105467898425e+00 3.800000000000e-08 -4.000000000000e-01 3.825000000000e-08 7.027339492126e-01 3.850000000000e-08 8.242640687119e-01 3.875000000000e-08 1.993211525331e-01 3.900000000000e-08 7.591149930875e-15 3.925000000000e-08 2.668178637919e-01 3.950000000000e-08 2.242640687119e-01 3.975000000000e-08 -6.021752652407e-02 4.000000000000e-08 2.789435349371e-15 4.025000000000e-08 1.801087632620e-01 4.050000000000e-08 -2.426406871194e-02 4.075000000000e-08 -2.336357275839e-01 4.100000000000e-08 2.275957200482e-15 4.125000000000e-08 5.033942373345e-02 4.150000000000e-08 -6.242640687119e-01 4.175000000000e-08 -1.105467898425e+00 4.200000000000e-08 -4.000000000000e-01 4.225000000000e-08 7.027339492126e-01 4.250000000000e-08 8.242640687119e-01 4.275000000000e-08 1.993211525331e-01 4.300000000000e-08 -1.748601263785e-15 4.325000000000e-08 2.668178637919e-01 4.350000000000e-08 2.242640687119e-01 4.375000000000e-08 -6.021752652407e-02 4.400000000000e-08 6.911138328292e-15 4.425000000000e-08 1.801087632620e-01 4.450000000000e-08 -2.426406871193e-02 4.475000000000e-08 -2.336357275839e-01 4.500000000000e-08 7.716050021145e-15 4.525000000000e-08 5.033942373345e-02 4.550000000000e-08 -6.242640687119e-01 4.575000000000e-08 -1.105467898425e+00 4.600000000000e-08 -4.000000000000e-01 4.625000000000e-08 7.027339492126e-01 4.650000000000e-08 8.242640687119e-01 4.675000000000e-08 1.993211525331e-01 4.700000000000e-08 9.714451465470e-16 4.725000000000e-08 2.668178637919e-01 4.750000000000e-08 2.242640687119e-01 4.775000000000e-08 -6.021752652407e-02 4.800000000000e-08 1.955380302121e-14 4.825000000000e-08 1.801087632620e-01 4.850000000000e-08 -2.426406871194e-02 4.875000000000e-08 -2.336357275839e-01 4.900000000000e-08 4.302114220422e-16 4.925000000000e-08 5.033942373345e-02 4.950000000000e-08 -6.242640687119e-01 4.975000000000e-08 -1.105467898425e+00 5.000000000000e-08 -4.000000000000e-01 5.025000000000e-08 7.027339492126e-01 5.050000000000e-08 8.242640687119e-01 5.075000000000e-08 1.993211525331e-01 5.100000000000e-08 -5.551115123126e-16 5.125000000000e-08 2.668178637919e-01 5.150000000000e-08 2.242640687119e-01 5.175000000000e-08 -6.021752652407e-02 5.200000000000e-08 1.088018564133e-14 5.225000000000e-08 1.801087632620e-01 5.250000000000e-08 -2.426406871193e-02 5.275000000000e-08 -2.336357275839e-01 5.300000000000e-08 5.925815393937e-15 5.325000000000e-08 5.033942373345e-02 5.350000000000e-08 -6.242640687119e-01 5.375000000000e-08 -1.105467898425e+00 5.400000000000e-08 -4.000000000000e-01 5.425000000000e-08 7.027339492126e-01 5.450000000000e-08 8.242640687119e-01 5.475000000000e-08 1.993211525331e-01 5.500000000000e-08 5.065392549852e-15 5.525000000000e-08 2.668178637919e-01 5.550000000000e-08 2.242640687119e-01 5.575000000000e-08 -6.021752652407e-02 5.600000000000e-08 1.498801083244e-14 5.625000000000e-08 1.801087632620e-01 5.650000000000e-08 -2.426406871194e-02 5.675000000000e-08 -2.336357275839e-01 5.700000000000e-08 1.457167719821e-15 5.725000000000e-08 5.033942373345e-02 5.750000000000e-08 -6.242640687119e-01 5.775000000000e-08 -1.105467898425e+00 5.800000000000e-08 -4.000000000000e-01 5.825000000000e-08 7.027339492126e-01 5.850000000000e-08 8.242640687119e-01 5.875000000000e-08 1.993211525331e-01 5.900000000000e-08 4.968248035198e-15 5.925000000000e-08 2.668178637919e-01 5.950000000000e-08 2.242640687119e-01 5.975000000000e-08 -6.021752652407e-02 6.000000000000e-08 2.765843110097e-14 6.025000000000e-08 1.801087632620e-01 6.050000000000e-08 -2.426406871195e-02 6.075000000000e-08 -2.336357275839e-01 6.100000000000e-08 -2.942091015257e-15 6.125000000000e-08 5.033942373345e-02 6.150000000000e-08 -6.242640687119e-01 6.175000000000e-08 -1.105467898425e+00 6.200000000000e-08 -4.000000000000e-01 6.225000000000e-08 7.027339492126e-01 6.250000000000e-08 8.242640687119e-01 6.275000000000e-08 1.993211525331e-01 6.300000000000e-08 1.051936315832e-14 6.325000000000e-08 2.668178637919e-01 6.350000000000e-08 2.242640687119e-01 6.375000000000e-08 -6.021752652407e-02 6.400000000000e-08 1.897093593328e-14 6.425000000000e-08 1.801087632620e-01 6.450000000000e-08 -2.426406871195e-02 6.475000000000e-08 -2.336357275839e-01 6.500000000000e-08 -3.330669073875e-16 6.525000000000e-08 5.033942373345e-02 6.550000000000e-08 -6.242640687119e-01 6.575000000000e-08 -1.105467898425e+00 6.600000000000e-08 -4.000000000000e-01 6.625000000000e-08 7.027339492126e-01 6.650000000000e-08 8.242640687119e-01 6.675000000000e-08 1.993211525331e-01 6.700000000000e-08 6.161737786670e-15 6.725000000000e-08 2.668178637919e-01 6.750000000000e-08 2.242640687119e-01 6.775000000000e-08 -6.021752652407e-02 6.800000000000e-08 1.028344076559e-14 6.825000000000e-08 1.801087632620e-01 6.850000000000e-08 -2.426406871194e-02 6.875000000000e-08 -2.336357275839e-01 6.900000000000e-08 7.993605777301e-15 6.925000000000e-08 5.033942373346e-02 6.950000000000e-08 -6.242640687119e-01 6.975000000000e-08 -1.105467898425e+00 7.000000000000e-08 -4.000000000000e-01 7.025000000000e-08 7.027339492126e-01 7.050000000000e-08 8.242640687119e-01 7.075000000000e-08 1.993211525331e-01 7.100000000000e-08 1.817990202824e-15 7.125000000000e-08 2.668178637919e-01 7.150000000000e-08 2.242640687119e-01 7.175000000000e-08 -6.021752652407e-02 7.200000000000e-08 5.884182030513e-15 7.225000000000e-08 1.801087632620e-01 7.250000000000e-08 -2.426406871194e-02 7.275000000000e-08 -2.336357275839e-01 7.300000000000e-08 3.524958103185e-15 7.325000000000e-08 5.033942373344e-02 7.350000000000e-08 -6.242640687119e-01 7.375000000000e-08 -1.105467898425e+00 7.400000000000e-08 -4.000000000000e-01 7.425000000000e-08 7.027339492126e-01 7.450000000000e-08 8.242640687119e-01 7.475000000000e-08 1.993211525331e-01 7.500000000000e-08 7.369105325949e-15 7.525000000000e-08 2.668178637919e-01 7.550000000000e-08 2.242640687119e-01 7.575000000000e-08 -6.021752652407e-02 7.600000000000e-08 1.426636586643e-14 7.625000000000e-08 1.801087632620e-01 7.650000000000e-08 -2.426406871193e-02 7.675000000000e-08 -2.336357275839e-01 7.700000000000e-08 -6.647460359943e-15 7.725000000000e-08 5.033942373345e-02 7.750000000000e-08 -6.242640687119e-01 7.775000000000e-08 -1.105467898425e+00 7.800000000000e-08 -4.000000000000e-01 7.825000000000e-08 7.027339492126e-01 7.850000000000e-08 8.242640687119e-01 7.875000000000e-08 1.993211525331e-01 7.900000000000e-08 1.297573160031e-14 7.925000000000e-08 2.668178637919e-01 7.950000000000e-08 2.242640687119e-01 7.975000000000e-08 -6.021752652407e-02 8.000000000000e-08 5.578870698741e-15 ]
VWL012 (wl012 0) vsource type=pwl wave=[ 0.000000000000e+00 0.000000000000e+00 2.500000000000e-10 -1.397824734759e-01 5.000000000000e-10 -3.414213562373e-01 7.500000000000e-10 -1.331821362081e-01 1.000000000000e-09 9.714451465470e-17 1.250000000000e-09 -3.993211525331e-01 1.500000000000e-09 -5.414213562373e-01 1.750000000000e-09 3.027339492126e-01 2.000000000000e-09 1.200000000000e+00 2.250000000000e-09 9.054678984252e-01 2.500000000000e-09 -5.857864376269e-02 2.750000000000e-09 -3.496605762665e-01 3.000000000000e-09 -2.636779683485e-16 3.250000000000e-09 3.363572758386e-02 3.500000000000e-09 -2.585786437627e-01 3.750000000000e-09 -2.198912367380e-01 4.000000000000e-09 3.885780586188e-16 4.250000000000e-09 -1.397824734759e-01 4.500000000000e-09 -3.414213562373e-01 4.750000000000e-09 -1.331821362081e-01 5.000000000000e-09 6.522560269673e-16 5.250000000000e-09 -3.993211525331e-01 5.500000000000e-09 -5.414213562373e-01 5.750000000000e-09 3.027339492126e-01 6.000000000000e-09 1.200000000000e+00 6.250000000000e-09 9.054678984252e-01 6.500000000000e-09 -5.857864376269e-02 6.750000000000e-09 -3.496605762665e-01 7.000000000000e-09 2.775557561563e-17 7.250000000000e-09 3.363572758386e-02 7.500000000000e-09 -2.585786437627e-01 7.750000000000e-09 -2.198912367380e-01 8.000000000000e-09 8.326672684689e-16 8.250000000000e-09 -1.397824734759e-01 8.500000000000e-09 -3.414213562373e-01 8.750000000000e-09 -1.331821362081e-01 9.000000000000e-09 -4.579669976579e-16 9.250000000000e-09 -3.993211525331e-01 9.500000000000e-09 -5.414213562373e-01 9.750000000000e-09 3.027339492126e-01 1.000000000000e-08 1.200000000000e+00 1.025000000000e-08 9.054678984252e-01 1.050000000000e-08 -5.857864376269e-02 1.075000000000e-08 -3.496605762665e-01 1.100000000000e-08 -1.804112415016e-16 1.125000000000e-08 3.363572758386e-02 1.150000000000e-08 -2.585786437627e-01 1.175000000000e-08 -2.198912367380e-01 1.200000000000e-08 1.609823385706e-15 1.225000000000e-08 -1.397824734759e-01 1.250000000000e-08 -3.414213562373e-01 1.275000000000e-08 -1.331821362081e-01 1.300000000000e-08 1.706967900361e-15 1.325000000000e-08 -3.993211525331e-01 1.350000000000e-08 -5.414213562373e-01 1.375000000000e-08 3.027339492126e-01 1.400000000000e-08 1.200000000000e+00 1.425000000000e-08 9.054678984252e-01 1.450000000000e-08 -5.857864376269e-02 1.475000000000e-08 -3.496605762665e-01 1.500000000000e-08 -7.216449660064e-16 1.525000000000e-08 3.363572758386e-02 1.550000000000e-08 -2.585786437627e-01 1.575000000000e-08 -2.198912367380e-01 1.600000000000e-08 1.554312234475e-15 1.625000000000e-08 -1.397824734759e-01 1.650000000000e-08 -3.414213562373e-01 1.675000000000e-08 -1.331821362081e-01 1.700000000000e-08 1.804112415016e-15 1.725000000000e-08 -3.993211525331e-01 1.750000000000e-08 -5.414213562373e-01 1.775000000000e-08 3.027339492126e-01 1.800000000000e-08 1.200000000000e+00 1.825000000000e-08 9.054678984252e-01 1.850000000000e-08 -5.857864376269e-02 1.875000000000e-08 -3.496605762665e-01 1.900000000000e-08 -2.720046410332e-15 1.925000000000e-08 3.363572758386e-02 1.950000000000e-08 -2.585786437627e-01 1.975000000000e-08 -2.198912367380e-01 2.000000000000e-08 4.440892098501e-16 2.025000000000e-08 -1.397824734759e-01 2.050000000000e-08 -3.414213562373e-01 2.075000000000e-08 -1.331821362081e-01 2.100000000000e-08 -1.804112415016e-16 2.125000000000e-08 -3.993211525331e-01 2.150000000000e-08 -5.414213562373e-01 2.175000000000e-08 3.027339492126e-01 2.200000000000e-08 1.200000000000e+00 2.225000000000e-08 9.054678984252e-01 2.250000000000e-08 -5.857864376270e-02 2.275000000000e-08 -3.496605762665e-01 2.300000000000e-08 -1.137978600241e-15 2.325000000000e-08 3.363572758386e-02 2.350000000000e-08 -2.585786437627e-01 2.375000000000e-08 -2.198912367380e-01 2.400000000000e-08 3.275157922644e-15 2.425000000000e-08 -1.397824734759e-01 2.450000000000e-08 -3.414213562373e-01 2.475000000000e-08 -1.331821362081e-01 2.500000000000e-08 2.040034807749e-15 2.525000000000e-08 -3.993211525331e-01 2.550000000000e-08 -5.414213562373e-01 2.575000000000e-08 3.027339492126e-01 2.600000000000e-08 1.200000000000e+00 2.625000000000e-08 9.054678984252e-01 2.650000000000e-08 -5.857864376270e-02 2.675000000000e-08 -3.496605762665e-01 2.700000000000e-08 -2.775557561563e-15 2.725000000000e-08 3.363572758386e-02 2.750000000000e-08 -2.585786437627e-01 2.775000000000e-08 -2.198912367380e-01 2.800000000000e-08 2.442490654175e-15 2.825000000000e-08 -1.397824734759e-01 2.850000000000e-08 -3.414213562373e-01 2.875000000000e-08 -1.331821362081e-01 2.900000000000e-08 4.260480856999e-15 2.925000000000e-08 -3.993211525331e-01 2.950000000000e-08 -5.414213562373e-01 2.975000000000e-08 3.027339492126e-01 3.000000000000e-08 1.200000000000e+00 3.025000000000e-08 9.054678984252e-01 3.050000000000e-08 -5.857864376269e-02 3.075000000000e-08 -3.496605762665e-01 3.100000000000e-08 -5.065392549852e-15 3.125000000000e-08 3.363572758385e-02 3.150000000000e-08 -2.585786437627e-01 3.175000000000e-08 -2.198912367380e-01 3.200000000000e-08 3.219646771413e-15 3.225000000000e-08 -1.397824734759e-01 3.250000000000e-08 -3.414213562373e-01 3.275000000000e-08 -1.331821362081e-01 3.300000000000e-08 1.471045507628e-15 3.325000000000e-08 -3.993211525331e-01 3.350000000000e-08 -5.414213562373e-01 3.375000000000e-08 3.027339492126e-01 3.400000000000e-08 1.200000000000e+00 3.425000000000e-08 9.054678984252e-01 3.450000000000e-08 -5.857864376270e-02 3.475000000000e-08 -3.496605762665e-01 3.500000000000e-08 4.440892098501e-16 3.525000000000e-08 3.363572758385e-02 3.550000000000e-08 -2.585786437627e-01 3.575000000000e-08 -2.198912367380e-01 3.600000000000e-08 9.992007221626e-16 3.625000000000e-08 -1.397824734759e-01 3.650000000000e-08 -3.414213562373e-01 3.675000000000e-08 -1.331821362081e-01 3.700000000000e-08 8.701372955500e-15 3.725000000000e-08 -3.993211525331e-01 3.750000000000e-08 -5.414213562373e-01 3.775000000000e-08 3.027339492126e-01 3.800000000000e-08 1.200000000000e+00 3.825000000000e-08 9.054678984252e-01 3.850000000000e-08 -5.857864376268e-02 3.875000000000e-08 -3.496605762666e-01 3.900000000000e-08 -2.622901895677e-15 3.925000000000e-08 3.363572758385e-02 3.950000000000e-08 -2.585786437627e-01 3.975000000000e-08 -2.198912367380e-01 4.000000000000e-08 8.881784197001e-16 4.025000000000e-08 -1.397824734759e-01 4.050000000000e-08 -3.414213562373e-01 4.075000000000e-08 -1.331821362081e-01 4.100000000000e-08 5.981326545168e-15 4.125000000000e-08 -3.993211525331e-01 4.150000000000e-08 -5.414213562373e-01 4.175000000000e-08 3.027339492126e-01 4.200000000000e-08 1.200000000000e+00 4.225000000000e-08 9.054678984252e-01 4.250000000000e-08 -5.857864376269e-02 4.275000000000e-08 -3.496605762666e-01 4.300000000000e-08 -3.538835890993e-15 4.325000000000e-08 3.363572758386e-02 4.350000000000e-08 -2.585786437627e-01 4.375000000000e-08 -2.198912367380e-01 4.400000000000e-08 2.331468351713e-15 4.425000000000e-08 -1.397824734759e-01 4.450000000000e-08 -3.414213562373e-01 4.475000000000e-08 -1.331821362081e-01 4.500000000000e-08 3.191891195797e-15 4.525000000000e-08 -3.993211525331e-01 4.550000000000e-08 -5.414213562373e-01 4.575000000000e-08 3.027339492126e-01 4.600000000000e-08 1.200000000000e+00 4.625000000000e-08 9.054678984252e-01 4.650000000000e-08 -5.857864376270e-02 4.675000000000e-08 -3.496605762665e-01 4.700000000000e-08 1.970645868710e-15 4.725000000000e-08 3.363572758386e-02 4.750000000000e-08 -2.585786437627e-01 4.775000000000e-08 -2.198912367380e-01 4.800000000000e-08 6.550315845288e-15 4.825000000000e-08 -1.397824734759e-01 4.850000000000e-08 -3.414213562373e-01 4.875000000000e-08 -1.331821362081e-01 4.900000000000e-08 1.042221864367e-14 4.925000000000e-08 -3.993211525331e-01 4.950000000000e-08 -5.414213562373e-01 4.975000000000e-08 3.027339492126e-01 5.000000000000e-08 1.200000000000e+00 5.025000000000e-08 9.054678984252e-01 5.050000000000e-08 -5.857864376268e-02 5.075000000000e-08 -3.496605762666e-01 5.100000000000e-08 -8.146261443187e-15 5.125000000000e-08 3.363572758385e-02 5.150000000000e-08 -2.585786437627e-01 5.175000000000e-08 -2.198912367380e-01 5.200000000000e-08 3.608224830032e-15 5.225000000000e-08 -1.397824734759e-01 5.250000000000e-08 -3.414213562373e-01 5.275000000000e-08 -1.331821362081e-01 5.300000000000e-08 7.688294445529e-15 5.325000000000e-08 -3.993211525331e-01 5.350000000000e-08 -5.414213562373e-01 5.375000000000e-08 3.027339492126e-01 5.400000000000e-08 1.200000000000e+00 5.425000000000e-08 9.054678984252e-01 5.450000000000e-08 -5.857864376270e-02 5.475000000000e-08 -3.496605762665e-01 5.500000000000e-08 -1.121325254871e-14 5.525000000000e-08 3.363572758385e-02 5.550000000000e-08 -2.585786437627e-01 5.575000000000e-08 -2.198912367379e-01 5.600000000000e-08 5.051514762044e-15 5.625000000000e-08 -1.397824734759e-01 5.650000000000e-08 -3.414213562373e-01 5.675000000000e-08 -1.331821362081e-01 5.700000000000e-08 6.411537967210e-15 5.725000000000e-08 -3.993211525331e-01 5.750000000000e-08 -5.414213562373e-01 5.775000000000e-08 3.027339492126e-01 5.800000000000e-08 1.200000000000e+00 5.825000000000e-08 9.054678984252e-01 5.850000000000e-08 -5.857864376269e-02 5.875000000000e-08 -3.496605762665e-01 5.900000000000e-08 2.803313137179e-15 5.925000000000e-08 3.363572758384e-02 5.950000000000e-08 -2.585786437627e-01 5.975000000000e-08 -2.198912367380e-01 6.000000000000e-08 9.214851104389e-15 6.025000000000e-08 -1.397824734759e-01 6.050000000000e-08 -3.414213562373e-01 6.075000000000e-08 -1.331821362081e-01 6.100000000000e-08 5.051514762044e-15 6.125000000000e-08 -3.993211525331e-01 6.150000000000e-08 -5.414213562373e-01 6.175000000000e-08 3.027339492126e-01 6.200000000000e-08 1.200000000000e+00 6.225000000000e-08 9.054678984252e-01 6.250000000000e-08 -5.857864376272e-02 6.275000000000e-08 -3.496605762665e-01 6.300000000000e-08 -2.775557561563e-16 6.325000000000e-08 3.363572758385e-02 6.350000000000e-08 -2.585786437627e-01 6.375000000000e-08 -2.198912367380e-01 6.400000000000e-08 6.272760089132e-15 6.425000000000e-08 -1.397824734759e-01 6.450000000000e-08 -3.414213562373e-01 6.475000000000e-08 -1.331821362081e-01 6.500000000000e-08 1.079691891448e-14 6.525000000000e-08 -3.993211525331e-01 6.550000000000e-08 -5.414213562373e-01 6.575000000000e-08 3.027339492126e-01 6.600000000000e-08 1.200000000000e+00 6.625000000000e-08 9.054678984252e-01 6.650000000000e-08 -5.857864376270e-02 6.675000000000e-08 -3.496605762666e-01 6.700000000000e-08 -1.859623566247e-15 6.725000000000e-08 3.363572758384e-02 6.750000000000e-08 -2.585786437627e-01 6.775000000000e-08 -2.198912367380e-01 6.800000000000e-08 3.441691376338e-15 6.825000000000e-08 -1.397824734759e-01 6.850000000000e-08 -3.414213562373e-01 6.875000000000e-08 -1.331821362081e-01 6.900000000000e-08 -4.163336342344e-16 6.925000000000e-08 -3.993211525331e-01 6.950000000000e-08 -5.414213562373e-01 6.975000000000e-08 3.027339492126e-01 7.000000000000e-08 1.200000000000e+00 7.025000000000e-08 9.054678984251e-01 7.050000000000e-08 -5.857864376269e-02 7.075000000000e-08 -3.496605762665e-01 7.100000000000e-08 -3.511080315377e-15 7.125000000000e-08 3.363572758384e-02 7.150000000000e-08 -2.585786437627e-01 7.175000000000e-08 -2.198912367379e-01 7.200000000000e-08 1.942890293094e-15 7.225000000000e-08 -1.397824734759e-01 7.250000000000e-08 -3.414213562373e-01 7.275000000000e-08 -1.331821362081e-01 7.300000000000e-08 -1.762479051592e-15 7.325000000000e-08 -3.993211525331e-01 7.350000000000e-08 -5.414213562373e-01 7.375000000000e-08 3.027339492126e-01 7.400000000000e-08 1.200000000000e+00 7.425000000000e-08 9.054678984251e-01 7.450000000000e-08 -5.857864376268e-02 7.475000000000e-08 -3.496605762665e-01 7.500000000000e-08 -6.480926906249e-15 7.525000000000e-08 3.363572758385e-02 7.550000000000e-08 -2.585786437627e-01 7.575000000000e-08 -2.198912367379e-01 7.600000000000e-08 4.829470157119e-15 7.625000000000e-08 -1.397824734759e-01 7.650000000000e-08 -3.414213562373e-01 7.675000000000e-08 -1.331821362081e-01 7.700000000000e-08 1.398881011028e-14 7.725000000000e-08 -3.993211525331e-01 7.750000000000e-08 -5.414213562373e-01 7.775000000000e-08 3.027339492126e-01 7.800000000000e-08 1.200000000000e+00 7.825000000000e-08 9.054678984252e-01 7.850000000000e-08 -5.857864376271e-02 7.875000000000e-08 -3.496605762665e-01 7.900000000000e-08 -9.561795799584e-15 7.925000000000e-08 3.363572758385e-02 7.950000000000e-08 -2.585786437627e-01 7.975000000000e-08 -2.198912367380e-01 8.000000000000e-08 1.887379141863e-15 ]
VWL013 (wl013 0) vsource type=pwl wave=[ 0.000000000000e+00 0.000000000000e+00 2.500000000000e-10 -1.801087632620e-01 5.000000000000e-10 2.426406871193e-02 7.500000000000e-10 2.336357275839e-01 1.000000000000e-09 -9.714451465470e-17 1.250000000000e-09 -5.033942373345e-02 1.500000000000e-09 6.242640687119e-01 1.750000000000e-09 1.105467898425e+00 2.000000000000e-09 4.000000000000e-01 2.250000000000e-09 -7.027339492126e-01 2.500000000000e-09 -8.242640687119e-01 2.750000000000e-09 -1.993211525331e-01 3.000000000000e-09 -5.412337245048e-16 3.250000000000e-09 -2.668178637919e-01 3.500000000000e-09 -2.242640687119e-01 3.750000000000e-09 6.021752652407e-02 4.000000000000e-09 -1.193489751472e-15 4.250000000000e-09 -1.801087632620e-01 4.500000000000e-09 2.426406871193e-02 4.750000000000e-09 2.336357275839e-01 5.000000000000e-09 4.024558464266e-16 5.250000000000e-09 -5.033942373345e-02 5.500000000000e-09 6.242640687119e-01 5.750000000000e-09 1.105467898425e+00 6.000000000000e-09 4.000000000000e-01 6.250000000000e-09 -7.027339492126e-01 6.500000000000e-09 -8.242640687119e-01 6.750000000000e-09 -1.993211525331e-01 7.000000000000e-09 -8.743006318923e-16 7.250000000000e-09 -2.668178637919e-01 7.500000000000e-09 -2.242640687119e-01 7.750000000000e-09 6.021752652407e-02 8.000000000000e-09 -2.373101715136e-15 8.250000000000e-09 -1.801087632620e-01 8.500000000000e-09 2.426406871193e-02 8.750000000000e-09 2.336357275839e-01 9.000000000000e-09 -1.013078509970e-15 9.250000000000e-09 -5.033942373345e-02 9.500000000000e-09 6.242640687119e-01 9.750000000000e-09 1.105467898425e+00 1.000000000000e-08 4.000000000000e-01 1.025000000000e-08 -7.027339492126e-01 1.050000000000e-08 -8.242640687119e-01 1.075000000000e-08 -1.993211525331e-01 1.100000000000e-08 -7.632783294298e-16 1.125000000000e-08 -2.668178637919e-01 1.150000000000e-08 -2.242640687119e-01 1.175000000000e-08 6.021752652407e-02 1.200000000000e-08 -4.898859096159e-15 1.225000000000e-08 -1.801087632620e-01 1.250000000000e-08 2.426406871193e-02 1.275000000000e-08 2.336357275839e-01 1.300000000000e-08 -4.163336342344e-17 1.325000000000e-08 -5.033942373345e-02 1.350000000000e-08 6.242640687119e-01 1.375000000000e-08 1.105467898425e+00 1.400000000000e-08 4.000000000000e-01 1.425000000000e-08 -7.027339492126e-01 1.450000000000e-08 -8.242640687119e-01 1.475000000000e-08 -1.993211525331e-01 1.500000000000e-08 -3.191891195797e-15 1.525000000000e-08 -2.668178637919e-01 1.550000000000e-08 -2.242640687119e-01 1.575000000000e-08 6.021752652407e-02 1.600000000000e-08 -4.732325642465e-15 1.625000000000e-08 -1.801087632620e-01 1.650000000000e-08 2.426406871193e-02 1.675000000000e-08 2.336357275839e-01 1.700000000000e-08 1.110223024625e-16 1.725000000000e-08 -5.033942373345e-02 1.750000000000e-08 6.242640687119e-01 1.775000000000e-08 1.105467898425e+00 1.800000000000e-08 4.000000000000e-01 1.825000000000e-08 -7.027339492126e-01 1.850000000000e-08 -8.242640687119e-01 1.875000000000e-08 -1.993211525331e-01 1.900000000000e-08 -1.304512053935e-15 1.925000000000e-08 -2.668178637919e-01 1.950000000000e-08 -2.242640687119e-01 1.975000000000e-08 6.021752652407e-02 2.000000000000e-08 -1.387778780781e-15 2.025000000000e-08 -1.801087632620e-01 2.050000000000e-08 2.426406871193e-02 2.075000000000e-08 2.336357275839e-01 2.100000000000e-08 -4.024558464266e-16 2.125000000000e-08 -5.033942373345e-02 2.150000000000e-08 6.242640687119e-01 2.175000000000e-08 1.105467898425e+00 2.200000000000e-08 4.000000000000e-01 2.225000000000e-08 -7.027339492126e-01 2.250000000000e-08 -8.242640687119e-01 2.275000000000e-08 -1.993211525331e-01 2.300000000000e-08 -2.955968803064e-15 2.325000000000e-08 -2.668178637919e-01 2.350000000000e-08 -2.242640687119e-01 2.375000000000e-08 6.021752652407e-02 2.400000000000e-08 -9.769962616701e-15 2.425000000000e-08 -1.801087632620e-01 2.450000000000e-08 2.426406871193e-02 2.475000000000e-08 2.336357275839e-01 2.500000000000e-08 4.718447854657e-16 2.525000000000e-08 -5.033942373345e-02 2.550000000000e-08 6.242640687119e-01 2.575000000000e-08 1.105467898425e+00 2.600000000000e-08 4.000000000000e-01 2.625000000000e-08 -7.027339492126e-01 2.650000000000e-08 -8.242640687119e-01 2.675000000000e-08 -1.993211525331e-01 2.700000000000e-08 1.346145417358e-15 2.725000000000e-08 -2.668178637919e-01 2.750000000000e-08 -2.242640687119e-01 2.775000000000e-08 6.021752652407e-02 2.800000000000e-08 -7.494005416220e-15 2.825000000000e-08 -1.801087632620e-01 2.850000000000e-08 2.426406871193e-02 2.875000000000e-08 2.336357275839e-01 2.900000000000e-08 1.443289932013e-15 2.925000000000e-08 -5.033942373345e-02 2.950000000000e-08 6.242640687119e-01 2.975000000000e-08 1.105467898425e+00 3.000000000000e-08 4.000000000000e-01 3.025000000000e-08 -7.027339492126e-01 3.050000000000e-08 -8.242640687119e-01 3.075000000000e-08 -1.993211525331e-01 3.100000000000e-08 7.632783294298e-16 3.125000000000e-08 -2.668178637919e-01 3.150000000000e-08 -2.242640687119e-01 3.175000000000e-08 6.021752652407e-02 3.200000000000e-08 -9.478529072737e-15 3.225000000000e-08 -1.801087632620e-01 3.250000000000e-08 2.426406871193e-02 3.275000000000e-08 2.336357275839e-01 3.300000000000e-08 -4.052314039882e-15 3.325000000000e-08 -5.033942373345e-02 3.350000000000e-08 6.242640687119e-01 3.375000000000e-08 1.105467898425e+00 3.400000000000e-08 4.000000000000e-01 3.425000000000e-08 -7.027339492126e-01 3.450000000000e-08 -8.242640687119e-01 3.475000000000e-08 -1.993211525331e-01 3.500000000000e-08 -2.012279232133e-15 3.525000000000e-08 -2.668178637919e-01 3.550000000000e-08 -2.242640687119e-01 3.575000000000e-08 6.021752652407e-02 3.600000000000e-08 -2.942091015257e-15 3.625000000000e-08 -1.801087632620e-01 3.650000000000e-08 2.426406871193e-02 3.675000000000e-08 2.336357275839e-01 3.700000000000e-08 3.233524559221e-15 3.725000000000e-08 -5.033942373346e-02 3.750000000000e-08 6.242640687119e-01 3.775000000000e-08 1.105467898425e+00 3.800000000000e-08 4.000000000000e-01 3.825000000000e-08 -7.027339492126e-01 3.850000000000e-08 -8.242640687119e-01 3.875000000000e-08 -1.993211525331e-01 3.900000000000e-08 -7.591149930875e-15 3.925000000000e-08 -2.668178637919e-01 3.950000000000e-08 -2.242640687119e-01 3.975000000000e-08 6.021752652407e-02 4.000000000000e-08 -2.789435349371e-15 4.025000000000e-08 -1.801087632620e-01 4.050000000000e-08 2.426406871194e-02 4.075000000000e-08 2.336357275839e-01 4.100000000000e-08 -2.275957200482e-15 4.125000000000e-08 -5.033942373345e-02 4.150000000000e-08 6.242640687119e-01 4.175000000000e-08 1.105467898425e+00 4.200000000000e-08 4.000000000000e-01 4.225000000000e-08 -7.027339492126e-01 4.250000000000e-08 -8.242640687119e-01 4.275000000000e-08 -1.993211525331e-01 4.300000000000e-08 1.748601263785e-15 4.325000000000e-08 -2.668178637919e-01 4.350000000000e-08 -2.242640687119e-01 4.375000000000e-08 6.021752652407e-02 4.400000000000e-08 -6.911138328292e-15 4.425000000000e-08 -1.801087632620e-01 4.450000000000e-08 2.426406871193e-02 4.475000000000e-08 2.336357275839e-01 4.500000000000e-08 -7.716050021145e-15 4.525000000000e-08 -5.033942373345e-02 4.550000000000e-08 6.242640687119e-01 4.575000000000e-08 1.105467898425e+00 4.600000000000e-08 4.000000000000e-01 4.625000000000e-08 -7.027339492126e-01 4.650000000000e-08 -8.242640687119e-01 4.675000000000e-08 -1.993211525331e-01 4.700000000000e-08 -9.714451465470e-16 4.725000000000e-08 -2.668178637919e-01 4.750000000000e-08 -2.242640687119e-01 4.775000000000e-08 6.021752652407e-02 4.800000000000e-08 -1.955380302121e-14 4.825000000000e-08 -1.801087632620e-01 4.850000000000e-08 2.426406871194e-02 4.875000000000e-08 2.336357275839e-01 4.900000000000e-08 -4.302114220422e-16 4.925000000000e-08 -5.033942373345e-02 4.950000000000e-08 6.242640687119e-01 4.975000000000e-08 1.105467898425e+00 5.000000000000e-08 4.000000000000e-01 5.025000000000e-08 -7.027339492126e-01 5.050000000000e-08 -8.242640687119e-01 5.075000000000e-08 -1.993211525331e-01 5.100000000000e-08 5.551115123126e-16 5.125000000000e-08 -2.668178637919e-01 5.150000000000e-08 -2.242640687119e-01 5.175000000000e-08 6.021752652407e-02 5.200000000000e-08 -1.088018564133e-14 5.225000000000e-08 -1.801087632620e-01 5.250000000000e-08 2.426406871193e-02 5.275000000000e-08 2.336357275839e-01 5.300000000000e-08 -5.925815393937e-15 5.325000000000e-08 -5.033942373345e-02 5.350000000000e-08 6.242640687119e-01 5.375000000000e-08 1.105467898425e+00 5.400000000000e-08 4.000000000000e-01 5.425000000000e-08 -7.027339492126e-01 5.450000000000e-08 -8.242640687119e-01 5.475000000000e-08 -1.993211525331e-01 5.500000000000e-08 -5.065392549852e-15 5.525000000000e-08 -2.668178637919e-01 5.550000000000e-08 -2.242640687119e-01 5.575000000000e-08 6.021752652407e-02 5.600000000000e-08 -1.498801083244e-14 5.625000000000e-08 -1.801087632620e-01 5.650000000000e-08 2.426406871194e-02 5.675000000000e-08 2.336357275839e-01 5.700000000000e-08 -1.457167719821e-15 5.725000000000e-08 -5.033942373345e-02 5.750000000000e-08 6.242640687119e-01 5.775000000000e-08 1.105467898425e+00 5.800000000000e-08 4.000000000000e-01 5.825000000000e-08 -7.027339492126e-01 5.850000000000e-08 -8.242640687119e-01 5.875000000000e-08 -1.993211525331e-01 5.900000000000e-08 -4.968248035198e-15 5.925000000000e-08 -2.668178637919e-01 5.950000000000e-08 -2.242640687119e-01 5.975000000000e-08 6.021752652407e-02 6.000000000000e-08 -2.765843110097e-14 6.025000000000e-08 -1.801087632620e-01 6.050000000000e-08 2.426406871195e-02 6.075000000000e-08 2.336357275839e-01 6.100000000000e-08 2.942091015257e-15 6.125000000000e-08 -5.033942373345e-02 6.150000000000e-08 6.242640687119e-01 6.175000000000e-08 1.105467898425e+00 6.200000000000e-08 4.000000000000e-01 6.225000000000e-08 -7.027339492126e-01 6.250000000000e-08 -8.242640687119e-01 6.275000000000e-08 -1.993211525331e-01 6.300000000000e-08 -1.051936315832e-14 6.325000000000e-08 -2.668178637919e-01 6.350000000000e-08 -2.242640687119e-01 6.375000000000e-08 6.021752652407e-02 6.400000000000e-08 -1.897093593328e-14 6.425000000000e-08 -1.801087632620e-01 6.450000000000e-08 2.426406871195e-02 6.475000000000e-08 2.336357275839e-01 6.500000000000e-08 3.330669073875e-16 6.525000000000e-08 -5.033942373345e-02 6.550000000000e-08 6.242640687119e-01 6.575000000000e-08 1.105467898425e+00 6.600000000000e-08 4.000000000000e-01 6.625000000000e-08 -7.027339492126e-01 6.650000000000e-08 -8.242640687119e-01 6.675000000000e-08 -1.993211525331e-01 6.700000000000e-08 -6.161737786670e-15 6.725000000000e-08 -2.668178637919e-01 6.750000000000e-08 -2.242640687119e-01 6.775000000000e-08 6.021752652407e-02 6.800000000000e-08 -1.028344076559e-14 6.825000000000e-08 -1.801087632620e-01 6.850000000000e-08 2.426406871194e-02 6.875000000000e-08 2.336357275839e-01 6.900000000000e-08 -7.993605777301e-15 6.925000000000e-08 -5.033942373346e-02 6.950000000000e-08 6.242640687119e-01 6.975000000000e-08 1.105467898425e+00 7.000000000000e-08 4.000000000000e-01 7.025000000000e-08 -7.027339492126e-01 7.050000000000e-08 -8.242640687119e-01 7.075000000000e-08 -1.993211525331e-01 7.100000000000e-08 -1.817990202824e-15 7.125000000000e-08 -2.668178637919e-01 7.150000000000e-08 -2.242640687119e-01 7.175000000000e-08 6.021752652407e-02 7.200000000000e-08 -5.884182030513e-15 7.225000000000e-08 -1.801087632620e-01 7.250000000000e-08 2.426406871194e-02 7.275000000000e-08 2.336357275839e-01 7.300000000000e-08 -3.524958103185e-15 7.325000000000e-08 -5.033942373344e-02 7.350000000000e-08 6.242640687119e-01 7.375000000000e-08 1.105467898425e+00 7.400000000000e-08 4.000000000000e-01 7.425000000000e-08 -7.027339492126e-01 7.450000000000e-08 -8.242640687119e-01 7.475000000000e-08 -1.993211525331e-01 7.500000000000e-08 -7.369105325949e-15 7.525000000000e-08 -2.668178637919e-01 7.550000000000e-08 -2.242640687119e-01 7.575000000000e-08 6.021752652407e-02 7.600000000000e-08 -1.426636586643e-14 7.625000000000e-08 -1.801087632620e-01 7.650000000000e-08 2.426406871193e-02 7.675000000000e-08 2.336357275839e-01 7.700000000000e-08 6.647460359943e-15 7.725000000000e-08 -5.033942373345e-02 7.750000000000e-08 6.242640687119e-01 7.775000000000e-08 1.105467898425e+00 7.800000000000e-08 4.000000000000e-01 7.825000000000e-08 -7.027339492126e-01 7.850000000000e-08 -8.242640687119e-01 7.875000000000e-08 -1.993211525331e-01 7.900000000000e-08 -1.297573160031e-14 7.925000000000e-08 -2.668178637919e-01 7.950000000000e-08 -2.242640687119e-01 7.975000000000e-08 6.021752652407e-02 8.000000000000e-08 -5.578870698741e-15 ]
VWL014 (wl014 0) vsource type=pwl wave=[ 0.000000000000e+00 0.000000000000e+00 2.500000000000e-10 1.397824734759e-01 5.000000000000e-10 3.414213562373e-01 7.500000000000e-10 1.331821362081e-01 1.000000000000e-09 -9.714451465470e-17 1.250000000000e-09 3.993211525331e-01 1.500000000000e-09 5.414213562373e-01 1.750000000000e-09 -3.027339492126e-01 2.000000000000e-09 -1.200000000000e+00 2.250000000000e-09 -9.054678984252e-01 2.500000000000e-09 5.857864376269e-02 2.750000000000e-09 3.496605762665e-01 3.000000000000e-09 2.636779683485e-16 3.250000000000e-09 -3.363572758386e-02 3.500000000000e-09 2.585786437627e-01 3.750000000000e-09 2.198912367380e-01 4.000000000000e-09 -3.885780586188e-16 4.250000000000e-09 1.397824734759e-01 4.500000000000e-09 3.414213562373e-01 4.750000000000e-09 1.331821362081e-01 5.000000000000e-09 -6.522560269673e-16 5.250000000000e-09 3.993211525331e-01 5.500000000000e-09 5.414213562373e-01 5.750000000000e-09 -3.027339492126e-01 6.000000000000e-09 -1.200000000000e+00 6.250000000000e-09 -9.054678984252e-01 6.500000000000e-09 5.857864376269e-02 6.750000000000e-09 3.496605762665e-01 7.000000000000e-09 -2.775557561563e-17 7.250000000000e-09 -3.363572758386e-02 7.500000000000e-09 2.585786437627e-01 7.750000000000e-09 2.198912367380e-01 8.000000000000e-09 -8.326672684689e-16 8.250000000000e-09 1.397824734759e-01 8.500000000000e-09 3.414213562373e-01 8.750000000000e-09 1.331821362081e-01 9.000000000000e-09 4.579669976579e-16 9.250000000000e-09 3.993211525331e-01 9.500000000000e-09 5.414213562373e-01 9.750000000000e-09 -3.027339492126e-01 1.000000000000e-08 -1.200000000000e+00 1.025000000000e-08 -9.054678984252e-01 1.050000000000e-08 5.857864376269e-02 1.075000000000e-08 3.496605762665e-01 1.100000000000e-08 1.804112415016e-16 1.125000000000e-08 -3.363572758386e-02 1.150000000000e-08 2.585786437627e-01 1.175000000000e-08 2.198912367380e-01 1.200000000000e-08 -1.609823385706e-15 1.225000000000e-08 1.397824734759e-01 1.250000000000e-08 3.414213562373e-01 1.275000000000e-08 1.331821362081e-01 1.300000000000e-08 -1.706967900361e-15 1.325000000000e-08 3.993211525331e-01 1.350000000000e-08 5.414213562373e-01 1.375000000000e-08 -3.027339492126e-01 1.400000000000e-08 -1.200000000000e+00 1.425000000000e-08 -9.054678984252e-01 1.450000000000e-08 5.857864376269e-02 1.475000000000e-08 3.496605762665e-01 1.500000000000e-08 7.216449660064e-16 1.525000000000e-08 -3.363572758386e-02 1.550000000000e-08 2.585786437627e-01 1.575000000000e-08 2.198912367380e-01 1.600000000000e-08 -1.554312234475e-15 1.625000000000e-08 1.397824734759e-01 1.650000000000e-08 3.414213562373e-01 1.675000000000e-08 1.331821362081e-01 1.700000000000e-08 -1.804112415016e-15 1.725000000000e-08 3.993211525331e-01 1.750000000000e-08 5.414213562373e-01 1.775000000000e-08 -3.027339492126e-01 1.800000000000e-08 -1.200000000000e+00 1.825000000000e-08 -9.054678984252e-01 1.850000000000e-08 5.857864376269e-02 1.875000000000e-08 3.496605762665e-01 1.900000000000e-08 2.720046410332e-15 1.925000000000e-08 -3.363572758386e-02 1.950000000000e-08 2.585786437627e-01 1.975000000000e-08 2.198912367380e-01 2.000000000000e-08 -4.440892098501e-16 2.025000000000e-08 1.397824734759e-01 2.050000000000e-08 3.414213562373e-01 2.075000000000e-08 1.331821362081e-01 2.100000000000e-08 1.804112415016e-16 2.125000000000e-08 3.993211525331e-01 2.150000000000e-08 5.414213562373e-01 2.175000000000e-08 -3.027339492126e-01 2.200000000000e-08 -1.200000000000e+00 2.225000000000e-08 -9.054678984252e-01 2.250000000000e-08 5.857864376270e-02 2.275000000000e-08 3.496605762665e-01 2.300000000000e-08 1.137978600241e-15 2.325000000000e-08 -3.363572758386e-02 2.350000000000e-08 2.585786437627e-01 2.375000000000e-08 2.198912367380e-01 2.400000000000e-08 -3.275157922644e-15 2.425000000000e-08 1.397824734759e-01 2.450000000000e-08 3.414213562373e-01 2.475000000000e-08 1.331821362081e-01 2.500000000000e-08 -2.040034807749e-15 2.525000000000e-08 3.993211525331e-01 2.550000000000e-08 5.414213562373e-01 2.575000000000e-08 -3.027339492126e-01 2.600000000000e-08 -1.200000000000e+00 2.625000000000e-08 -9.054678984252e-01 2.650000000000e-08 5.857864376270e-02 2.675000000000e-08 3.496605762665e-01 2.700000000000e-08 2.775557561563e-15 2.725000000000e-08 -3.363572758386e-02 2.750000000000e-08 2.585786437627e-01 2.775000000000e-08 2.198912367380e-01 2.800000000000e-08 -2.442490654175e-15 2.825000000000e-08 1.397824734759e-01 2.850000000000e-08 3.414213562373e-01 2.875000000000e-08 1.331821362081e-01 2.900000000000e-08 -4.260480856999e-15 2.925000000000e-08 3.993211525331e-01 2.950000000000e-08 5.414213562373e-01 2.975000000000e-08 -3.027339492126e-01 3.000000000000e-08 -1.200000000000e+00 3.025000000000e-08 -9.054678984252e-01 3.050000000000e-08 5.857864376269e-02 3.075000000000e-08 3.496605762665e-01 3.100000000000e-08 5.065392549852e-15 3.125000000000e-08 -3.363572758385e-02 3.150000000000e-08 2.585786437627e-01 3.175000000000e-08 2.198912367380e-01 3.200000000000e-08 -3.219646771413e-15 3.225000000000e-08 1.397824734759e-01 3.250000000000e-08 3.414213562373e-01 3.275000000000e-08 1.331821362081e-01 3.300000000000e-08 -1.471045507628e-15 3.325000000000e-08 3.993211525331e-01 3.350000000000e-08 5.414213562373e-01 3.375000000000e-08 -3.027339492126e-01 3.400000000000e-08 -1.200000000000e+00 3.425000000000e-08 -9.054678984252e-01 3.450000000000e-08 5.857864376270e-02 3.475000000000e-08 3.496605762665e-01 3.500000000000e-08 -4.440892098501e-16 3.525000000000e-08 -3.363572758385e-02 3.550000000000e-08 2.585786437627e-01 3.575000000000e-08 2.198912367380e-01 3.600000000000e-08 -9.992007221626e-16 3.625000000000e-08 1.397824734759e-01 3.650000000000e-08 3.414213562373e-01 3.675000000000e-08 1.331821362081e-01 3.700000000000e-08 -8.701372955500e-15 3.725000000000e-08 3.993211525331e-01 3.750000000000e-08 5.414213562373e-01 3.775000000000e-08 -3.027339492126e-01 3.800000000000e-08 -1.200000000000e+00 3.825000000000e-08 -9.054678984252e-01 3.850000000000e-08 5.857864376268e-02 3.875000000000e-08 3.496605762666e-01 3.900000000000e-08 2.622901895677e-15 3.925000000000e-08 -3.363572758385e-02 3.950000000000e-08 2.585786437627e-01 3.975000000000e-08 2.198912367380e-01 4.000000000000e-08 -8.881784197001e-16 4.025000000000e-08 1.397824734759e-01 4.050000000000e-08 3.414213562373e-01 4.075000000000e-08 1.331821362081e-01 4.100000000000e-08 -5.981326545168e-15 4.125000000000e-08 3.993211525331e-01 4.150000000000e-08 5.414213562373e-01 4.175000000000e-08 -3.027339492126e-01 4.200000000000e-08 -1.200000000000e+00 4.225000000000e-08 -9.054678984252e-01 4.250000000000e-08 5.857864376269e-02 4.275000000000e-08 3.496605762666e-01 4.300000000000e-08 3.538835890993e-15 4.325000000000e-08 -3.363572758386e-02 4.350000000000e-08 2.585786437627e-01 4.375000000000e-08 2.198912367380e-01 4.400000000000e-08 -2.331468351713e-15 4.425000000000e-08 1.397824734759e-01 4.450000000000e-08 3.414213562373e-01 4.475000000000e-08 1.331821362081e-01 4.500000000000e-08 -3.191891195797e-15 4.525000000000e-08 3.993211525331e-01 4.550000000000e-08 5.414213562373e-01 4.575000000000e-08 -3.027339492126e-01 4.600000000000e-08 -1.200000000000e+00 4.625000000000e-08 -9.054678984252e-01 4.650000000000e-08 5.857864376270e-02 4.675000000000e-08 3.496605762665e-01 4.700000000000e-08 -1.970645868710e-15 4.725000000000e-08 -3.363572758386e-02 4.750000000000e-08 2.585786437627e-01 4.775000000000e-08 2.198912367380e-01 4.800000000000e-08 -6.550315845288e-15 4.825000000000e-08 1.397824734759e-01 4.850000000000e-08 3.414213562373e-01 4.875000000000e-08 1.331821362081e-01 4.900000000000e-08 -1.042221864367e-14 4.925000000000e-08 3.993211525331e-01 4.950000000000e-08 5.414213562373e-01 4.975000000000e-08 -3.027339492126e-01 5.000000000000e-08 -1.200000000000e+00 5.025000000000e-08 -9.054678984252e-01 5.050000000000e-08 5.857864376268e-02 5.075000000000e-08 3.496605762666e-01 5.100000000000e-08 8.146261443187e-15 5.125000000000e-08 -3.363572758385e-02 5.150000000000e-08 2.585786437627e-01 5.175000000000e-08 2.198912367380e-01 5.200000000000e-08 -3.608224830032e-15 5.225000000000e-08 1.397824734759e-01 5.250000000000e-08 3.414213562373e-01 5.275000000000e-08 1.331821362081e-01 5.300000000000e-08 -7.688294445529e-15 5.325000000000e-08 3.993211525331e-01 5.350000000000e-08 5.414213562373e-01 5.375000000000e-08 -3.027339492126e-01 5.400000000000e-08 -1.200000000000e+00 5.425000000000e-08 -9.054678984252e-01 5.450000000000e-08 5.857864376270e-02 5.475000000000e-08 3.496605762665e-01 5.500000000000e-08 1.121325254871e-14 5.525000000000e-08 -3.363572758385e-02 5.550000000000e-08 2.585786437627e-01 5.575000000000e-08 2.198912367379e-01 5.600000000000e-08 -5.051514762044e-15 5.625000000000e-08 1.397824734759e-01 5.650000000000e-08 3.414213562373e-01 5.675000000000e-08 1.331821362081e-01 5.700000000000e-08 -6.411537967210e-15 5.725000000000e-08 3.993211525331e-01 5.750000000000e-08 5.414213562373e-01 5.775000000000e-08 -3.027339492126e-01 5.800000000000e-08 -1.200000000000e+00 5.825000000000e-08 -9.054678984252e-01 5.850000000000e-08 5.857864376269e-02 5.875000000000e-08 3.496605762665e-01 5.900000000000e-08 -2.803313137179e-15 5.925000000000e-08 -3.363572758384e-02 5.950000000000e-08 2.585786437627e-01 5.975000000000e-08 2.198912367380e-01 6.000000000000e-08 -9.214851104389e-15 6.025000000000e-08 1.397824734759e-01 6.050000000000e-08 3.414213562373e-01 6.075000000000e-08 1.331821362081e-01 6.100000000000e-08 -5.051514762044e-15 6.125000000000e-08 3.993211525331e-01 6.150000000000e-08 5.414213562373e-01 6.175000000000e-08 -3.027339492126e-01 6.200000000000e-08 -1.200000000000e+00 6.225000000000e-08 -9.054678984252e-01 6.250000000000e-08 5.857864376272e-02 6.275000000000e-08 3.496605762665e-01 6.300000000000e-08 2.775557561563e-16 6.325000000000e-08 -3.363572758385e-02 6.350000000000e-08 2.585786437627e-01 6.375000000000e-08 2.198912367380e-01 6.400000000000e-08 -6.272760089132e-15 6.425000000000e-08 1.397824734759e-01 6.450000000000e-08 3.414213562373e-01 6.475000000000e-08 1.331821362081e-01 6.500000000000e-08 -1.079691891448e-14 6.525000000000e-08 3.993211525331e-01 6.550000000000e-08 5.414213562373e-01 6.575000000000e-08 -3.027339492126e-01 6.600000000000e-08 -1.200000000000e+00 6.625000000000e-08 -9.054678984252e-01 6.650000000000e-08 5.857864376270e-02 6.675000000000e-08 3.496605762666e-01 6.700000000000e-08 1.859623566247e-15 6.725000000000e-08 -3.363572758384e-02 6.750000000000e-08 2.585786437627e-01 6.775000000000e-08 2.198912367380e-01 6.800000000000e-08 -3.441691376338e-15 6.825000000000e-08 1.397824734759e-01 6.850000000000e-08 3.414213562373e-01 6.875000000000e-08 1.331821362081e-01 6.900000000000e-08 4.163336342344e-16 6.925000000000e-08 3.993211525331e-01 6.950000000000e-08 5.414213562373e-01 6.975000000000e-08 -3.027339492126e-01 7.000000000000e-08 -1.200000000000e+00 7.025000000000e-08 -9.054678984251e-01 7.050000000000e-08 5.857864376269e-02 7.075000000000e-08 3.496605762665e-01 7.100000000000e-08 3.511080315377e-15 7.125000000000e-08 -3.363572758384e-02 7.150000000000e-08 2.585786437627e-01 7.175000000000e-08 2.198912367379e-01 7.200000000000e-08 -1.942890293094e-15 7.225000000000e-08 1.397824734759e-01 7.250000000000e-08 3.414213562373e-01 7.275000000000e-08 1.331821362081e-01 7.300000000000e-08 1.762479051592e-15 7.325000000000e-08 3.993211525331e-01 7.350000000000e-08 5.414213562373e-01 7.375000000000e-08 -3.027339492126e-01 7.400000000000e-08 -1.200000000000e+00 7.425000000000e-08 -9.054678984251e-01 7.450000000000e-08 5.857864376268e-02 7.475000000000e-08 3.496605762665e-01 7.500000000000e-08 6.480926906249e-15 7.525000000000e-08 -3.363572758385e-02 7.550000000000e-08 2.585786437627e-01 7.575000000000e-08 2.198912367379e-01 7.600000000000e-08 -4.829470157119e-15 7.625000000000e-08 1.397824734759e-01 7.650000000000e-08 3.414213562373e-01 7.675000000000e-08 1.331821362081e-01 7.700000000000e-08 -1.398881011028e-14 7.725000000000e-08 3.993211525331e-01 7.750000000000e-08 5.414213562373e-01 7.775000000000e-08 -3.027339492126e-01 7.800000000000e-08 -1.200000000000e+00 7.825000000000e-08 -9.054678984252e-01 7.850000000000e-08 5.857864376271e-02 7.875000000000e-08 3.496605762665e-01 7.900000000000e-08 9.561795799584e-15 7.925000000000e-08 -3.363572758385e-02 7.950000000000e-08 2.585786437627e-01 7.975000000000e-08 2.198912367380e-01 8.000000000000e-08 -1.887379141863e-15 ]
VWL015 (wl015 0) vsource type=pwl wave=[ 0.000000000000e+00 0.000000000000e+00 2.500000000000e-10 1.801087632620e-01 5.000000000000e-10 -2.426406871193e-02 7.500000000000e-10 -2.336357275839e-01 1.000000000000e-09 9.714451465470e-17 1.250000000000e-09 5.033942373345e-02 1.500000000000e-09 -6.242640687119e-01 1.750000000000e-09 -1.105467898425e+00 2.000000000000e-09 -4.000000000000e-01 2.250000000000e-09 7.027339492126e-01 2.500000000000e-09 8.242640687119e-01 2.750000000000e-09 1.993211525331e-01 3.000000000000e-09 5.412337245048e-16 3.250000000000e-09 2.668178637919e-01 3.500000000000e-09 2.242640687119e-01 3.750000000000e-09 -6.021752652407e-02 4.000000000000e-09 1.193489751472e-15 4.250000000000e-09 1.801087632620e-01 4.500000000000e-09 -2.426406871193e-02 4.750000000000e-09 -2.336357275839e-01 5.000000000000e-09 -4.024558464266e-16 5.250000000000e-09 5.033942373345e-02 5.500000000000e-09 -6.242640687119e-01 5.750000000000e-09 -1.105467898425e+00 6.000000000000e-09 -4.000000000000e-01 6.250000000000e-09 7.027339492126e-01 6.500000000000e-09 8.242640687119e-01 6.750000000000e-09 1.993211525331e-01 7.000000000000e-09 8.743006318923e-16 7.250000000000e-09 2.668178637919e-01 7.500000000000e-09 2.242640687119e-01 7.750000000000e-09 -6.021752652407e-02 8.000000000000e-09 2.373101715136e-15 8.250000000000e-09 1.801087632620e-01 8.500000000000e-09 -2.426406871193e-02 8.750000000000e-09 -2.336357275839e-01 9.000000000000e-09 1.013078509970e-15 9.250000000000e-09 5.033942373345e-02 9.500000000000e-09 -6.242640687119e-01 9.750000000000e-09 -1.105467898425e+00 1.000000000000e-08 -4.000000000000e-01 1.025000000000e-08 7.027339492126e-01 1.050000000000e-08 8.242640687119e-01 1.075000000000e-08 1.993211525331e-01 1.100000000000e-08 7.632783294298e-16 1.125000000000e-08 2.668178637919e-01 1.150000000000e-08 2.242640687119e-01 1.175000000000e-08 -6.021752652407e-02 1.200000000000e-08 4.898859096159e-15 1.225000000000e-08 1.801087632620e-01 1.250000000000e-08 -2.426406871193e-02 1.275000000000e-08 -2.336357275839e-01 1.300000000000e-08 4.163336342344e-17 1.325000000000e-08 5.033942373345e-02 1.350000000000e-08 -6.242640687119e-01 1.375000000000e-08 -1.105467898425e+00 1.400000000000e-08 -4.000000000000e-01 1.425000000000e-08 7.027339492126e-01 1.450000000000e-08 8.242640687119e-01 1.475000000000e-08 1.993211525331e-01 1.500000000000e-08 3.191891195797e-15 1.525000000000e-08 2.668178637919e-01 1.550000000000e-08 2.242640687119e-01 1.575000000000e-08 -6.021752652407e-02 1.600000000000e-08 4.732325642465e-15 1.625000000000e-08 1.801087632620e-01 1.650000000000e-08 -2.426406871193e-02 1.675000000000e-08 -2.336357275839e-01 1.700000000000e-08 -1.110223024625e-16 1.725000000000e-08 5.033942373345e-02 1.750000000000e-08 -6.242640687119e-01 1.775000000000e-08 -1.105467898425e+00 1.800000000000e-08 -4.000000000000e-01 1.825000000000e-08 7.027339492126e-01 1.850000000000e-08 8.242640687119e-01 1.875000000000e-08 1.993211525331e-01 1.900000000000e-08 1.304512053935e-15 1.925000000000e-08 2.668178637919e-01 1.950000000000e-08 2.242640687119e-01 1.975000000000e-08 -6.021752652407e-02 2.000000000000e-08 1.387778780781e-15 2.025000000000e-08 1.801087632620e-01 2.050000000000e-08 -2.426406871193e-02 2.075000000000e-08 -2.336357275839e-01 2.100000000000e-08 4.024558464266e-16 2.125000000000e-08 5.033942373345e-02 2.150000000000e-08 -6.242640687119e-01 2.175000000000e-08 -1.105467898425e+00 2.200000000000e-08 -4.000000000000e-01 2.225000000000e-08 7.027339492126e-01 2.250000000000e-08 8.242640687119e-01 2.275000000000e-08 1.993211525331e-01 2.300000000000e-08 2.955968803064e-15 2.325000000000e-08 2.668178637919e-01 2.350000000000e-08 2.242640687119e-01 2.375000000000e-08 -6.021752652407e-02 2.400000000000e-08 9.769962616701e-15 2.425000000000e-08 1.801087632620e-01 2.450000000000e-08 -2.426406871193e-02 2.475000000000e-08 -2.336357275839e-01 2.500000000000e-08 -4.718447854657e-16 2.525000000000e-08 5.033942373345e-02 2.550000000000e-08 -6.242640687119e-01 2.575000000000e-08 -1.105467898425e+00 2.600000000000e-08 -4.000000000000e-01 2.625000000000e-08 7.027339492126e-01 2.650000000000e-08 8.242640687119e-01 2.675000000000e-08 1.993211525331e-01 2.700000000000e-08 -1.346145417358e-15 2.725000000000e-08 2.668178637919e-01 2.750000000000e-08 2.242640687119e-01 2.775000000000e-08 -6.021752652407e-02 2.800000000000e-08 7.494005416220e-15 2.825000000000e-08 1.801087632620e-01 2.850000000000e-08 -2.426406871193e-02 2.875000000000e-08 -2.336357275839e-01 2.900000000000e-08 -1.443289932013e-15 2.925000000000e-08 5.033942373345e-02 2.950000000000e-08 -6.242640687119e-01 2.975000000000e-08 -1.105467898425e+00 3.000000000000e-08 -4.000000000000e-01 3.025000000000e-08 7.027339492126e-01 3.050000000000e-08 8.242640687119e-01 3.075000000000e-08 1.993211525331e-01 3.100000000000e-08 -7.632783294298e-16 3.125000000000e-08 2.668178637919e-01 3.150000000000e-08 2.242640687119e-01 3.175000000000e-08 -6.021752652407e-02 3.200000000000e-08 9.478529072737e-15 3.225000000000e-08 1.801087632620e-01 3.250000000000e-08 -2.426406871193e-02 3.275000000000e-08 -2.336357275839e-01 3.300000000000e-08 4.052314039882e-15 3.325000000000e-08 5.033942373345e-02 3.350000000000e-08 -6.242640687119e-01 3.375000000000e-08 -1.105467898425e+00 3.400000000000e-08 -4.000000000000e-01 3.425000000000e-08 7.027339492126e-01 3.450000000000e-08 8.242640687119e-01 3.475000000000e-08 1.993211525331e-01 3.500000000000e-08 2.012279232133e-15 3.525000000000e-08 2.668178637919e-01 3.550000000000e-08 2.242640687119e-01 3.575000000000e-08 -6.021752652407e-02 3.600000000000e-08 2.942091015257e-15 3.625000000000e-08 1.801087632620e-01 3.650000000000e-08 -2.426406871193e-02 3.675000000000e-08 -2.336357275839e-01 3.700000000000e-08 -3.233524559221e-15 3.725000000000e-08 5.033942373346e-02 3.750000000000e-08 -6.242640687119e-01 3.775000000000e-08 -1.105467898425e+00 3.800000000000e-08 -4.000000000000e-01 3.825000000000e-08 7.027339492126e-01 3.850000000000e-08 8.242640687119e-01 3.875000000000e-08 1.993211525331e-01 3.900000000000e-08 7.591149930875e-15 3.925000000000e-08 2.668178637919e-01 3.950000000000e-08 2.242640687119e-01 3.975000000000e-08 -6.021752652407e-02 4.000000000000e-08 2.789435349371e-15 4.025000000000e-08 1.801087632620e-01 4.050000000000e-08 -2.426406871194e-02 4.075000000000e-08 -2.336357275839e-01 4.100000000000e-08 2.275957200482e-15 4.125000000000e-08 5.033942373345e-02 4.150000000000e-08 -6.242640687119e-01 4.175000000000e-08 -1.105467898425e+00 4.200000000000e-08 -4.000000000000e-01 4.225000000000e-08 7.027339492126e-01 4.250000000000e-08 8.242640687119e-01 4.275000000000e-08 1.993211525331e-01 4.300000000000e-08 -1.748601263785e-15 4.325000000000e-08 2.668178637919e-01 4.350000000000e-08 2.242640687119e-01 4.375000000000e-08 -6.021752652407e-02 4.400000000000e-08 6.911138328292e-15 4.425000000000e-08 1.801087632620e-01 4.450000000000e-08 -2.426406871193e-02 4.475000000000e-08 -2.336357275839e-01 4.500000000000e-08 7.716050021145e-15 4.525000000000e-08 5.033942373345e-02 4.550000000000e-08 -6.242640687119e-01 4.575000000000e-08 -1.105467898425e+00 4.600000000000e-08 -4.000000000000e-01 4.625000000000e-08 7.027339492126e-01 4.650000000000e-08 8.242640687119e-01 4.675000000000e-08 1.993211525331e-01 4.700000000000e-08 9.714451465470e-16 4.725000000000e-08 2.668178637919e-01 4.750000000000e-08 2.242640687119e-01 4.775000000000e-08 -6.021752652407e-02 4.800000000000e-08 1.955380302121e-14 4.825000000000e-08 1.801087632620e-01 4.850000000000e-08 -2.426406871194e-02 4.875000000000e-08 -2.336357275839e-01 4.900000000000e-08 4.302114220422e-16 4.925000000000e-08 5.033942373345e-02 4.950000000000e-08 -6.242640687119e-01 4.975000000000e-08 -1.105467898425e+00 5.000000000000e-08 -4.000000000000e-01 5.025000000000e-08 7.027339492126e-01 5.050000000000e-08 8.242640687119e-01 5.075000000000e-08 1.993211525331e-01 5.100000000000e-08 -5.551115123126e-16 5.125000000000e-08 2.668178637919e-01 5.150000000000e-08 2.242640687119e-01 5.175000000000e-08 -6.021752652407e-02 5.200000000000e-08 1.088018564133e-14 5.225000000000e-08 1.801087632620e-01 5.250000000000e-08 -2.426406871193e-02 5.275000000000e-08 -2.336357275839e-01 5.300000000000e-08 5.925815393937e-15 5.325000000000e-08 5.033942373345e-02 5.350000000000e-08 -6.242640687119e-01 5.375000000000e-08 -1.105467898425e+00 5.400000000000e-08 -4.000000000000e-01 5.425000000000e-08 7.027339492126e-01 5.450000000000e-08 8.242640687119e-01 5.475000000000e-08 1.993211525331e-01 5.500000000000e-08 5.065392549852e-15 5.525000000000e-08 2.668178637919e-01 5.550000000000e-08 2.242640687119e-01 5.575000000000e-08 -6.021752652407e-02 5.600000000000e-08 1.498801083244e-14 5.625000000000e-08 1.801087632620e-01 5.650000000000e-08 -2.426406871194e-02 5.675000000000e-08 -2.336357275839e-01 5.700000000000e-08 1.457167719821e-15 5.725000000000e-08 5.033942373345e-02 5.750000000000e-08 -6.242640687119e-01 5.775000000000e-08 -1.105467898425e+00 5.800000000000e-08 -4.000000000000e-01 5.825000000000e-08 7.027339492126e-01 5.850000000000e-08 8.242640687119e-01 5.875000000000e-08 1.993211525331e-01 5.900000000000e-08 4.968248035198e-15 5.925000000000e-08 2.668178637919e-01 5.950000000000e-08 2.242640687119e-01 5.975000000000e-08 -6.021752652407e-02 6.000000000000e-08 2.765843110097e-14 6.025000000000e-08 1.801087632620e-01 6.050000000000e-08 -2.426406871195e-02 6.075000000000e-08 -2.336357275839e-01 6.100000000000e-08 -2.942091015257e-15 6.125000000000e-08 5.033942373345e-02 6.150000000000e-08 -6.242640687119e-01 6.175000000000e-08 -1.105467898425e+00 6.200000000000e-08 -4.000000000000e-01 6.225000000000e-08 7.027339492126e-01 6.250000000000e-08 8.242640687119e-01 6.275000000000e-08 1.993211525331e-01 6.300000000000e-08 1.051936315832e-14 6.325000000000e-08 2.668178637919e-01 6.350000000000e-08 2.242640687119e-01 6.375000000000e-08 -6.021752652407e-02 6.400000000000e-08 1.897093593328e-14 6.425000000000e-08 1.801087632620e-01 6.450000000000e-08 -2.426406871195e-02 6.475000000000e-08 -2.336357275839e-01 6.500000000000e-08 -3.330669073875e-16 6.525000000000e-08 5.033942373345e-02 6.550000000000e-08 -6.242640687119e-01 6.575000000000e-08 -1.105467898425e+00 6.600000000000e-08 -4.000000000000e-01 6.625000000000e-08 7.027339492126e-01 6.650000000000e-08 8.242640687119e-01 6.675000000000e-08 1.993211525331e-01 6.700000000000e-08 6.161737786670e-15 6.725000000000e-08 2.668178637919e-01 6.750000000000e-08 2.242640687119e-01 6.775000000000e-08 -6.021752652407e-02 6.800000000000e-08 1.028344076559e-14 6.825000000000e-08 1.801087632620e-01 6.850000000000e-08 -2.426406871194e-02 6.875000000000e-08 -2.336357275839e-01 6.900000000000e-08 7.993605777301e-15 6.925000000000e-08 5.033942373346e-02 6.950000000000e-08 -6.242640687119e-01 6.975000000000e-08 -1.105467898425e+00 7.000000000000e-08 -4.000000000000e-01 7.025000000000e-08 7.027339492126e-01 7.050000000000e-08 8.242640687119e-01 7.075000000000e-08 1.993211525331e-01 7.100000000000e-08 1.817990202824e-15 7.125000000000e-08 2.668178637919e-01 7.150000000000e-08 2.242640687119e-01 7.175000000000e-08 -6.021752652407e-02 7.200000000000e-08 5.884182030513e-15 7.225000000000e-08 1.801087632620e-01 7.250000000000e-08 -2.426406871194e-02 7.275000000000e-08 -2.336357275839e-01 7.300000000000e-08 3.524958103185e-15 7.325000000000e-08 5.033942373344e-02 7.350000000000e-08 -6.242640687119e-01 7.375000000000e-08 -1.105467898425e+00 7.400000000000e-08 -4.000000000000e-01 7.425000000000e-08 7.027339492126e-01 7.450000000000e-08 8.242640687119e-01 7.475000000000e-08 1.993211525331e-01 7.500000000000e-08 7.369105325949e-15 7.525000000000e-08 2.668178637919e-01 7.550000000000e-08 2.242640687119e-01 7.575000000000e-08 -6.021752652407e-02 7.600000000000e-08 1.426636586643e-14 7.625000000000e-08 1.801087632620e-01 7.650000000000e-08 -2.426406871193e-02 7.675000000000e-08 -2.336357275839e-01 7.700000000000e-08 -6.647460359943e-15 7.725000000000e-08 5.033942373345e-02 7.750000000000e-08 -6.242640687119e-01 7.775000000000e-08 -1.105467898425e+00 7.800000000000e-08 -4.000000000000e-01 7.825000000000e-08 7.027339492126e-01 7.850000000000e-08 8.242640687119e-01 7.875000000000e-08 1.993211525331e-01 7.900000000000e-08 1.297573160031e-14 7.925000000000e-08 2.668178637919e-01 7.950000000000e-08 2.242640687119e-01 7.975000000000e-08 -6.021752652407e-02 8.000000000000e-08 5.578870698741e-15 ]
VWL016 (wl016 0) vsource type=pwl wave=[ 0.000000000000e+00 0.000000000000e+00 2.500000000000e-10 -1.397824734759e-01 5.000000000000e-10 -3.414213562373e-01 7.500000000000e-10 -1.331821362081e-01 1.000000000000e-09 9.714451465470e-17 1.250000000000e-09 -3.993211525331e-01 1.500000000000e-09 -5.414213562373e-01 1.750000000000e-09 3.027339492126e-01 2.000000000000e-09 1.200000000000e+00 2.250000000000e-09 9.054678984252e-01 2.500000000000e-09 -5.857864376269e-02 2.750000000000e-09 -3.496605762665e-01 3.000000000000e-09 -2.636779683485e-16 3.250000000000e-09 3.363572758386e-02 3.500000000000e-09 -2.585786437627e-01 3.750000000000e-09 -2.198912367380e-01 4.000000000000e-09 3.885780586188e-16 4.250000000000e-09 -1.397824734759e-01 4.500000000000e-09 -3.414213562373e-01 4.750000000000e-09 -1.331821362081e-01 5.000000000000e-09 6.522560269673e-16 5.250000000000e-09 -3.993211525331e-01 5.500000000000e-09 -5.414213562373e-01 5.750000000000e-09 3.027339492126e-01 6.000000000000e-09 1.200000000000e+00 6.250000000000e-09 9.054678984252e-01 6.500000000000e-09 -5.857864376269e-02 6.750000000000e-09 -3.496605762665e-01 7.000000000000e-09 2.775557561563e-17 7.250000000000e-09 3.363572758386e-02 7.500000000000e-09 -2.585786437627e-01 7.750000000000e-09 -2.198912367380e-01 8.000000000000e-09 8.326672684689e-16 8.250000000000e-09 -1.397824734759e-01 8.500000000000e-09 -3.414213562373e-01 8.750000000000e-09 -1.331821362081e-01 9.000000000000e-09 -4.579669976579e-16 9.250000000000e-09 -3.993211525331e-01 9.500000000000e-09 -5.414213562373e-01 9.750000000000e-09 3.027339492126e-01 1.000000000000e-08 1.200000000000e+00 1.025000000000e-08 9.054678984252e-01 1.050000000000e-08 -5.857864376269e-02 1.075000000000e-08 -3.496605762665e-01 1.100000000000e-08 -1.804112415016e-16 1.125000000000e-08 3.363572758386e-02 1.150000000000e-08 -2.585786437627e-01 1.175000000000e-08 -2.198912367380e-01 1.200000000000e-08 1.609823385706e-15 1.225000000000e-08 -1.397824734759e-01 1.250000000000e-08 -3.414213562373e-01 1.275000000000e-08 -1.331821362081e-01 1.300000000000e-08 1.706967900361e-15 1.325000000000e-08 -3.993211525331e-01 1.350000000000e-08 -5.414213562373e-01 1.375000000000e-08 3.027339492126e-01 1.400000000000e-08 1.200000000000e+00 1.425000000000e-08 9.054678984252e-01 1.450000000000e-08 -5.857864376269e-02 1.475000000000e-08 -3.496605762665e-01 1.500000000000e-08 -7.216449660064e-16 1.525000000000e-08 3.363572758386e-02 1.550000000000e-08 -2.585786437627e-01 1.575000000000e-08 -2.198912367380e-01 1.600000000000e-08 1.554312234475e-15 1.625000000000e-08 -1.397824734759e-01 1.650000000000e-08 -3.414213562373e-01 1.675000000000e-08 -1.331821362081e-01 1.700000000000e-08 1.804112415016e-15 1.725000000000e-08 -3.993211525331e-01 1.750000000000e-08 -5.414213562373e-01 1.775000000000e-08 3.027339492126e-01 1.800000000000e-08 1.200000000000e+00 1.825000000000e-08 9.054678984252e-01 1.850000000000e-08 -5.857864376269e-02 1.875000000000e-08 -3.496605762665e-01 1.900000000000e-08 -2.720046410332e-15 1.925000000000e-08 3.363572758386e-02 1.950000000000e-08 -2.585786437627e-01 1.975000000000e-08 -2.198912367380e-01 2.000000000000e-08 4.440892098501e-16 2.025000000000e-08 -1.397824734759e-01 2.050000000000e-08 -3.414213562373e-01 2.075000000000e-08 -1.331821362081e-01 2.100000000000e-08 -1.804112415016e-16 2.125000000000e-08 -3.993211525331e-01 2.150000000000e-08 -5.414213562373e-01 2.175000000000e-08 3.027339492126e-01 2.200000000000e-08 1.200000000000e+00 2.225000000000e-08 9.054678984252e-01 2.250000000000e-08 -5.857864376270e-02 2.275000000000e-08 -3.496605762665e-01 2.300000000000e-08 -1.137978600241e-15 2.325000000000e-08 3.363572758386e-02 2.350000000000e-08 -2.585786437627e-01 2.375000000000e-08 -2.198912367380e-01 2.400000000000e-08 3.275157922644e-15 2.425000000000e-08 -1.397824734759e-01 2.450000000000e-08 -3.414213562373e-01 2.475000000000e-08 -1.331821362081e-01 2.500000000000e-08 2.040034807749e-15 2.525000000000e-08 -3.993211525331e-01 2.550000000000e-08 -5.414213562373e-01 2.575000000000e-08 3.027339492126e-01 2.600000000000e-08 1.200000000000e+00 2.625000000000e-08 9.054678984252e-01 2.650000000000e-08 -5.857864376270e-02 2.675000000000e-08 -3.496605762665e-01 2.700000000000e-08 -2.775557561563e-15 2.725000000000e-08 3.363572758386e-02 2.750000000000e-08 -2.585786437627e-01 2.775000000000e-08 -2.198912367380e-01 2.800000000000e-08 2.442490654175e-15 2.825000000000e-08 -1.397824734759e-01 2.850000000000e-08 -3.414213562373e-01 2.875000000000e-08 -1.331821362081e-01 2.900000000000e-08 4.260480856999e-15 2.925000000000e-08 -3.993211525331e-01 2.950000000000e-08 -5.414213562373e-01 2.975000000000e-08 3.027339492126e-01 3.000000000000e-08 1.200000000000e+00 3.025000000000e-08 9.054678984252e-01 3.050000000000e-08 -5.857864376269e-02 3.075000000000e-08 -3.496605762665e-01 3.100000000000e-08 -5.065392549852e-15 3.125000000000e-08 3.363572758385e-02 3.150000000000e-08 -2.585786437627e-01 3.175000000000e-08 -2.198912367380e-01 3.200000000000e-08 3.219646771413e-15 3.225000000000e-08 -1.397824734759e-01 3.250000000000e-08 -3.414213562373e-01 3.275000000000e-08 -1.331821362081e-01 3.300000000000e-08 1.471045507628e-15 3.325000000000e-08 -3.993211525331e-01 3.350000000000e-08 -5.414213562373e-01 3.375000000000e-08 3.027339492126e-01 3.400000000000e-08 1.200000000000e+00 3.425000000000e-08 9.054678984252e-01 3.450000000000e-08 -5.857864376270e-02 3.475000000000e-08 -3.496605762665e-01 3.500000000000e-08 4.440892098501e-16 3.525000000000e-08 3.363572758385e-02 3.550000000000e-08 -2.585786437627e-01 3.575000000000e-08 -2.198912367380e-01 3.600000000000e-08 9.992007221626e-16 3.625000000000e-08 -1.397824734759e-01 3.650000000000e-08 -3.414213562373e-01 3.675000000000e-08 -1.331821362081e-01 3.700000000000e-08 8.701372955500e-15 3.725000000000e-08 -3.993211525331e-01 3.750000000000e-08 -5.414213562373e-01 3.775000000000e-08 3.027339492126e-01 3.800000000000e-08 1.200000000000e+00 3.825000000000e-08 9.054678984252e-01 3.850000000000e-08 -5.857864376268e-02 3.875000000000e-08 -3.496605762666e-01 3.900000000000e-08 -2.622901895677e-15 3.925000000000e-08 3.363572758385e-02 3.950000000000e-08 -2.585786437627e-01 3.975000000000e-08 -2.198912367380e-01 4.000000000000e-08 8.881784197001e-16 4.025000000000e-08 -1.397824734759e-01 4.050000000000e-08 -3.414213562373e-01 4.075000000000e-08 -1.331821362081e-01 4.100000000000e-08 5.981326545168e-15 4.125000000000e-08 -3.993211525331e-01 4.150000000000e-08 -5.414213562373e-01 4.175000000000e-08 3.027339492126e-01 4.200000000000e-08 1.200000000000e+00 4.225000000000e-08 9.054678984252e-01 4.250000000000e-08 -5.857864376269e-02 4.275000000000e-08 -3.496605762666e-01 4.300000000000e-08 -3.538835890993e-15 4.325000000000e-08 3.363572758386e-02 4.350000000000e-08 -2.585786437627e-01 4.375000000000e-08 -2.198912367380e-01 4.400000000000e-08 2.331468351713e-15 4.425000000000e-08 -1.397824734759e-01 4.450000000000e-08 -3.414213562373e-01 4.475000000000e-08 -1.331821362081e-01 4.500000000000e-08 3.191891195797e-15 4.525000000000e-08 -3.993211525331e-01 4.550000000000e-08 -5.414213562373e-01 4.575000000000e-08 3.027339492126e-01 4.600000000000e-08 1.200000000000e+00 4.625000000000e-08 9.054678984252e-01 4.650000000000e-08 -5.857864376270e-02 4.675000000000e-08 -3.496605762665e-01 4.700000000000e-08 1.970645868710e-15 4.725000000000e-08 3.363572758386e-02 4.750000000000e-08 -2.585786437627e-01 4.775000000000e-08 -2.198912367380e-01 4.800000000000e-08 6.550315845288e-15 4.825000000000e-08 -1.397824734759e-01 4.850000000000e-08 -3.414213562373e-01 4.875000000000e-08 -1.331821362081e-01 4.900000000000e-08 1.042221864367e-14 4.925000000000e-08 -3.993211525331e-01 4.950000000000e-08 -5.414213562373e-01 4.975000000000e-08 3.027339492126e-01 5.000000000000e-08 1.200000000000e+00 5.025000000000e-08 9.054678984252e-01 5.050000000000e-08 -5.857864376268e-02 5.075000000000e-08 -3.496605762666e-01 5.100000000000e-08 -8.146261443187e-15 5.125000000000e-08 3.363572758385e-02 5.150000000000e-08 -2.585786437627e-01 5.175000000000e-08 -2.198912367380e-01 5.200000000000e-08 3.608224830032e-15 5.225000000000e-08 -1.397824734759e-01 5.250000000000e-08 -3.414213562373e-01 5.275000000000e-08 -1.331821362081e-01 5.300000000000e-08 7.688294445529e-15 5.325000000000e-08 -3.993211525331e-01 5.350000000000e-08 -5.414213562373e-01 5.375000000000e-08 3.027339492126e-01 5.400000000000e-08 1.200000000000e+00 5.425000000000e-08 9.054678984252e-01 5.450000000000e-08 -5.857864376270e-02 5.475000000000e-08 -3.496605762665e-01 5.500000000000e-08 -1.121325254871e-14 5.525000000000e-08 3.363572758385e-02 5.550000000000e-08 -2.585786437627e-01 5.575000000000e-08 -2.198912367379e-01 5.600000000000e-08 5.051514762044e-15 5.625000000000e-08 -1.397824734759e-01 5.650000000000e-08 -3.414213562373e-01 5.675000000000e-08 -1.331821362081e-01 5.700000000000e-08 6.411537967210e-15 5.725000000000e-08 -3.993211525331e-01 5.750000000000e-08 -5.414213562373e-01 5.775000000000e-08 3.027339492126e-01 5.800000000000e-08 1.200000000000e+00 5.825000000000e-08 9.054678984252e-01 5.850000000000e-08 -5.857864376269e-02 5.875000000000e-08 -3.496605762665e-01 5.900000000000e-08 2.803313137179e-15 5.925000000000e-08 3.363572758384e-02 5.950000000000e-08 -2.585786437627e-01 5.975000000000e-08 -2.198912367380e-01 6.000000000000e-08 9.214851104389e-15 6.025000000000e-08 -1.397824734759e-01 6.050000000000e-08 -3.414213562373e-01 6.075000000000e-08 -1.331821362081e-01 6.100000000000e-08 5.051514762044e-15 6.125000000000e-08 -3.993211525331e-01 6.150000000000e-08 -5.414213562373e-01 6.175000000000e-08 3.027339492126e-01 6.200000000000e-08 1.200000000000e+00 6.225000000000e-08 9.054678984252e-01 6.250000000000e-08 -5.857864376272e-02 6.275000000000e-08 -3.496605762665e-01 6.300000000000e-08 -2.775557561563e-16 6.325000000000e-08 3.363572758385e-02 6.350000000000e-08 -2.585786437627e-01 6.375000000000e-08 -2.198912367380e-01 6.400000000000e-08 6.272760089132e-15 6.425000000000e-08 -1.397824734759e-01 6.450000000000e-08 -3.414213562373e-01 6.475000000000e-08 -1.331821362081e-01 6.500000000000e-08 1.079691891448e-14 6.525000000000e-08 -3.993211525331e-01 6.550000000000e-08 -5.414213562373e-01 6.575000000000e-08 3.027339492126e-01 6.600000000000e-08 1.200000000000e+00 6.625000000000e-08 9.054678984252e-01 6.650000000000e-08 -5.857864376270e-02 6.675000000000e-08 -3.496605762666e-01 6.700000000000e-08 -1.859623566247e-15 6.725000000000e-08 3.363572758384e-02 6.750000000000e-08 -2.585786437627e-01 6.775000000000e-08 -2.198912367380e-01 6.800000000000e-08 3.441691376338e-15 6.825000000000e-08 -1.397824734759e-01 6.850000000000e-08 -3.414213562373e-01 6.875000000000e-08 -1.331821362081e-01 6.900000000000e-08 -4.163336342344e-16 6.925000000000e-08 -3.993211525331e-01 6.950000000000e-08 -5.414213562373e-01 6.975000000000e-08 3.027339492126e-01 7.000000000000e-08 1.200000000000e+00 7.025000000000e-08 9.054678984251e-01 7.050000000000e-08 -5.857864376269e-02 7.075000000000e-08 -3.496605762665e-01 7.100000000000e-08 -3.511080315377e-15 7.125000000000e-08 3.363572758384e-02 7.150000000000e-08 -2.585786437627e-01 7.175000000000e-08 -2.198912367379e-01 7.200000000000e-08 1.942890293094e-15 7.225000000000e-08 -1.397824734759e-01 7.250000000000e-08 -3.414213562373e-01 7.275000000000e-08 -1.331821362081e-01 7.300000000000e-08 -1.762479051592e-15 7.325000000000e-08 -3.993211525331e-01 7.350000000000e-08 -5.414213562373e-01 7.375000000000e-08 3.027339492126e-01 7.400000000000e-08 1.200000000000e+00 7.425000000000e-08 9.054678984251e-01 7.450000000000e-08 -5.857864376268e-02 7.475000000000e-08 -3.496605762665e-01 7.500000000000e-08 -6.480926906249e-15 7.525000000000e-08 3.363572758385e-02 7.550000000000e-08 -2.585786437627e-01 7.575000000000e-08 -2.198912367379e-01 7.600000000000e-08 4.829470157119e-15 7.625000000000e-08 -1.397824734759e-01 7.650000000000e-08 -3.414213562373e-01 7.675000000000e-08 -1.331821362081e-01 7.700000000000e-08 1.398881011028e-14 7.725000000000e-08 -3.993211525331e-01 7.750000000000e-08 -5.414213562373e-01 7.775000000000e-08 3.027339492126e-01 7.800000000000e-08 1.200000000000e+00 7.825000000000e-08 9.054678984252e-01 7.850000000000e-08 -5.857864376271e-02 7.875000000000e-08 -3.496605762665e-01 7.900000000000e-08 -9.561795799584e-15 7.925000000000e-08 3.363572758385e-02 7.950000000000e-08 -2.585786437627e-01 7.975000000000e-08 -2.198912367380e-01 8.000000000000e-08 1.887379141863e-15 ]
VWL017 (wl017 0) vsource type=pwl wave=[ 0.000000000000e+00 0.000000000000e+00 2.500000000000e-10 -1.801087632620e-01 5.000000000000e-10 2.426406871193e-02 7.500000000000e-10 2.336357275839e-01 1.000000000000e-09 -9.714451465470e-17 1.250000000000e-09 -5.033942373345e-02 1.500000000000e-09 6.242640687119e-01 1.750000000000e-09 1.105467898425e+00 2.000000000000e-09 4.000000000000e-01 2.250000000000e-09 -7.027339492126e-01 2.500000000000e-09 -8.242640687119e-01 2.750000000000e-09 -1.993211525331e-01 3.000000000000e-09 -5.412337245048e-16 3.250000000000e-09 -2.668178637919e-01 3.500000000000e-09 -2.242640687119e-01 3.750000000000e-09 6.021752652407e-02 4.000000000000e-09 -1.193489751472e-15 4.250000000000e-09 -1.801087632620e-01 4.500000000000e-09 2.426406871193e-02 4.750000000000e-09 2.336357275839e-01 5.000000000000e-09 4.024558464266e-16 5.250000000000e-09 -5.033942373345e-02 5.500000000000e-09 6.242640687119e-01 5.750000000000e-09 1.105467898425e+00 6.000000000000e-09 4.000000000000e-01 6.250000000000e-09 -7.027339492126e-01 6.500000000000e-09 -8.242640687119e-01 6.750000000000e-09 -1.993211525331e-01 7.000000000000e-09 -8.743006318923e-16 7.250000000000e-09 -2.668178637919e-01 7.500000000000e-09 -2.242640687119e-01 7.750000000000e-09 6.021752652407e-02 8.000000000000e-09 -2.373101715136e-15 8.250000000000e-09 -1.801087632620e-01 8.500000000000e-09 2.426406871193e-02 8.750000000000e-09 2.336357275839e-01 9.000000000000e-09 -1.013078509970e-15 9.250000000000e-09 -5.033942373345e-02 9.500000000000e-09 6.242640687119e-01 9.750000000000e-09 1.105467898425e+00 1.000000000000e-08 4.000000000000e-01 1.025000000000e-08 -7.027339492126e-01 1.050000000000e-08 -8.242640687119e-01 1.075000000000e-08 -1.993211525331e-01 1.100000000000e-08 -7.632783294298e-16 1.125000000000e-08 -2.668178637919e-01 1.150000000000e-08 -2.242640687119e-01 1.175000000000e-08 6.021752652407e-02 1.200000000000e-08 -4.898859096159e-15 1.225000000000e-08 -1.801087632620e-01 1.250000000000e-08 2.426406871193e-02 1.275000000000e-08 2.336357275839e-01 1.300000000000e-08 -4.163336342344e-17 1.325000000000e-08 -5.033942373345e-02 1.350000000000e-08 6.242640687119e-01 1.375000000000e-08 1.105467898425e+00 1.400000000000e-08 4.000000000000e-01 1.425000000000e-08 -7.027339492126e-01 1.450000000000e-08 -8.242640687119e-01 1.475000000000e-08 -1.993211525331e-01 1.500000000000e-08 -3.191891195797e-15 1.525000000000e-08 -2.668178637919e-01 1.550000000000e-08 -2.242640687119e-01 1.575000000000e-08 6.021752652407e-02 1.600000000000e-08 -4.732325642465e-15 1.625000000000e-08 -1.801087632620e-01 1.650000000000e-08 2.426406871193e-02 1.675000000000e-08 2.336357275839e-01 1.700000000000e-08 1.110223024625e-16 1.725000000000e-08 -5.033942373345e-02 1.750000000000e-08 6.242640687119e-01 1.775000000000e-08 1.105467898425e+00 1.800000000000e-08 4.000000000000e-01 1.825000000000e-08 -7.027339492126e-01 1.850000000000e-08 -8.242640687119e-01 1.875000000000e-08 -1.993211525331e-01 1.900000000000e-08 -1.304512053935e-15 1.925000000000e-08 -2.668178637919e-01 1.950000000000e-08 -2.242640687119e-01 1.975000000000e-08 6.021752652407e-02 2.000000000000e-08 -1.387778780781e-15 2.025000000000e-08 -1.801087632620e-01 2.050000000000e-08 2.426406871193e-02 2.075000000000e-08 2.336357275839e-01 2.100000000000e-08 -4.024558464266e-16 2.125000000000e-08 -5.033942373345e-02 2.150000000000e-08 6.242640687119e-01 2.175000000000e-08 1.105467898425e+00 2.200000000000e-08 4.000000000000e-01 2.225000000000e-08 -7.027339492126e-01 2.250000000000e-08 -8.242640687119e-01 2.275000000000e-08 -1.993211525331e-01 2.300000000000e-08 -2.955968803064e-15 2.325000000000e-08 -2.668178637919e-01 2.350000000000e-08 -2.242640687119e-01 2.375000000000e-08 6.021752652407e-02 2.400000000000e-08 -9.769962616701e-15 2.425000000000e-08 -1.801087632620e-01 2.450000000000e-08 2.426406871193e-02 2.475000000000e-08 2.336357275839e-01 2.500000000000e-08 4.718447854657e-16 2.525000000000e-08 -5.033942373345e-02 2.550000000000e-08 6.242640687119e-01 2.575000000000e-08 1.105467898425e+00 2.600000000000e-08 4.000000000000e-01 2.625000000000e-08 -7.027339492126e-01 2.650000000000e-08 -8.242640687119e-01 2.675000000000e-08 -1.993211525331e-01 2.700000000000e-08 1.346145417358e-15 2.725000000000e-08 -2.668178637919e-01 2.750000000000e-08 -2.242640687119e-01 2.775000000000e-08 6.021752652407e-02 2.800000000000e-08 -7.494005416220e-15 2.825000000000e-08 -1.801087632620e-01 2.850000000000e-08 2.426406871193e-02 2.875000000000e-08 2.336357275839e-01 2.900000000000e-08 1.443289932013e-15 2.925000000000e-08 -5.033942373345e-02 2.950000000000e-08 6.242640687119e-01 2.975000000000e-08 1.105467898425e+00 3.000000000000e-08 4.000000000000e-01 3.025000000000e-08 -7.027339492126e-01 3.050000000000e-08 -8.242640687119e-01 3.075000000000e-08 -1.993211525331e-01 3.100000000000e-08 7.632783294298e-16 3.125000000000e-08 -2.668178637919e-01 3.150000000000e-08 -2.242640687119e-01 3.175000000000e-08 6.021752652407e-02 3.200000000000e-08 -9.478529072737e-15 3.225000000000e-08 -1.801087632620e-01 3.250000000000e-08 2.426406871193e-02 3.275000000000e-08 2.336357275839e-01 3.300000000000e-08 -4.052314039882e-15 3.325000000000e-08 -5.033942373345e-02 3.350000000000e-08 6.242640687119e-01 3.375000000000e-08 1.105467898425e+00 3.400000000000e-08 4.000000000000e-01 3.425000000000e-08 -7.027339492126e-01 3.450000000000e-08 -8.242640687119e-01 3.475000000000e-08 -1.993211525331e-01 3.500000000000e-08 -2.012279232133e-15 3.525000000000e-08 -2.668178637919e-01 3.550000000000e-08 -2.242640687119e-01 3.575000000000e-08 6.021752652407e-02 3.600000000000e-08 -2.942091015257e-15 3.625000000000e-08 -1.801087632620e-01 3.650000000000e-08 2.426406871193e-02 3.675000000000e-08 2.336357275839e-01 3.700000000000e-08 3.233524559221e-15 3.725000000000e-08 -5.033942373346e-02 3.750000000000e-08 6.242640687119e-01 3.775000000000e-08 1.105467898425e+00 3.800000000000e-08 4.000000000000e-01 3.825000000000e-08 -7.027339492126e-01 3.850000000000e-08 -8.242640687119e-01 3.875000000000e-08 -1.993211525331e-01 3.900000000000e-08 -7.591149930875e-15 3.925000000000e-08 -2.668178637919e-01 3.950000000000e-08 -2.242640687119e-01 3.975000000000e-08 6.021752652407e-02 4.000000000000e-08 -2.789435349371e-15 4.025000000000e-08 -1.801087632620e-01 4.050000000000e-08 2.426406871194e-02 4.075000000000e-08 2.336357275839e-01 4.100000000000e-08 -2.275957200482e-15 4.125000000000e-08 -5.033942373345e-02 4.150000000000e-08 6.242640687119e-01 4.175000000000e-08 1.105467898425e+00 4.200000000000e-08 4.000000000000e-01 4.225000000000e-08 -7.027339492126e-01 4.250000000000e-08 -8.242640687119e-01 4.275000000000e-08 -1.993211525331e-01 4.300000000000e-08 1.748601263785e-15 4.325000000000e-08 -2.668178637919e-01 4.350000000000e-08 -2.242640687119e-01 4.375000000000e-08 6.021752652407e-02 4.400000000000e-08 -6.911138328292e-15 4.425000000000e-08 -1.801087632620e-01 4.450000000000e-08 2.426406871193e-02 4.475000000000e-08 2.336357275839e-01 4.500000000000e-08 -7.716050021145e-15 4.525000000000e-08 -5.033942373345e-02 4.550000000000e-08 6.242640687119e-01 4.575000000000e-08 1.105467898425e+00 4.600000000000e-08 4.000000000000e-01 4.625000000000e-08 -7.027339492126e-01 4.650000000000e-08 -8.242640687119e-01 4.675000000000e-08 -1.993211525331e-01 4.700000000000e-08 -9.714451465470e-16 4.725000000000e-08 -2.668178637919e-01 4.750000000000e-08 -2.242640687119e-01 4.775000000000e-08 6.021752652407e-02 4.800000000000e-08 -1.955380302121e-14 4.825000000000e-08 -1.801087632620e-01 4.850000000000e-08 2.426406871194e-02 4.875000000000e-08 2.336357275839e-01 4.900000000000e-08 -4.302114220422e-16 4.925000000000e-08 -5.033942373345e-02 4.950000000000e-08 6.242640687119e-01 4.975000000000e-08 1.105467898425e+00 5.000000000000e-08 4.000000000000e-01 5.025000000000e-08 -7.027339492126e-01 5.050000000000e-08 -8.242640687119e-01 5.075000000000e-08 -1.993211525331e-01 5.100000000000e-08 5.551115123126e-16 5.125000000000e-08 -2.668178637919e-01 5.150000000000e-08 -2.242640687119e-01 5.175000000000e-08 6.021752652407e-02 5.200000000000e-08 -1.088018564133e-14 5.225000000000e-08 -1.801087632620e-01 5.250000000000e-08 2.426406871193e-02 5.275000000000e-08 2.336357275839e-01 5.300000000000e-08 -5.925815393937e-15 5.325000000000e-08 -5.033942373345e-02 5.350000000000e-08 6.242640687119e-01 5.375000000000e-08 1.105467898425e+00 5.400000000000e-08 4.000000000000e-01 5.425000000000e-08 -7.027339492126e-01 5.450000000000e-08 -8.242640687119e-01 5.475000000000e-08 -1.993211525331e-01 5.500000000000e-08 -5.065392549852e-15 5.525000000000e-08 -2.668178637919e-01 5.550000000000e-08 -2.242640687119e-01 5.575000000000e-08 6.021752652407e-02 5.600000000000e-08 -1.498801083244e-14 5.625000000000e-08 -1.801087632620e-01 5.650000000000e-08 2.426406871194e-02 5.675000000000e-08 2.336357275839e-01 5.700000000000e-08 -1.457167719821e-15 5.725000000000e-08 -5.033942373345e-02 5.750000000000e-08 6.242640687119e-01 5.775000000000e-08 1.105467898425e+00 5.800000000000e-08 4.000000000000e-01 5.825000000000e-08 -7.027339492126e-01 5.850000000000e-08 -8.242640687119e-01 5.875000000000e-08 -1.993211525331e-01 5.900000000000e-08 -4.968248035198e-15 5.925000000000e-08 -2.668178637919e-01 5.950000000000e-08 -2.242640687119e-01 5.975000000000e-08 6.021752652407e-02 6.000000000000e-08 -2.765843110097e-14 6.025000000000e-08 -1.801087632620e-01 6.050000000000e-08 2.426406871195e-02 6.075000000000e-08 2.336357275839e-01 6.100000000000e-08 2.942091015257e-15 6.125000000000e-08 -5.033942373345e-02 6.150000000000e-08 6.242640687119e-01 6.175000000000e-08 1.105467898425e+00 6.200000000000e-08 4.000000000000e-01 6.225000000000e-08 -7.027339492126e-01 6.250000000000e-08 -8.242640687119e-01 6.275000000000e-08 -1.993211525331e-01 6.300000000000e-08 -1.051936315832e-14 6.325000000000e-08 -2.668178637919e-01 6.350000000000e-08 -2.242640687119e-01 6.375000000000e-08 6.021752652407e-02 6.400000000000e-08 -1.897093593328e-14 6.425000000000e-08 -1.801087632620e-01 6.450000000000e-08 2.426406871195e-02 6.475000000000e-08 2.336357275839e-01 6.500000000000e-08 3.330669073875e-16 6.525000000000e-08 -5.033942373345e-02 6.550000000000e-08 6.242640687119e-01 6.575000000000e-08 1.105467898425e+00 6.600000000000e-08 4.000000000000e-01 6.625000000000e-08 -7.027339492126e-01 6.650000000000e-08 -8.242640687119e-01 6.675000000000e-08 -1.993211525331e-01 6.700000000000e-08 -6.161737786670e-15 6.725000000000e-08 -2.668178637919e-01 6.750000000000e-08 -2.242640687119e-01 6.775000000000e-08 6.021752652407e-02 6.800000000000e-08 -1.028344076559e-14 6.825000000000e-08 -1.801087632620e-01 6.850000000000e-08 2.426406871194e-02 6.875000000000e-08 2.336357275839e-01 6.900000000000e-08 -7.993605777301e-15 6.925000000000e-08 -5.033942373346e-02 6.950000000000e-08 6.242640687119e-01 6.975000000000e-08 1.105467898425e+00 7.000000000000e-08 4.000000000000e-01 7.025000000000e-08 -7.027339492126e-01 7.050000000000e-08 -8.242640687119e-01 7.075000000000e-08 -1.993211525331e-01 7.100000000000e-08 -1.817990202824e-15 7.125000000000e-08 -2.668178637919e-01 7.150000000000e-08 -2.242640687119e-01 7.175000000000e-08 6.021752652407e-02 7.200000000000e-08 -5.884182030513e-15 7.225000000000e-08 -1.801087632620e-01 7.250000000000e-08 2.426406871194e-02 7.275000000000e-08 2.336357275839e-01 7.300000000000e-08 -3.524958103185e-15 7.325000000000e-08 -5.033942373344e-02 7.350000000000e-08 6.242640687119e-01 7.375000000000e-08 1.105467898425e+00 7.400000000000e-08 4.000000000000e-01 7.425000000000e-08 -7.027339492126e-01 7.450000000000e-08 -8.242640687119e-01 7.475000000000e-08 -1.993211525331e-01 7.500000000000e-08 -7.369105325949e-15 7.525000000000e-08 -2.668178637919e-01 7.550000000000e-08 -2.242640687119e-01 7.575000000000e-08 6.021752652407e-02 7.600000000000e-08 -1.426636586643e-14 7.625000000000e-08 -1.801087632620e-01 7.650000000000e-08 2.426406871193e-02 7.675000000000e-08 2.336357275839e-01 7.700000000000e-08 6.647460359943e-15 7.725000000000e-08 -5.033942373345e-02 7.750000000000e-08 6.242640687119e-01 7.775000000000e-08 1.105467898425e+00 7.800000000000e-08 4.000000000000e-01 7.825000000000e-08 -7.027339492126e-01 7.850000000000e-08 -8.242640687119e-01 7.875000000000e-08 -1.993211525331e-01 7.900000000000e-08 -1.297573160031e-14 7.925000000000e-08 -2.668178637919e-01 7.950000000000e-08 -2.242640687119e-01 7.975000000000e-08 6.021752652407e-02 8.000000000000e-08 -5.578870698741e-15 ]
VWL018 (wl018 0) vsource type=pwl wave=[ 0.000000000000e+00 0.000000000000e+00 2.500000000000e-10 1.397824734759e-01 5.000000000000e-10 3.414213562373e-01 7.500000000000e-10 1.331821362081e-01 1.000000000000e-09 -9.714451465470e-17 1.250000000000e-09 3.993211525331e-01 1.500000000000e-09 5.414213562373e-01 1.750000000000e-09 -3.027339492126e-01 2.000000000000e-09 -1.200000000000e+00 2.250000000000e-09 -9.054678984252e-01 2.500000000000e-09 5.857864376269e-02 2.750000000000e-09 3.496605762665e-01 3.000000000000e-09 2.636779683485e-16 3.250000000000e-09 -3.363572758386e-02 3.500000000000e-09 2.585786437627e-01 3.750000000000e-09 2.198912367380e-01 4.000000000000e-09 -3.885780586188e-16 4.250000000000e-09 1.397824734759e-01 4.500000000000e-09 3.414213562373e-01 4.750000000000e-09 1.331821362081e-01 5.000000000000e-09 -6.522560269673e-16 5.250000000000e-09 3.993211525331e-01 5.500000000000e-09 5.414213562373e-01 5.750000000000e-09 -3.027339492126e-01 6.000000000000e-09 -1.200000000000e+00 6.250000000000e-09 -9.054678984252e-01 6.500000000000e-09 5.857864376269e-02 6.750000000000e-09 3.496605762665e-01 7.000000000000e-09 -2.775557561563e-17 7.250000000000e-09 -3.363572758386e-02 7.500000000000e-09 2.585786437627e-01 7.750000000000e-09 2.198912367380e-01 8.000000000000e-09 -8.326672684689e-16 8.250000000000e-09 1.397824734759e-01 8.500000000000e-09 3.414213562373e-01 8.750000000000e-09 1.331821362081e-01 9.000000000000e-09 4.579669976579e-16 9.250000000000e-09 3.993211525331e-01 9.500000000000e-09 5.414213562373e-01 9.750000000000e-09 -3.027339492126e-01 1.000000000000e-08 -1.200000000000e+00 1.025000000000e-08 -9.054678984252e-01 1.050000000000e-08 5.857864376269e-02 1.075000000000e-08 3.496605762665e-01 1.100000000000e-08 1.804112415016e-16 1.125000000000e-08 -3.363572758386e-02 1.150000000000e-08 2.585786437627e-01 1.175000000000e-08 2.198912367380e-01 1.200000000000e-08 -1.609823385706e-15 1.225000000000e-08 1.397824734759e-01 1.250000000000e-08 3.414213562373e-01 1.275000000000e-08 1.331821362081e-01 1.300000000000e-08 -1.706967900361e-15 1.325000000000e-08 3.993211525331e-01 1.350000000000e-08 5.414213562373e-01 1.375000000000e-08 -3.027339492126e-01 1.400000000000e-08 -1.200000000000e+00 1.425000000000e-08 -9.054678984252e-01 1.450000000000e-08 5.857864376269e-02 1.475000000000e-08 3.496605762665e-01 1.500000000000e-08 7.216449660064e-16 1.525000000000e-08 -3.363572758386e-02 1.550000000000e-08 2.585786437627e-01 1.575000000000e-08 2.198912367380e-01 1.600000000000e-08 -1.554312234475e-15 1.625000000000e-08 1.397824734759e-01 1.650000000000e-08 3.414213562373e-01 1.675000000000e-08 1.331821362081e-01 1.700000000000e-08 -1.804112415016e-15 1.725000000000e-08 3.993211525331e-01 1.750000000000e-08 5.414213562373e-01 1.775000000000e-08 -3.027339492126e-01 1.800000000000e-08 -1.200000000000e+00 1.825000000000e-08 -9.054678984252e-01 1.850000000000e-08 5.857864376269e-02 1.875000000000e-08 3.496605762665e-01 1.900000000000e-08 2.720046410332e-15 1.925000000000e-08 -3.363572758386e-02 1.950000000000e-08 2.585786437627e-01 1.975000000000e-08 2.198912367380e-01 2.000000000000e-08 -4.440892098501e-16 2.025000000000e-08 1.397824734759e-01 2.050000000000e-08 3.414213562373e-01 2.075000000000e-08 1.331821362081e-01 2.100000000000e-08 1.804112415016e-16 2.125000000000e-08 3.993211525331e-01 2.150000000000e-08 5.414213562373e-01 2.175000000000e-08 -3.027339492126e-01 2.200000000000e-08 -1.200000000000e+00 2.225000000000e-08 -9.054678984252e-01 2.250000000000e-08 5.857864376270e-02 2.275000000000e-08 3.496605762665e-01 2.300000000000e-08 1.137978600241e-15 2.325000000000e-08 -3.363572758386e-02 2.350000000000e-08 2.585786437627e-01 2.375000000000e-08 2.198912367380e-01 2.400000000000e-08 -3.275157922644e-15 2.425000000000e-08 1.397824734759e-01 2.450000000000e-08 3.414213562373e-01 2.475000000000e-08 1.331821362081e-01 2.500000000000e-08 -2.040034807749e-15 2.525000000000e-08 3.993211525331e-01 2.550000000000e-08 5.414213562373e-01 2.575000000000e-08 -3.027339492126e-01 2.600000000000e-08 -1.200000000000e+00 2.625000000000e-08 -9.054678984252e-01 2.650000000000e-08 5.857864376270e-02 2.675000000000e-08 3.496605762665e-01 2.700000000000e-08 2.775557561563e-15 2.725000000000e-08 -3.363572758386e-02 2.750000000000e-08 2.585786437627e-01 2.775000000000e-08 2.198912367380e-01 2.800000000000e-08 -2.442490654175e-15 2.825000000000e-08 1.397824734759e-01 2.850000000000e-08 3.414213562373e-01 2.875000000000e-08 1.331821362081e-01 2.900000000000e-08 -4.260480856999e-15 2.925000000000e-08 3.993211525331e-01 2.950000000000e-08 5.414213562373e-01 2.975000000000e-08 -3.027339492126e-01 3.000000000000e-08 -1.200000000000e+00 3.025000000000e-08 -9.054678984252e-01 3.050000000000e-08 5.857864376269e-02 3.075000000000e-08 3.496605762665e-01 3.100000000000e-08 5.065392549852e-15 3.125000000000e-08 -3.363572758385e-02 3.150000000000e-08 2.585786437627e-01 3.175000000000e-08 2.198912367380e-01 3.200000000000e-08 -3.219646771413e-15 3.225000000000e-08 1.397824734759e-01 3.250000000000e-08 3.414213562373e-01 3.275000000000e-08 1.331821362081e-01 3.300000000000e-08 -1.471045507628e-15 3.325000000000e-08 3.993211525331e-01 3.350000000000e-08 5.414213562373e-01 3.375000000000e-08 -3.027339492126e-01 3.400000000000e-08 -1.200000000000e+00 3.425000000000e-08 -9.054678984252e-01 3.450000000000e-08 5.857864376270e-02 3.475000000000e-08 3.496605762665e-01 3.500000000000e-08 -4.440892098501e-16 3.525000000000e-08 -3.363572758385e-02 3.550000000000e-08 2.585786437627e-01 3.575000000000e-08 2.198912367380e-01 3.600000000000e-08 -9.992007221626e-16 3.625000000000e-08 1.397824734759e-01 3.650000000000e-08 3.414213562373e-01 3.675000000000e-08 1.331821362081e-01 3.700000000000e-08 -8.701372955500e-15 3.725000000000e-08 3.993211525331e-01 3.750000000000e-08 5.414213562373e-01 3.775000000000e-08 -3.027339492126e-01 3.800000000000e-08 -1.200000000000e+00 3.825000000000e-08 -9.054678984252e-01 3.850000000000e-08 5.857864376268e-02 3.875000000000e-08 3.496605762666e-01 3.900000000000e-08 2.622901895677e-15 3.925000000000e-08 -3.363572758385e-02 3.950000000000e-08 2.585786437627e-01 3.975000000000e-08 2.198912367380e-01 4.000000000000e-08 -8.881784197001e-16 4.025000000000e-08 1.397824734759e-01 4.050000000000e-08 3.414213562373e-01 4.075000000000e-08 1.331821362081e-01 4.100000000000e-08 -5.981326545168e-15 4.125000000000e-08 3.993211525331e-01 4.150000000000e-08 5.414213562373e-01 4.175000000000e-08 -3.027339492126e-01 4.200000000000e-08 -1.200000000000e+00 4.225000000000e-08 -9.054678984252e-01 4.250000000000e-08 5.857864376269e-02 4.275000000000e-08 3.496605762666e-01 4.300000000000e-08 3.538835890993e-15 4.325000000000e-08 -3.363572758386e-02 4.350000000000e-08 2.585786437627e-01 4.375000000000e-08 2.198912367380e-01 4.400000000000e-08 -2.331468351713e-15 4.425000000000e-08 1.397824734759e-01 4.450000000000e-08 3.414213562373e-01 4.475000000000e-08 1.331821362081e-01 4.500000000000e-08 -3.191891195797e-15 4.525000000000e-08 3.993211525331e-01 4.550000000000e-08 5.414213562373e-01 4.575000000000e-08 -3.027339492126e-01 4.600000000000e-08 -1.200000000000e+00 4.625000000000e-08 -9.054678984252e-01 4.650000000000e-08 5.857864376270e-02 4.675000000000e-08 3.496605762665e-01 4.700000000000e-08 -1.970645868710e-15 4.725000000000e-08 -3.363572758386e-02 4.750000000000e-08 2.585786437627e-01 4.775000000000e-08 2.198912367380e-01 4.800000000000e-08 -6.550315845288e-15 4.825000000000e-08 1.397824734759e-01 4.850000000000e-08 3.414213562373e-01 4.875000000000e-08 1.331821362081e-01 4.900000000000e-08 -1.042221864367e-14 4.925000000000e-08 3.993211525331e-01 4.950000000000e-08 5.414213562373e-01 4.975000000000e-08 -3.027339492126e-01 5.000000000000e-08 -1.200000000000e+00 5.025000000000e-08 -9.054678984252e-01 5.050000000000e-08 5.857864376268e-02 5.075000000000e-08 3.496605762666e-01 5.100000000000e-08 8.146261443187e-15 5.125000000000e-08 -3.363572758385e-02 5.150000000000e-08 2.585786437627e-01 5.175000000000e-08 2.198912367380e-01 5.200000000000e-08 -3.608224830032e-15 5.225000000000e-08 1.397824734759e-01 5.250000000000e-08 3.414213562373e-01 5.275000000000e-08 1.331821362081e-01 5.300000000000e-08 -7.688294445529e-15 5.325000000000e-08 3.993211525331e-01 5.350000000000e-08 5.414213562373e-01 5.375000000000e-08 -3.027339492126e-01 5.400000000000e-08 -1.200000000000e+00 5.425000000000e-08 -9.054678984252e-01 5.450000000000e-08 5.857864376270e-02 5.475000000000e-08 3.496605762665e-01 5.500000000000e-08 1.121325254871e-14 5.525000000000e-08 -3.363572758385e-02 5.550000000000e-08 2.585786437627e-01 5.575000000000e-08 2.198912367379e-01 5.600000000000e-08 -5.051514762044e-15 5.625000000000e-08 1.397824734759e-01 5.650000000000e-08 3.414213562373e-01 5.675000000000e-08 1.331821362081e-01 5.700000000000e-08 -6.411537967210e-15 5.725000000000e-08 3.993211525331e-01 5.750000000000e-08 5.414213562373e-01 5.775000000000e-08 -3.027339492126e-01 5.800000000000e-08 -1.200000000000e+00 5.825000000000e-08 -9.054678984252e-01 5.850000000000e-08 5.857864376269e-02 5.875000000000e-08 3.496605762665e-01 5.900000000000e-08 -2.803313137179e-15 5.925000000000e-08 -3.363572758384e-02 5.950000000000e-08 2.585786437627e-01 5.975000000000e-08 2.198912367380e-01 6.000000000000e-08 -9.214851104389e-15 6.025000000000e-08 1.397824734759e-01 6.050000000000e-08 3.414213562373e-01 6.075000000000e-08 1.331821362081e-01 6.100000000000e-08 -5.051514762044e-15 6.125000000000e-08 3.993211525331e-01 6.150000000000e-08 5.414213562373e-01 6.175000000000e-08 -3.027339492126e-01 6.200000000000e-08 -1.200000000000e+00 6.225000000000e-08 -9.054678984252e-01 6.250000000000e-08 5.857864376272e-02 6.275000000000e-08 3.496605762665e-01 6.300000000000e-08 2.775557561563e-16 6.325000000000e-08 -3.363572758385e-02 6.350000000000e-08 2.585786437627e-01 6.375000000000e-08 2.198912367380e-01 6.400000000000e-08 -6.272760089132e-15 6.425000000000e-08 1.397824734759e-01 6.450000000000e-08 3.414213562373e-01 6.475000000000e-08 1.331821362081e-01 6.500000000000e-08 -1.079691891448e-14 6.525000000000e-08 3.993211525331e-01 6.550000000000e-08 5.414213562373e-01 6.575000000000e-08 -3.027339492126e-01 6.600000000000e-08 -1.200000000000e+00 6.625000000000e-08 -9.054678984252e-01 6.650000000000e-08 5.857864376270e-02 6.675000000000e-08 3.496605762666e-01 6.700000000000e-08 1.859623566247e-15 6.725000000000e-08 -3.363572758384e-02 6.750000000000e-08 2.585786437627e-01 6.775000000000e-08 2.198912367380e-01 6.800000000000e-08 -3.441691376338e-15 6.825000000000e-08 1.397824734759e-01 6.850000000000e-08 3.414213562373e-01 6.875000000000e-08 1.331821362081e-01 6.900000000000e-08 4.163336342344e-16 6.925000000000e-08 3.993211525331e-01 6.950000000000e-08 5.414213562373e-01 6.975000000000e-08 -3.027339492126e-01 7.000000000000e-08 -1.200000000000e+00 7.025000000000e-08 -9.054678984251e-01 7.050000000000e-08 5.857864376269e-02 7.075000000000e-08 3.496605762665e-01 7.100000000000e-08 3.511080315377e-15 7.125000000000e-08 -3.363572758384e-02 7.150000000000e-08 2.585786437627e-01 7.175000000000e-08 2.198912367379e-01 7.200000000000e-08 -1.942890293094e-15 7.225000000000e-08 1.397824734759e-01 7.250000000000e-08 3.414213562373e-01 7.275000000000e-08 1.331821362081e-01 7.300000000000e-08 1.762479051592e-15 7.325000000000e-08 3.993211525331e-01 7.350000000000e-08 5.414213562373e-01 7.375000000000e-08 -3.027339492126e-01 7.400000000000e-08 -1.200000000000e+00 7.425000000000e-08 -9.054678984251e-01 7.450000000000e-08 5.857864376268e-02 7.475000000000e-08 3.496605762665e-01 7.500000000000e-08 6.480926906249e-15 7.525000000000e-08 -3.363572758385e-02 7.550000000000e-08 2.585786437627e-01 7.575000000000e-08 2.198912367379e-01 7.600000000000e-08 -4.829470157119e-15 7.625000000000e-08 1.397824734759e-01 7.650000000000e-08 3.414213562373e-01 7.675000000000e-08 1.331821362081e-01 7.700000000000e-08 -1.398881011028e-14 7.725000000000e-08 3.993211525331e-01 7.750000000000e-08 5.414213562373e-01 7.775000000000e-08 -3.027339492126e-01 7.800000000000e-08 -1.200000000000e+00 7.825000000000e-08 -9.054678984252e-01 7.850000000000e-08 5.857864376271e-02 7.875000000000e-08 3.496605762665e-01 7.900000000000e-08 9.561795799584e-15 7.925000000000e-08 -3.363572758385e-02 7.950000000000e-08 2.585786437627e-01 7.975000000000e-08 2.198912367380e-01 8.000000000000e-08 -1.887379141863e-15 ]
VWL019 (wl019 0) vsource type=pwl wave=[ 0.000000000000e+00 0.000000000000e+00 2.500000000000e-10 1.801087632620e-01 5.000000000000e-10 -2.426406871193e-02 7.500000000000e-10 -2.336357275839e-01 1.000000000000e-09 9.714451465470e-17 1.250000000000e-09 5.033942373345e-02 1.500000000000e-09 -6.242640687119e-01 1.750000000000e-09 -1.105467898425e+00 2.000000000000e-09 -4.000000000000e-01 2.250000000000e-09 7.027339492126e-01 2.500000000000e-09 8.242640687119e-01 2.750000000000e-09 1.993211525331e-01 3.000000000000e-09 5.412337245048e-16 3.250000000000e-09 2.668178637919e-01 3.500000000000e-09 2.242640687119e-01 3.750000000000e-09 -6.021752652407e-02 4.000000000000e-09 1.193489751472e-15 4.250000000000e-09 1.801087632620e-01 4.500000000000e-09 -2.426406871193e-02 4.750000000000e-09 -2.336357275839e-01 5.000000000000e-09 -4.024558464266e-16 5.250000000000e-09 5.033942373345e-02 5.500000000000e-09 -6.242640687119e-01 5.750000000000e-09 -1.105467898425e+00 6.000000000000e-09 -4.000000000000e-01 6.250000000000e-09 7.027339492126e-01 6.500000000000e-09 8.242640687119e-01 6.750000000000e-09 1.993211525331e-01 7.000000000000e-09 8.743006318923e-16 7.250000000000e-09 2.668178637919e-01 7.500000000000e-09 2.242640687119e-01 7.750000000000e-09 -6.021752652407e-02 8.000000000000e-09 2.373101715136e-15 8.250000000000e-09 1.801087632620e-01 8.500000000000e-09 -2.426406871193e-02 8.750000000000e-09 -2.336357275839e-01 9.000000000000e-09 1.013078509970e-15 9.250000000000e-09 5.033942373345e-02 9.500000000000e-09 -6.242640687119e-01 9.750000000000e-09 -1.105467898425e+00 1.000000000000e-08 -4.000000000000e-01 1.025000000000e-08 7.027339492126e-01 1.050000000000e-08 8.242640687119e-01 1.075000000000e-08 1.993211525331e-01 1.100000000000e-08 7.632783294298e-16 1.125000000000e-08 2.668178637919e-01 1.150000000000e-08 2.242640687119e-01 1.175000000000e-08 -6.021752652407e-02 1.200000000000e-08 4.898859096159e-15 1.225000000000e-08 1.801087632620e-01 1.250000000000e-08 -2.426406871193e-02 1.275000000000e-08 -2.336357275839e-01 1.300000000000e-08 4.163336342344e-17 1.325000000000e-08 5.033942373345e-02 1.350000000000e-08 -6.242640687119e-01 1.375000000000e-08 -1.105467898425e+00 1.400000000000e-08 -4.000000000000e-01 1.425000000000e-08 7.027339492126e-01 1.450000000000e-08 8.242640687119e-01 1.475000000000e-08 1.993211525331e-01 1.500000000000e-08 3.191891195797e-15 1.525000000000e-08 2.668178637919e-01 1.550000000000e-08 2.242640687119e-01 1.575000000000e-08 -6.021752652407e-02 1.600000000000e-08 4.732325642465e-15 1.625000000000e-08 1.801087632620e-01 1.650000000000e-08 -2.426406871193e-02 1.675000000000e-08 -2.336357275839e-01 1.700000000000e-08 -1.110223024625e-16 1.725000000000e-08 5.033942373345e-02 1.750000000000e-08 -6.242640687119e-01 1.775000000000e-08 -1.105467898425e+00 1.800000000000e-08 -4.000000000000e-01 1.825000000000e-08 7.027339492126e-01 1.850000000000e-08 8.242640687119e-01 1.875000000000e-08 1.993211525331e-01 1.900000000000e-08 1.304512053935e-15 1.925000000000e-08 2.668178637919e-01 1.950000000000e-08 2.242640687119e-01 1.975000000000e-08 -6.021752652407e-02 2.000000000000e-08 1.387778780781e-15 2.025000000000e-08 1.801087632620e-01 2.050000000000e-08 -2.426406871193e-02 2.075000000000e-08 -2.336357275839e-01 2.100000000000e-08 4.024558464266e-16 2.125000000000e-08 5.033942373345e-02 2.150000000000e-08 -6.242640687119e-01 2.175000000000e-08 -1.105467898425e+00 2.200000000000e-08 -4.000000000000e-01 2.225000000000e-08 7.027339492126e-01 2.250000000000e-08 8.242640687119e-01 2.275000000000e-08 1.993211525331e-01 2.300000000000e-08 2.955968803064e-15 2.325000000000e-08 2.668178637919e-01 2.350000000000e-08 2.242640687119e-01 2.375000000000e-08 -6.021752652407e-02 2.400000000000e-08 9.769962616701e-15 2.425000000000e-08 1.801087632620e-01 2.450000000000e-08 -2.426406871193e-02 2.475000000000e-08 -2.336357275839e-01 2.500000000000e-08 -4.718447854657e-16 2.525000000000e-08 5.033942373345e-02 2.550000000000e-08 -6.242640687119e-01 2.575000000000e-08 -1.105467898425e+00 2.600000000000e-08 -4.000000000000e-01 2.625000000000e-08 7.027339492126e-01 2.650000000000e-08 8.242640687119e-01 2.675000000000e-08 1.993211525331e-01 2.700000000000e-08 -1.346145417358e-15 2.725000000000e-08 2.668178637919e-01 2.750000000000e-08 2.242640687119e-01 2.775000000000e-08 -6.021752652407e-02 2.800000000000e-08 7.494005416220e-15 2.825000000000e-08 1.801087632620e-01 2.850000000000e-08 -2.426406871193e-02 2.875000000000e-08 -2.336357275839e-01 2.900000000000e-08 -1.443289932013e-15 2.925000000000e-08 5.033942373345e-02 2.950000000000e-08 -6.242640687119e-01 2.975000000000e-08 -1.105467898425e+00 3.000000000000e-08 -4.000000000000e-01 3.025000000000e-08 7.027339492126e-01 3.050000000000e-08 8.242640687119e-01 3.075000000000e-08 1.993211525331e-01 3.100000000000e-08 -7.632783294298e-16 3.125000000000e-08 2.668178637919e-01 3.150000000000e-08 2.242640687119e-01 3.175000000000e-08 -6.021752652407e-02 3.200000000000e-08 9.478529072737e-15 3.225000000000e-08 1.801087632620e-01 3.250000000000e-08 -2.426406871193e-02 3.275000000000e-08 -2.336357275839e-01 3.300000000000e-08 4.052314039882e-15 3.325000000000e-08 5.033942373345e-02 3.350000000000e-08 -6.242640687119e-01 3.375000000000e-08 -1.105467898425e+00 3.400000000000e-08 -4.000000000000e-01 3.425000000000e-08 7.027339492126e-01 3.450000000000e-08 8.242640687119e-01 3.475000000000e-08 1.993211525331e-01 3.500000000000e-08 2.012279232133e-15 3.525000000000e-08 2.668178637919e-01 3.550000000000e-08 2.242640687119e-01 3.575000000000e-08 -6.021752652407e-02 3.600000000000e-08 2.942091015257e-15 3.625000000000e-08 1.801087632620e-01 3.650000000000e-08 -2.426406871193e-02 3.675000000000e-08 -2.336357275839e-01 3.700000000000e-08 -3.233524559221e-15 3.725000000000e-08 5.033942373346e-02 3.750000000000e-08 -6.242640687119e-01 3.775000000000e-08 -1.105467898425e+00 3.800000000000e-08 -4.000000000000e-01 3.825000000000e-08 7.027339492126e-01 3.850000000000e-08 8.242640687119e-01 3.875000000000e-08 1.993211525331e-01 3.900000000000e-08 7.591149930875e-15 3.925000000000e-08 2.668178637919e-01 3.950000000000e-08 2.242640687119e-01 3.975000000000e-08 -6.021752652407e-02 4.000000000000e-08 2.789435349371e-15 4.025000000000e-08 1.801087632620e-01 4.050000000000e-08 -2.426406871194e-02 4.075000000000e-08 -2.336357275839e-01 4.100000000000e-08 2.275957200482e-15 4.125000000000e-08 5.033942373345e-02 4.150000000000e-08 -6.242640687119e-01 4.175000000000e-08 -1.105467898425e+00 4.200000000000e-08 -4.000000000000e-01 4.225000000000e-08 7.027339492126e-01 4.250000000000e-08 8.242640687119e-01 4.275000000000e-08 1.993211525331e-01 4.300000000000e-08 -1.748601263785e-15 4.325000000000e-08 2.668178637919e-01 4.350000000000e-08 2.242640687119e-01 4.375000000000e-08 -6.021752652407e-02 4.400000000000e-08 6.911138328292e-15 4.425000000000e-08 1.801087632620e-01 4.450000000000e-08 -2.426406871193e-02 4.475000000000e-08 -2.336357275839e-01 4.500000000000e-08 7.716050021145e-15 4.525000000000e-08 5.033942373345e-02 4.550000000000e-08 -6.242640687119e-01 4.575000000000e-08 -1.105467898425e+00 4.600000000000e-08 -4.000000000000e-01 4.625000000000e-08 7.027339492126e-01 4.650000000000e-08 8.242640687119e-01 4.675000000000e-08 1.993211525331e-01 4.700000000000e-08 9.714451465470e-16 4.725000000000e-08 2.668178637919e-01 4.750000000000e-08 2.242640687119e-01 4.775000000000e-08 -6.021752652407e-02 4.800000000000e-08 1.955380302121e-14 4.825000000000e-08 1.801087632620e-01 4.850000000000e-08 -2.426406871194e-02 4.875000000000e-08 -2.336357275839e-01 4.900000000000e-08 4.302114220422e-16 4.925000000000e-08 5.033942373345e-02 4.950000000000e-08 -6.242640687119e-01 4.975000000000e-08 -1.105467898425e+00 5.000000000000e-08 -4.000000000000e-01 5.025000000000e-08 7.027339492126e-01 5.050000000000e-08 8.242640687119e-01 5.075000000000e-08 1.993211525331e-01 5.100000000000e-08 -5.551115123126e-16 5.125000000000e-08 2.668178637919e-01 5.150000000000e-08 2.242640687119e-01 5.175000000000e-08 -6.021752652407e-02 5.200000000000e-08 1.088018564133e-14 5.225000000000e-08 1.801087632620e-01 5.250000000000e-08 -2.426406871193e-02 5.275000000000e-08 -2.336357275839e-01 5.300000000000e-08 5.925815393937e-15 5.325000000000e-08 5.033942373345e-02 5.350000000000e-08 -6.242640687119e-01 5.375000000000e-08 -1.105467898425e+00 5.400000000000e-08 -4.000000000000e-01 5.425000000000e-08 7.027339492126e-01 5.450000000000e-08 8.242640687119e-01 5.475000000000e-08 1.993211525331e-01 5.500000000000e-08 5.065392549852e-15 5.525000000000e-08 2.668178637919e-01 5.550000000000e-08 2.242640687119e-01 5.575000000000e-08 -6.021752652407e-02 5.600000000000e-08 1.498801083244e-14 5.625000000000e-08 1.801087632620e-01 5.650000000000e-08 -2.426406871194e-02 5.675000000000e-08 -2.336357275839e-01 5.700000000000e-08 1.457167719821e-15 5.725000000000e-08 5.033942373345e-02 5.750000000000e-08 -6.242640687119e-01 5.775000000000e-08 -1.105467898425e+00 5.800000000000e-08 -4.000000000000e-01 5.825000000000e-08 7.027339492126e-01 5.850000000000e-08 8.242640687119e-01 5.875000000000e-08 1.993211525331e-01 5.900000000000e-08 4.968248035198e-15 5.925000000000e-08 2.668178637919e-01 5.950000000000e-08 2.242640687119e-01 5.975000000000e-08 -6.021752652407e-02 6.000000000000e-08 2.765843110097e-14 6.025000000000e-08 1.801087632620e-01 6.050000000000e-08 -2.426406871195e-02 6.075000000000e-08 -2.336357275839e-01 6.100000000000e-08 -2.942091015257e-15 6.125000000000e-08 5.033942373345e-02 6.150000000000e-08 -6.242640687119e-01 6.175000000000e-08 -1.105467898425e+00 6.200000000000e-08 -4.000000000000e-01 6.225000000000e-08 7.027339492126e-01 6.250000000000e-08 8.242640687119e-01 6.275000000000e-08 1.993211525331e-01 6.300000000000e-08 1.051936315832e-14 6.325000000000e-08 2.668178637919e-01 6.350000000000e-08 2.242640687119e-01 6.375000000000e-08 -6.021752652407e-02 6.400000000000e-08 1.897093593328e-14 6.425000000000e-08 1.801087632620e-01 6.450000000000e-08 -2.426406871195e-02 6.475000000000e-08 -2.336357275839e-01 6.500000000000e-08 -3.330669073875e-16 6.525000000000e-08 5.033942373345e-02 6.550000000000e-08 -6.242640687119e-01 6.575000000000e-08 -1.105467898425e+00 6.600000000000e-08 -4.000000000000e-01 6.625000000000e-08 7.027339492126e-01 6.650000000000e-08 8.242640687119e-01 6.675000000000e-08 1.993211525331e-01 6.700000000000e-08 6.161737786670e-15 6.725000000000e-08 2.668178637919e-01 6.750000000000e-08 2.242640687119e-01 6.775000000000e-08 -6.021752652407e-02 6.800000000000e-08 1.028344076559e-14 6.825000000000e-08 1.801087632620e-01 6.850000000000e-08 -2.426406871194e-02 6.875000000000e-08 -2.336357275839e-01 6.900000000000e-08 7.993605777301e-15 6.925000000000e-08 5.033942373346e-02 6.950000000000e-08 -6.242640687119e-01 6.975000000000e-08 -1.105467898425e+00 7.000000000000e-08 -4.000000000000e-01 7.025000000000e-08 7.027339492126e-01 7.050000000000e-08 8.242640687119e-01 7.075000000000e-08 1.993211525331e-01 7.100000000000e-08 1.817990202824e-15 7.125000000000e-08 2.668178637919e-01 7.150000000000e-08 2.242640687119e-01 7.175000000000e-08 -6.021752652407e-02 7.200000000000e-08 5.884182030513e-15 7.225000000000e-08 1.801087632620e-01 7.250000000000e-08 -2.426406871194e-02 7.275000000000e-08 -2.336357275839e-01 7.300000000000e-08 3.524958103185e-15 7.325000000000e-08 5.033942373344e-02 7.350000000000e-08 -6.242640687119e-01 7.375000000000e-08 -1.105467898425e+00 7.400000000000e-08 -4.000000000000e-01 7.425000000000e-08 7.027339492126e-01 7.450000000000e-08 8.242640687119e-01 7.475000000000e-08 1.993211525331e-01 7.500000000000e-08 7.369105325949e-15 7.525000000000e-08 2.668178637919e-01 7.550000000000e-08 2.242640687119e-01 7.575000000000e-08 -6.021752652407e-02 7.600000000000e-08 1.426636586643e-14 7.625000000000e-08 1.801087632620e-01 7.650000000000e-08 -2.426406871193e-02 7.675000000000e-08 -2.336357275839e-01 7.700000000000e-08 -6.647460359943e-15 7.725000000000e-08 5.033942373345e-02 7.750000000000e-08 -6.242640687119e-01 7.775000000000e-08 -1.105467898425e+00 7.800000000000e-08 -4.000000000000e-01 7.825000000000e-08 7.027339492126e-01 7.850000000000e-08 8.242640687119e-01 7.875000000000e-08 1.993211525331e-01 7.900000000000e-08 1.297573160031e-14 7.925000000000e-08 2.668178637919e-01 7.950000000000e-08 2.242640687119e-01 7.975000000000e-08 -6.021752652407e-02 8.000000000000e-08 5.578870698741e-15 ]
VWL020 (wl020 0) vsource type=pwl wave=[ 0.000000000000e+00 0.000000000000e+00 2.500000000000e-10 -1.397824734759e-01 5.000000000000e-10 -3.414213562373e-01 7.500000000000e-10 -1.331821362081e-01 1.000000000000e-09 9.714451465470e-17 1.250000000000e-09 -3.993211525331e-01 1.500000000000e-09 -5.414213562373e-01 1.750000000000e-09 3.027339492126e-01 2.000000000000e-09 1.200000000000e+00 2.250000000000e-09 9.054678984252e-01 2.500000000000e-09 -5.857864376269e-02 2.750000000000e-09 -3.496605762665e-01 3.000000000000e-09 -2.636779683485e-16 3.250000000000e-09 3.363572758386e-02 3.500000000000e-09 -2.585786437627e-01 3.750000000000e-09 -2.198912367380e-01 4.000000000000e-09 3.885780586188e-16 4.250000000000e-09 -1.397824734759e-01 4.500000000000e-09 -3.414213562373e-01 4.750000000000e-09 -1.331821362081e-01 5.000000000000e-09 6.522560269673e-16 5.250000000000e-09 -3.993211525331e-01 5.500000000000e-09 -5.414213562373e-01 5.750000000000e-09 3.027339492126e-01 6.000000000000e-09 1.200000000000e+00 6.250000000000e-09 9.054678984252e-01 6.500000000000e-09 -5.857864376269e-02 6.750000000000e-09 -3.496605762665e-01 7.000000000000e-09 2.775557561563e-17 7.250000000000e-09 3.363572758386e-02 7.500000000000e-09 -2.585786437627e-01 7.750000000000e-09 -2.198912367380e-01 8.000000000000e-09 8.326672684689e-16 8.250000000000e-09 -1.397824734759e-01 8.500000000000e-09 -3.414213562373e-01 8.750000000000e-09 -1.331821362081e-01 9.000000000000e-09 -4.579669976579e-16 9.250000000000e-09 -3.993211525331e-01 9.500000000000e-09 -5.414213562373e-01 9.750000000000e-09 3.027339492126e-01 1.000000000000e-08 1.200000000000e+00 1.025000000000e-08 9.054678984252e-01 1.050000000000e-08 -5.857864376269e-02 1.075000000000e-08 -3.496605762665e-01 1.100000000000e-08 -1.804112415016e-16 1.125000000000e-08 3.363572758386e-02 1.150000000000e-08 -2.585786437627e-01 1.175000000000e-08 -2.198912367380e-01 1.200000000000e-08 1.609823385706e-15 1.225000000000e-08 -1.397824734759e-01 1.250000000000e-08 -3.414213562373e-01 1.275000000000e-08 -1.331821362081e-01 1.300000000000e-08 1.706967900361e-15 1.325000000000e-08 -3.993211525331e-01 1.350000000000e-08 -5.414213562373e-01 1.375000000000e-08 3.027339492126e-01 1.400000000000e-08 1.200000000000e+00 1.425000000000e-08 9.054678984252e-01 1.450000000000e-08 -5.857864376269e-02 1.475000000000e-08 -3.496605762665e-01 1.500000000000e-08 -7.216449660064e-16 1.525000000000e-08 3.363572758386e-02 1.550000000000e-08 -2.585786437627e-01 1.575000000000e-08 -2.198912367380e-01 1.600000000000e-08 1.554312234475e-15 1.625000000000e-08 -1.397824734759e-01 1.650000000000e-08 -3.414213562373e-01 1.675000000000e-08 -1.331821362081e-01 1.700000000000e-08 1.804112415016e-15 1.725000000000e-08 -3.993211525331e-01 1.750000000000e-08 -5.414213562373e-01 1.775000000000e-08 3.027339492126e-01 1.800000000000e-08 1.200000000000e+00 1.825000000000e-08 9.054678984252e-01 1.850000000000e-08 -5.857864376269e-02 1.875000000000e-08 -3.496605762665e-01 1.900000000000e-08 -2.720046410332e-15 1.925000000000e-08 3.363572758386e-02 1.950000000000e-08 -2.585786437627e-01 1.975000000000e-08 -2.198912367380e-01 2.000000000000e-08 4.440892098501e-16 2.025000000000e-08 -1.397824734759e-01 2.050000000000e-08 -3.414213562373e-01 2.075000000000e-08 -1.331821362081e-01 2.100000000000e-08 -1.804112415016e-16 2.125000000000e-08 -3.993211525331e-01 2.150000000000e-08 -5.414213562373e-01 2.175000000000e-08 3.027339492126e-01 2.200000000000e-08 1.200000000000e+00 2.225000000000e-08 9.054678984252e-01 2.250000000000e-08 -5.857864376270e-02 2.275000000000e-08 -3.496605762665e-01 2.300000000000e-08 -1.137978600241e-15 2.325000000000e-08 3.363572758386e-02 2.350000000000e-08 -2.585786437627e-01 2.375000000000e-08 -2.198912367380e-01 2.400000000000e-08 3.275157922644e-15 2.425000000000e-08 -1.397824734759e-01 2.450000000000e-08 -3.414213562373e-01 2.475000000000e-08 -1.331821362081e-01 2.500000000000e-08 2.040034807749e-15 2.525000000000e-08 -3.993211525331e-01 2.550000000000e-08 -5.414213562373e-01 2.575000000000e-08 3.027339492126e-01 2.600000000000e-08 1.200000000000e+00 2.625000000000e-08 9.054678984252e-01 2.650000000000e-08 -5.857864376270e-02 2.675000000000e-08 -3.496605762665e-01 2.700000000000e-08 -2.775557561563e-15 2.725000000000e-08 3.363572758386e-02 2.750000000000e-08 -2.585786437627e-01 2.775000000000e-08 -2.198912367380e-01 2.800000000000e-08 2.442490654175e-15 2.825000000000e-08 -1.397824734759e-01 2.850000000000e-08 -3.414213562373e-01 2.875000000000e-08 -1.331821362081e-01 2.900000000000e-08 4.260480856999e-15 2.925000000000e-08 -3.993211525331e-01 2.950000000000e-08 -5.414213562373e-01 2.975000000000e-08 3.027339492126e-01 3.000000000000e-08 1.200000000000e+00 3.025000000000e-08 9.054678984252e-01 3.050000000000e-08 -5.857864376269e-02 3.075000000000e-08 -3.496605762665e-01 3.100000000000e-08 -5.065392549852e-15 3.125000000000e-08 3.363572758385e-02 3.150000000000e-08 -2.585786437627e-01 3.175000000000e-08 -2.198912367380e-01 3.200000000000e-08 3.219646771413e-15 3.225000000000e-08 -1.397824734759e-01 3.250000000000e-08 -3.414213562373e-01 3.275000000000e-08 -1.331821362081e-01 3.300000000000e-08 1.471045507628e-15 3.325000000000e-08 -3.993211525331e-01 3.350000000000e-08 -5.414213562373e-01 3.375000000000e-08 3.027339492126e-01 3.400000000000e-08 1.200000000000e+00 3.425000000000e-08 9.054678984252e-01 3.450000000000e-08 -5.857864376270e-02 3.475000000000e-08 -3.496605762665e-01 3.500000000000e-08 4.440892098501e-16 3.525000000000e-08 3.363572758385e-02 3.550000000000e-08 -2.585786437627e-01 3.575000000000e-08 -2.198912367380e-01 3.600000000000e-08 9.992007221626e-16 3.625000000000e-08 -1.397824734759e-01 3.650000000000e-08 -3.414213562373e-01 3.675000000000e-08 -1.331821362081e-01 3.700000000000e-08 8.701372955500e-15 3.725000000000e-08 -3.993211525331e-01 3.750000000000e-08 -5.414213562373e-01 3.775000000000e-08 3.027339492126e-01 3.800000000000e-08 1.200000000000e+00 3.825000000000e-08 9.054678984252e-01 3.850000000000e-08 -5.857864376268e-02 3.875000000000e-08 -3.496605762666e-01 3.900000000000e-08 -2.622901895677e-15 3.925000000000e-08 3.363572758385e-02 3.950000000000e-08 -2.585786437627e-01 3.975000000000e-08 -2.198912367380e-01 4.000000000000e-08 8.881784197001e-16 4.025000000000e-08 -1.397824734759e-01 4.050000000000e-08 -3.414213562373e-01 4.075000000000e-08 -1.331821362081e-01 4.100000000000e-08 5.981326545168e-15 4.125000000000e-08 -3.993211525331e-01 4.150000000000e-08 -5.414213562373e-01 4.175000000000e-08 3.027339492126e-01 4.200000000000e-08 1.200000000000e+00 4.225000000000e-08 9.054678984252e-01 4.250000000000e-08 -5.857864376269e-02 4.275000000000e-08 -3.496605762666e-01 4.300000000000e-08 -3.538835890993e-15 4.325000000000e-08 3.363572758386e-02 4.350000000000e-08 -2.585786437627e-01 4.375000000000e-08 -2.198912367380e-01 4.400000000000e-08 2.331468351713e-15 4.425000000000e-08 -1.397824734759e-01 4.450000000000e-08 -3.414213562373e-01 4.475000000000e-08 -1.331821362081e-01 4.500000000000e-08 3.191891195797e-15 4.525000000000e-08 -3.993211525331e-01 4.550000000000e-08 -5.414213562373e-01 4.575000000000e-08 3.027339492126e-01 4.600000000000e-08 1.200000000000e+00 4.625000000000e-08 9.054678984252e-01 4.650000000000e-08 -5.857864376270e-02 4.675000000000e-08 -3.496605762665e-01 4.700000000000e-08 1.970645868710e-15 4.725000000000e-08 3.363572758386e-02 4.750000000000e-08 -2.585786437627e-01 4.775000000000e-08 -2.198912367380e-01 4.800000000000e-08 6.550315845288e-15 4.825000000000e-08 -1.397824734759e-01 4.850000000000e-08 -3.414213562373e-01 4.875000000000e-08 -1.331821362081e-01 4.900000000000e-08 1.042221864367e-14 4.925000000000e-08 -3.993211525331e-01 4.950000000000e-08 -5.414213562373e-01 4.975000000000e-08 3.027339492126e-01 5.000000000000e-08 1.200000000000e+00 5.025000000000e-08 9.054678984252e-01 5.050000000000e-08 -5.857864376268e-02 5.075000000000e-08 -3.496605762666e-01 5.100000000000e-08 -8.146261443187e-15 5.125000000000e-08 3.363572758385e-02 5.150000000000e-08 -2.585786437627e-01 5.175000000000e-08 -2.198912367380e-01 5.200000000000e-08 3.608224830032e-15 5.225000000000e-08 -1.397824734759e-01 5.250000000000e-08 -3.414213562373e-01 5.275000000000e-08 -1.331821362081e-01 5.300000000000e-08 7.688294445529e-15 5.325000000000e-08 -3.993211525331e-01 5.350000000000e-08 -5.414213562373e-01 5.375000000000e-08 3.027339492126e-01 5.400000000000e-08 1.200000000000e+00 5.425000000000e-08 9.054678984252e-01 5.450000000000e-08 -5.857864376270e-02 5.475000000000e-08 -3.496605762665e-01 5.500000000000e-08 -1.121325254871e-14 5.525000000000e-08 3.363572758385e-02 5.550000000000e-08 -2.585786437627e-01 5.575000000000e-08 -2.198912367379e-01 5.600000000000e-08 5.051514762044e-15 5.625000000000e-08 -1.397824734759e-01 5.650000000000e-08 -3.414213562373e-01 5.675000000000e-08 -1.331821362081e-01 5.700000000000e-08 6.411537967210e-15 5.725000000000e-08 -3.993211525331e-01 5.750000000000e-08 -5.414213562373e-01 5.775000000000e-08 3.027339492126e-01 5.800000000000e-08 1.200000000000e+00 5.825000000000e-08 9.054678984252e-01 5.850000000000e-08 -5.857864376269e-02 5.875000000000e-08 -3.496605762665e-01 5.900000000000e-08 2.803313137179e-15 5.925000000000e-08 3.363572758384e-02 5.950000000000e-08 -2.585786437627e-01 5.975000000000e-08 -2.198912367380e-01 6.000000000000e-08 9.214851104389e-15 6.025000000000e-08 -1.397824734759e-01 6.050000000000e-08 -3.414213562373e-01 6.075000000000e-08 -1.331821362081e-01 6.100000000000e-08 5.051514762044e-15 6.125000000000e-08 -3.993211525331e-01 6.150000000000e-08 -5.414213562373e-01 6.175000000000e-08 3.027339492126e-01 6.200000000000e-08 1.200000000000e+00 6.225000000000e-08 9.054678984252e-01 6.250000000000e-08 -5.857864376272e-02 6.275000000000e-08 -3.496605762665e-01 6.300000000000e-08 -2.775557561563e-16 6.325000000000e-08 3.363572758385e-02 6.350000000000e-08 -2.585786437627e-01 6.375000000000e-08 -2.198912367380e-01 6.400000000000e-08 6.272760089132e-15 6.425000000000e-08 -1.397824734759e-01 6.450000000000e-08 -3.414213562373e-01 6.475000000000e-08 -1.331821362081e-01 6.500000000000e-08 1.079691891448e-14 6.525000000000e-08 -3.993211525331e-01 6.550000000000e-08 -5.414213562373e-01 6.575000000000e-08 3.027339492126e-01 6.600000000000e-08 1.200000000000e+00 6.625000000000e-08 9.054678984252e-01 6.650000000000e-08 -5.857864376270e-02 6.675000000000e-08 -3.496605762666e-01 6.700000000000e-08 -1.859623566247e-15 6.725000000000e-08 3.363572758384e-02 6.750000000000e-08 -2.585786437627e-01 6.775000000000e-08 -2.198912367380e-01 6.800000000000e-08 3.441691376338e-15 6.825000000000e-08 -1.397824734759e-01 6.850000000000e-08 -3.414213562373e-01 6.875000000000e-08 -1.331821362081e-01 6.900000000000e-08 -4.163336342344e-16 6.925000000000e-08 -3.993211525331e-01 6.950000000000e-08 -5.414213562373e-01 6.975000000000e-08 3.027339492126e-01 7.000000000000e-08 1.200000000000e+00 7.025000000000e-08 9.054678984251e-01 7.050000000000e-08 -5.857864376269e-02 7.075000000000e-08 -3.496605762665e-01 7.100000000000e-08 -3.511080315377e-15 7.125000000000e-08 3.363572758384e-02 7.150000000000e-08 -2.585786437627e-01 7.175000000000e-08 -2.198912367379e-01 7.200000000000e-08 1.942890293094e-15 7.225000000000e-08 -1.397824734759e-01 7.250000000000e-08 -3.414213562373e-01 7.275000000000e-08 -1.331821362081e-01 7.300000000000e-08 -1.762479051592e-15 7.325000000000e-08 -3.993211525331e-01 7.350000000000e-08 -5.414213562373e-01 7.375000000000e-08 3.027339492126e-01 7.400000000000e-08 1.200000000000e+00 7.425000000000e-08 9.054678984251e-01 7.450000000000e-08 -5.857864376268e-02 7.475000000000e-08 -3.496605762665e-01 7.500000000000e-08 -6.480926906249e-15 7.525000000000e-08 3.363572758385e-02 7.550000000000e-08 -2.585786437627e-01 7.575000000000e-08 -2.198912367379e-01 7.600000000000e-08 4.829470157119e-15 7.625000000000e-08 -1.397824734759e-01 7.650000000000e-08 -3.414213562373e-01 7.675000000000e-08 -1.331821362081e-01 7.700000000000e-08 1.398881011028e-14 7.725000000000e-08 -3.993211525331e-01 7.750000000000e-08 -5.414213562373e-01 7.775000000000e-08 3.027339492126e-01 7.800000000000e-08 1.200000000000e+00 7.825000000000e-08 9.054678984252e-01 7.850000000000e-08 -5.857864376271e-02 7.875000000000e-08 -3.496605762665e-01 7.900000000000e-08 -9.561795799584e-15 7.925000000000e-08 3.363572758385e-02 7.950000000000e-08 -2.585786437627e-01 7.975000000000e-08 -2.198912367380e-01 8.000000000000e-08 1.887379141863e-15 ]
VWL021 (wl021 0) vsource type=pwl wave=[ 0.000000000000e+00 0.000000000000e+00 2.500000000000e-10 -1.801087632620e-01 5.000000000000e-10 2.426406871193e-02 7.500000000000e-10 2.336357275839e-01 1.000000000000e-09 -9.714451465470e-17 1.250000000000e-09 -5.033942373345e-02 1.500000000000e-09 6.242640687119e-01 1.750000000000e-09 1.105467898425e+00 2.000000000000e-09 4.000000000000e-01 2.250000000000e-09 -7.027339492126e-01 2.500000000000e-09 -8.242640687119e-01 2.750000000000e-09 -1.993211525331e-01 3.000000000000e-09 -5.412337245048e-16 3.250000000000e-09 -2.668178637919e-01 3.500000000000e-09 -2.242640687119e-01 3.750000000000e-09 6.021752652407e-02 4.000000000000e-09 -1.193489751472e-15 4.250000000000e-09 -1.801087632620e-01 4.500000000000e-09 2.426406871193e-02 4.750000000000e-09 2.336357275839e-01 5.000000000000e-09 4.024558464266e-16 5.250000000000e-09 -5.033942373345e-02 5.500000000000e-09 6.242640687119e-01 5.750000000000e-09 1.105467898425e+00 6.000000000000e-09 4.000000000000e-01 6.250000000000e-09 -7.027339492126e-01 6.500000000000e-09 -8.242640687119e-01 6.750000000000e-09 -1.993211525331e-01 7.000000000000e-09 -8.743006318923e-16 7.250000000000e-09 -2.668178637919e-01 7.500000000000e-09 -2.242640687119e-01 7.750000000000e-09 6.021752652407e-02 8.000000000000e-09 -2.373101715136e-15 8.250000000000e-09 -1.801087632620e-01 8.500000000000e-09 2.426406871193e-02 8.750000000000e-09 2.336357275839e-01 9.000000000000e-09 -1.013078509970e-15 9.250000000000e-09 -5.033942373345e-02 9.500000000000e-09 6.242640687119e-01 9.750000000000e-09 1.105467898425e+00 1.000000000000e-08 4.000000000000e-01 1.025000000000e-08 -7.027339492126e-01 1.050000000000e-08 -8.242640687119e-01 1.075000000000e-08 -1.993211525331e-01 1.100000000000e-08 -7.632783294298e-16 1.125000000000e-08 -2.668178637919e-01 1.150000000000e-08 -2.242640687119e-01 1.175000000000e-08 6.021752652407e-02 1.200000000000e-08 -4.898859096159e-15 1.225000000000e-08 -1.801087632620e-01 1.250000000000e-08 2.426406871193e-02 1.275000000000e-08 2.336357275839e-01 1.300000000000e-08 -4.163336342344e-17 1.325000000000e-08 -5.033942373345e-02 1.350000000000e-08 6.242640687119e-01 1.375000000000e-08 1.105467898425e+00 1.400000000000e-08 4.000000000000e-01 1.425000000000e-08 -7.027339492126e-01 1.450000000000e-08 -8.242640687119e-01 1.475000000000e-08 -1.993211525331e-01 1.500000000000e-08 -3.191891195797e-15 1.525000000000e-08 -2.668178637919e-01 1.550000000000e-08 -2.242640687119e-01 1.575000000000e-08 6.021752652407e-02 1.600000000000e-08 -4.732325642465e-15 1.625000000000e-08 -1.801087632620e-01 1.650000000000e-08 2.426406871193e-02 1.675000000000e-08 2.336357275839e-01 1.700000000000e-08 1.110223024625e-16 1.725000000000e-08 -5.033942373345e-02 1.750000000000e-08 6.242640687119e-01 1.775000000000e-08 1.105467898425e+00 1.800000000000e-08 4.000000000000e-01 1.825000000000e-08 -7.027339492126e-01 1.850000000000e-08 -8.242640687119e-01 1.875000000000e-08 -1.993211525331e-01 1.900000000000e-08 -1.304512053935e-15 1.925000000000e-08 -2.668178637919e-01 1.950000000000e-08 -2.242640687119e-01 1.975000000000e-08 6.021752652407e-02 2.000000000000e-08 -1.387778780781e-15 2.025000000000e-08 -1.801087632620e-01 2.050000000000e-08 2.426406871193e-02 2.075000000000e-08 2.336357275839e-01 2.100000000000e-08 -4.024558464266e-16 2.125000000000e-08 -5.033942373345e-02 2.150000000000e-08 6.242640687119e-01 2.175000000000e-08 1.105467898425e+00 2.200000000000e-08 4.000000000000e-01 2.225000000000e-08 -7.027339492126e-01 2.250000000000e-08 -8.242640687119e-01 2.275000000000e-08 -1.993211525331e-01 2.300000000000e-08 -2.955968803064e-15 2.325000000000e-08 -2.668178637919e-01 2.350000000000e-08 -2.242640687119e-01 2.375000000000e-08 6.021752652407e-02 2.400000000000e-08 -9.769962616701e-15 2.425000000000e-08 -1.801087632620e-01 2.450000000000e-08 2.426406871193e-02 2.475000000000e-08 2.336357275839e-01 2.500000000000e-08 4.718447854657e-16 2.525000000000e-08 -5.033942373345e-02 2.550000000000e-08 6.242640687119e-01 2.575000000000e-08 1.105467898425e+00 2.600000000000e-08 4.000000000000e-01 2.625000000000e-08 -7.027339492126e-01 2.650000000000e-08 -8.242640687119e-01 2.675000000000e-08 -1.993211525331e-01 2.700000000000e-08 1.346145417358e-15 2.725000000000e-08 -2.668178637919e-01 2.750000000000e-08 -2.242640687119e-01 2.775000000000e-08 6.021752652407e-02 2.800000000000e-08 -7.494005416220e-15 2.825000000000e-08 -1.801087632620e-01 2.850000000000e-08 2.426406871193e-02 2.875000000000e-08 2.336357275839e-01 2.900000000000e-08 1.443289932013e-15 2.925000000000e-08 -5.033942373345e-02 2.950000000000e-08 6.242640687119e-01 2.975000000000e-08 1.105467898425e+00 3.000000000000e-08 4.000000000000e-01 3.025000000000e-08 -7.027339492126e-01 3.050000000000e-08 -8.242640687119e-01 3.075000000000e-08 -1.993211525331e-01 3.100000000000e-08 7.632783294298e-16 3.125000000000e-08 -2.668178637919e-01 3.150000000000e-08 -2.242640687119e-01 3.175000000000e-08 6.021752652407e-02 3.200000000000e-08 -9.478529072737e-15 3.225000000000e-08 -1.801087632620e-01 3.250000000000e-08 2.426406871193e-02 3.275000000000e-08 2.336357275839e-01 3.300000000000e-08 -4.052314039882e-15 3.325000000000e-08 -5.033942373345e-02 3.350000000000e-08 6.242640687119e-01 3.375000000000e-08 1.105467898425e+00 3.400000000000e-08 4.000000000000e-01 3.425000000000e-08 -7.027339492126e-01 3.450000000000e-08 -8.242640687119e-01 3.475000000000e-08 -1.993211525331e-01 3.500000000000e-08 -2.012279232133e-15 3.525000000000e-08 -2.668178637919e-01 3.550000000000e-08 -2.242640687119e-01 3.575000000000e-08 6.021752652407e-02 3.600000000000e-08 -2.942091015257e-15 3.625000000000e-08 -1.801087632620e-01 3.650000000000e-08 2.426406871193e-02 3.675000000000e-08 2.336357275839e-01 3.700000000000e-08 3.233524559221e-15 3.725000000000e-08 -5.033942373346e-02 3.750000000000e-08 6.242640687119e-01 3.775000000000e-08 1.105467898425e+00 3.800000000000e-08 4.000000000000e-01 3.825000000000e-08 -7.027339492126e-01 3.850000000000e-08 -8.242640687119e-01 3.875000000000e-08 -1.993211525331e-01 3.900000000000e-08 -7.591149930875e-15 3.925000000000e-08 -2.668178637919e-01 3.950000000000e-08 -2.242640687119e-01 3.975000000000e-08 6.021752652407e-02 4.000000000000e-08 -2.789435349371e-15 4.025000000000e-08 -1.801087632620e-01 4.050000000000e-08 2.426406871194e-02 4.075000000000e-08 2.336357275839e-01 4.100000000000e-08 -2.275957200482e-15 4.125000000000e-08 -5.033942373345e-02 4.150000000000e-08 6.242640687119e-01 4.175000000000e-08 1.105467898425e+00 4.200000000000e-08 4.000000000000e-01 4.225000000000e-08 -7.027339492126e-01 4.250000000000e-08 -8.242640687119e-01 4.275000000000e-08 -1.993211525331e-01 4.300000000000e-08 1.748601263785e-15 4.325000000000e-08 -2.668178637919e-01 4.350000000000e-08 -2.242640687119e-01 4.375000000000e-08 6.021752652407e-02 4.400000000000e-08 -6.911138328292e-15 4.425000000000e-08 -1.801087632620e-01 4.450000000000e-08 2.426406871193e-02 4.475000000000e-08 2.336357275839e-01 4.500000000000e-08 -7.716050021145e-15 4.525000000000e-08 -5.033942373345e-02 4.550000000000e-08 6.242640687119e-01 4.575000000000e-08 1.105467898425e+00 4.600000000000e-08 4.000000000000e-01 4.625000000000e-08 -7.027339492126e-01 4.650000000000e-08 -8.242640687119e-01 4.675000000000e-08 -1.993211525331e-01 4.700000000000e-08 -9.714451465470e-16 4.725000000000e-08 -2.668178637919e-01 4.750000000000e-08 -2.242640687119e-01 4.775000000000e-08 6.021752652407e-02 4.800000000000e-08 -1.955380302121e-14 4.825000000000e-08 -1.801087632620e-01 4.850000000000e-08 2.426406871194e-02 4.875000000000e-08 2.336357275839e-01 4.900000000000e-08 -4.302114220422e-16 4.925000000000e-08 -5.033942373345e-02 4.950000000000e-08 6.242640687119e-01 4.975000000000e-08 1.105467898425e+00 5.000000000000e-08 4.000000000000e-01 5.025000000000e-08 -7.027339492126e-01 5.050000000000e-08 -8.242640687119e-01 5.075000000000e-08 -1.993211525331e-01 5.100000000000e-08 5.551115123126e-16 5.125000000000e-08 -2.668178637919e-01 5.150000000000e-08 -2.242640687119e-01 5.175000000000e-08 6.021752652407e-02 5.200000000000e-08 -1.088018564133e-14 5.225000000000e-08 -1.801087632620e-01 5.250000000000e-08 2.426406871193e-02 5.275000000000e-08 2.336357275839e-01 5.300000000000e-08 -5.925815393937e-15 5.325000000000e-08 -5.033942373345e-02 5.350000000000e-08 6.242640687119e-01 5.375000000000e-08 1.105467898425e+00 5.400000000000e-08 4.000000000000e-01 5.425000000000e-08 -7.027339492126e-01 5.450000000000e-08 -8.242640687119e-01 5.475000000000e-08 -1.993211525331e-01 5.500000000000e-08 -5.065392549852e-15 5.525000000000e-08 -2.668178637919e-01 5.550000000000e-08 -2.242640687119e-01 5.575000000000e-08 6.021752652407e-02 5.600000000000e-08 -1.498801083244e-14 5.625000000000e-08 -1.801087632620e-01 5.650000000000e-08 2.426406871194e-02 5.675000000000e-08 2.336357275839e-01 5.700000000000e-08 -1.457167719821e-15 5.725000000000e-08 -5.033942373345e-02 5.750000000000e-08 6.242640687119e-01 5.775000000000e-08 1.105467898425e+00 5.800000000000e-08 4.000000000000e-01 5.825000000000e-08 -7.027339492126e-01 5.850000000000e-08 -8.242640687119e-01 5.875000000000e-08 -1.993211525331e-01 5.900000000000e-08 -4.968248035198e-15 5.925000000000e-08 -2.668178637919e-01 5.950000000000e-08 -2.242640687119e-01 5.975000000000e-08 6.021752652407e-02 6.000000000000e-08 -2.765843110097e-14 6.025000000000e-08 -1.801087632620e-01 6.050000000000e-08 2.426406871195e-02 6.075000000000e-08 2.336357275839e-01 6.100000000000e-08 2.942091015257e-15 6.125000000000e-08 -5.033942373345e-02 6.150000000000e-08 6.242640687119e-01 6.175000000000e-08 1.105467898425e+00 6.200000000000e-08 4.000000000000e-01 6.225000000000e-08 -7.027339492126e-01 6.250000000000e-08 -8.242640687119e-01 6.275000000000e-08 -1.993211525331e-01 6.300000000000e-08 -1.051936315832e-14 6.325000000000e-08 -2.668178637919e-01 6.350000000000e-08 -2.242640687119e-01 6.375000000000e-08 6.021752652407e-02 6.400000000000e-08 -1.897093593328e-14 6.425000000000e-08 -1.801087632620e-01 6.450000000000e-08 2.426406871195e-02 6.475000000000e-08 2.336357275839e-01 6.500000000000e-08 3.330669073875e-16 6.525000000000e-08 -5.033942373345e-02 6.550000000000e-08 6.242640687119e-01 6.575000000000e-08 1.105467898425e+00 6.600000000000e-08 4.000000000000e-01 6.625000000000e-08 -7.027339492126e-01 6.650000000000e-08 -8.242640687119e-01 6.675000000000e-08 -1.993211525331e-01 6.700000000000e-08 -6.161737786670e-15 6.725000000000e-08 -2.668178637919e-01 6.750000000000e-08 -2.242640687119e-01 6.775000000000e-08 6.021752652407e-02 6.800000000000e-08 -1.028344076559e-14 6.825000000000e-08 -1.801087632620e-01 6.850000000000e-08 2.426406871194e-02 6.875000000000e-08 2.336357275839e-01 6.900000000000e-08 -7.993605777301e-15 6.925000000000e-08 -5.033942373346e-02 6.950000000000e-08 6.242640687119e-01 6.975000000000e-08 1.105467898425e+00 7.000000000000e-08 4.000000000000e-01 7.025000000000e-08 -7.027339492126e-01 7.050000000000e-08 -8.242640687119e-01 7.075000000000e-08 -1.993211525331e-01 7.100000000000e-08 -1.817990202824e-15 7.125000000000e-08 -2.668178637919e-01 7.150000000000e-08 -2.242640687119e-01 7.175000000000e-08 6.021752652407e-02 7.200000000000e-08 -5.884182030513e-15 7.225000000000e-08 -1.801087632620e-01 7.250000000000e-08 2.426406871194e-02 7.275000000000e-08 2.336357275839e-01 7.300000000000e-08 -3.524958103185e-15 7.325000000000e-08 -5.033942373344e-02 7.350000000000e-08 6.242640687119e-01 7.375000000000e-08 1.105467898425e+00 7.400000000000e-08 4.000000000000e-01 7.425000000000e-08 -7.027339492126e-01 7.450000000000e-08 -8.242640687119e-01 7.475000000000e-08 -1.993211525331e-01 7.500000000000e-08 -7.369105325949e-15 7.525000000000e-08 -2.668178637919e-01 7.550000000000e-08 -2.242640687119e-01 7.575000000000e-08 6.021752652407e-02 7.600000000000e-08 -1.426636586643e-14 7.625000000000e-08 -1.801087632620e-01 7.650000000000e-08 2.426406871193e-02 7.675000000000e-08 2.336357275839e-01 7.700000000000e-08 6.647460359943e-15 7.725000000000e-08 -5.033942373345e-02 7.750000000000e-08 6.242640687119e-01 7.775000000000e-08 1.105467898425e+00 7.800000000000e-08 4.000000000000e-01 7.825000000000e-08 -7.027339492126e-01 7.850000000000e-08 -8.242640687119e-01 7.875000000000e-08 -1.993211525331e-01 7.900000000000e-08 -1.297573160031e-14 7.925000000000e-08 -2.668178637919e-01 7.950000000000e-08 -2.242640687119e-01 7.975000000000e-08 6.021752652407e-02 8.000000000000e-08 -5.578870698741e-15 ]
VWL022 (wl022 0) vsource type=pwl wave=[ 0.000000000000e+00 0.000000000000e+00 2.500000000000e-10 1.397824734759e-01 5.000000000000e-10 3.414213562373e-01 7.500000000000e-10 1.331821362081e-01 1.000000000000e-09 -9.714451465470e-17 1.250000000000e-09 3.993211525331e-01 1.500000000000e-09 5.414213562373e-01 1.750000000000e-09 -3.027339492126e-01 2.000000000000e-09 -1.200000000000e+00 2.250000000000e-09 -9.054678984252e-01 2.500000000000e-09 5.857864376269e-02 2.750000000000e-09 3.496605762665e-01 3.000000000000e-09 2.636779683485e-16 3.250000000000e-09 -3.363572758386e-02 3.500000000000e-09 2.585786437627e-01 3.750000000000e-09 2.198912367380e-01 4.000000000000e-09 -3.885780586188e-16 4.250000000000e-09 1.397824734759e-01 4.500000000000e-09 3.414213562373e-01 4.750000000000e-09 1.331821362081e-01 5.000000000000e-09 -6.522560269673e-16 5.250000000000e-09 3.993211525331e-01 5.500000000000e-09 5.414213562373e-01 5.750000000000e-09 -3.027339492126e-01 6.000000000000e-09 -1.200000000000e+00 6.250000000000e-09 -9.054678984252e-01 6.500000000000e-09 5.857864376269e-02 6.750000000000e-09 3.496605762665e-01 7.000000000000e-09 -2.775557561563e-17 7.250000000000e-09 -3.363572758386e-02 7.500000000000e-09 2.585786437627e-01 7.750000000000e-09 2.198912367380e-01 8.000000000000e-09 -8.326672684689e-16 8.250000000000e-09 1.397824734759e-01 8.500000000000e-09 3.414213562373e-01 8.750000000000e-09 1.331821362081e-01 9.000000000000e-09 4.579669976579e-16 9.250000000000e-09 3.993211525331e-01 9.500000000000e-09 5.414213562373e-01 9.750000000000e-09 -3.027339492126e-01 1.000000000000e-08 -1.200000000000e+00 1.025000000000e-08 -9.054678984252e-01 1.050000000000e-08 5.857864376269e-02 1.075000000000e-08 3.496605762665e-01 1.100000000000e-08 1.804112415016e-16 1.125000000000e-08 -3.363572758386e-02 1.150000000000e-08 2.585786437627e-01 1.175000000000e-08 2.198912367380e-01 1.200000000000e-08 -1.609823385706e-15 1.225000000000e-08 1.397824734759e-01 1.250000000000e-08 3.414213562373e-01 1.275000000000e-08 1.331821362081e-01 1.300000000000e-08 -1.706967900361e-15 1.325000000000e-08 3.993211525331e-01 1.350000000000e-08 5.414213562373e-01 1.375000000000e-08 -3.027339492126e-01 1.400000000000e-08 -1.200000000000e+00 1.425000000000e-08 -9.054678984252e-01 1.450000000000e-08 5.857864376269e-02 1.475000000000e-08 3.496605762665e-01 1.500000000000e-08 7.216449660064e-16 1.525000000000e-08 -3.363572758386e-02 1.550000000000e-08 2.585786437627e-01 1.575000000000e-08 2.198912367380e-01 1.600000000000e-08 -1.554312234475e-15 1.625000000000e-08 1.397824734759e-01 1.650000000000e-08 3.414213562373e-01 1.675000000000e-08 1.331821362081e-01 1.700000000000e-08 -1.804112415016e-15 1.725000000000e-08 3.993211525331e-01 1.750000000000e-08 5.414213562373e-01 1.775000000000e-08 -3.027339492126e-01 1.800000000000e-08 -1.200000000000e+00 1.825000000000e-08 -9.054678984252e-01 1.850000000000e-08 5.857864376269e-02 1.875000000000e-08 3.496605762665e-01 1.900000000000e-08 2.720046410332e-15 1.925000000000e-08 -3.363572758386e-02 1.950000000000e-08 2.585786437627e-01 1.975000000000e-08 2.198912367380e-01 2.000000000000e-08 -4.440892098501e-16 2.025000000000e-08 1.397824734759e-01 2.050000000000e-08 3.414213562373e-01 2.075000000000e-08 1.331821362081e-01 2.100000000000e-08 1.804112415016e-16 2.125000000000e-08 3.993211525331e-01 2.150000000000e-08 5.414213562373e-01 2.175000000000e-08 -3.027339492126e-01 2.200000000000e-08 -1.200000000000e+00 2.225000000000e-08 -9.054678984252e-01 2.250000000000e-08 5.857864376270e-02 2.275000000000e-08 3.496605762665e-01 2.300000000000e-08 1.137978600241e-15 2.325000000000e-08 -3.363572758386e-02 2.350000000000e-08 2.585786437627e-01 2.375000000000e-08 2.198912367380e-01 2.400000000000e-08 -3.275157922644e-15 2.425000000000e-08 1.397824734759e-01 2.450000000000e-08 3.414213562373e-01 2.475000000000e-08 1.331821362081e-01 2.500000000000e-08 -2.040034807749e-15 2.525000000000e-08 3.993211525331e-01 2.550000000000e-08 5.414213562373e-01 2.575000000000e-08 -3.027339492126e-01 2.600000000000e-08 -1.200000000000e+00 2.625000000000e-08 -9.054678984252e-01 2.650000000000e-08 5.857864376270e-02 2.675000000000e-08 3.496605762665e-01 2.700000000000e-08 2.775557561563e-15 2.725000000000e-08 -3.363572758386e-02 2.750000000000e-08 2.585786437627e-01 2.775000000000e-08 2.198912367380e-01 2.800000000000e-08 -2.442490654175e-15 2.825000000000e-08 1.397824734759e-01 2.850000000000e-08 3.414213562373e-01 2.875000000000e-08 1.331821362081e-01 2.900000000000e-08 -4.260480856999e-15 2.925000000000e-08 3.993211525331e-01 2.950000000000e-08 5.414213562373e-01 2.975000000000e-08 -3.027339492126e-01 3.000000000000e-08 -1.200000000000e+00 3.025000000000e-08 -9.054678984252e-01 3.050000000000e-08 5.857864376269e-02 3.075000000000e-08 3.496605762665e-01 3.100000000000e-08 5.065392549852e-15 3.125000000000e-08 -3.363572758385e-02 3.150000000000e-08 2.585786437627e-01 3.175000000000e-08 2.198912367380e-01 3.200000000000e-08 -3.219646771413e-15 3.225000000000e-08 1.397824734759e-01 3.250000000000e-08 3.414213562373e-01 3.275000000000e-08 1.331821362081e-01 3.300000000000e-08 -1.471045507628e-15 3.325000000000e-08 3.993211525331e-01 3.350000000000e-08 5.414213562373e-01 3.375000000000e-08 -3.027339492126e-01 3.400000000000e-08 -1.200000000000e+00 3.425000000000e-08 -9.054678984252e-01 3.450000000000e-08 5.857864376270e-02 3.475000000000e-08 3.496605762665e-01 3.500000000000e-08 -4.440892098501e-16 3.525000000000e-08 -3.363572758385e-02 3.550000000000e-08 2.585786437627e-01 3.575000000000e-08 2.198912367380e-01 3.600000000000e-08 -9.992007221626e-16 3.625000000000e-08 1.397824734759e-01 3.650000000000e-08 3.414213562373e-01 3.675000000000e-08 1.331821362081e-01 3.700000000000e-08 -8.701372955500e-15 3.725000000000e-08 3.993211525331e-01 3.750000000000e-08 5.414213562373e-01 3.775000000000e-08 -3.027339492126e-01 3.800000000000e-08 -1.200000000000e+00 3.825000000000e-08 -9.054678984252e-01 3.850000000000e-08 5.857864376268e-02 3.875000000000e-08 3.496605762666e-01 3.900000000000e-08 2.622901895677e-15 3.925000000000e-08 -3.363572758385e-02 3.950000000000e-08 2.585786437627e-01 3.975000000000e-08 2.198912367380e-01 4.000000000000e-08 -8.881784197001e-16 4.025000000000e-08 1.397824734759e-01 4.050000000000e-08 3.414213562373e-01 4.075000000000e-08 1.331821362081e-01 4.100000000000e-08 -5.981326545168e-15 4.125000000000e-08 3.993211525331e-01 4.150000000000e-08 5.414213562373e-01 4.175000000000e-08 -3.027339492126e-01 4.200000000000e-08 -1.200000000000e+00 4.225000000000e-08 -9.054678984252e-01 4.250000000000e-08 5.857864376269e-02 4.275000000000e-08 3.496605762666e-01 4.300000000000e-08 3.538835890993e-15 4.325000000000e-08 -3.363572758386e-02 4.350000000000e-08 2.585786437627e-01 4.375000000000e-08 2.198912367380e-01 4.400000000000e-08 -2.331468351713e-15 4.425000000000e-08 1.397824734759e-01 4.450000000000e-08 3.414213562373e-01 4.475000000000e-08 1.331821362081e-01 4.500000000000e-08 -3.191891195797e-15 4.525000000000e-08 3.993211525331e-01 4.550000000000e-08 5.414213562373e-01 4.575000000000e-08 -3.027339492126e-01 4.600000000000e-08 -1.200000000000e+00 4.625000000000e-08 -9.054678984252e-01 4.650000000000e-08 5.857864376270e-02 4.675000000000e-08 3.496605762665e-01 4.700000000000e-08 -1.970645868710e-15 4.725000000000e-08 -3.363572758386e-02 4.750000000000e-08 2.585786437627e-01 4.775000000000e-08 2.198912367380e-01 4.800000000000e-08 -6.550315845288e-15 4.825000000000e-08 1.397824734759e-01 4.850000000000e-08 3.414213562373e-01 4.875000000000e-08 1.331821362081e-01 4.900000000000e-08 -1.042221864367e-14 4.925000000000e-08 3.993211525331e-01 4.950000000000e-08 5.414213562373e-01 4.975000000000e-08 -3.027339492126e-01 5.000000000000e-08 -1.200000000000e+00 5.025000000000e-08 -9.054678984252e-01 5.050000000000e-08 5.857864376268e-02 5.075000000000e-08 3.496605762666e-01 5.100000000000e-08 8.146261443187e-15 5.125000000000e-08 -3.363572758385e-02 5.150000000000e-08 2.585786437627e-01 5.175000000000e-08 2.198912367380e-01 5.200000000000e-08 -3.608224830032e-15 5.225000000000e-08 1.397824734759e-01 5.250000000000e-08 3.414213562373e-01 5.275000000000e-08 1.331821362081e-01 5.300000000000e-08 -7.688294445529e-15 5.325000000000e-08 3.993211525331e-01 5.350000000000e-08 5.414213562373e-01 5.375000000000e-08 -3.027339492126e-01 5.400000000000e-08 -1.200000000000e+00 5.425000000000e-08 -9.054678984252e-01 5.450000000000e-08 5.857864376270e-02 5.475000000000e-08 3.496605762665e-01 5.500000000000e-08 1.121325254871e-14 5.525000000000e-08 -3.363572758385e-02 5.550000000000e-08 2.585786437627e-01 5.575000000000e-08 2.198912367379e-01 5.600000000000e-08 -5.051514762044e-15 5.625000000000e-08 1.397824734759e-01 5.650000000000e-08 3.414213562373e-01 5.675000000000e-08 1.331821362081e-01 5.700000000000e-08 -6.411537967210e-15 5.725000000000e-08 3.993211525331e-01 5.750000000000e-08 5.414213562373e-01 5.775000000000e-08 -3.027339492126e-01 5.800000000000e-08 -1.200000000000e+00 5.825000000000e-08 -9.054678984252e-01 5.850000000000e-08 5.857864376269e-02 5.875000000000e-08 3.496605762665e-01 5.900000000000e-08 -2.803313137179e-15 5.925000000000e-08 -3.363572758384e-02 5.950000000000e-08 2.585786437627e-01 5.975000000000e-08 2.198912367380e-01 6.000000000000e-08 -9.214851104389e-15 6.025000000000e-08 1.397824734759e-01 6.050000000000e-08 3.414213562373e-01 6.075000000000e-08 1.331821362081e-01 6.100000000000e-08 -5.051514762044e-15 6.125000000000e-08 3.993211525331e-01 6.150000000000e-08 5.414213562373e-01 6.175000000000e-08 -3.027339492126e-01 6.200000000000e-08 -1.200000000000e+00 6.225000000000e-08 -9.054678984252e-01 6.250000000000e-08 5.857864376272e-02 6.275000000000e-08 3.496605762665e-01 6.300000000000e-08 2.775557561563e-16 6.325000000000e-08 -3.363572758385e-02 6.350000000000e-08 2.585786437627e-01 6.375000000000e-08 2.198912367380e-01 6.400000000000e-08 -6.272760089132e-15 6.425000000000e-08 1.397824734759e-01 6.450000000000e-08 3.414213562373e-01 6.475000000000e-08 1.331821362081e-01 6.500000000000e-08 -1.079691891448e-14 6.525000000000e-08 3.993211525331e-01 6.550000000000e-08 5.414213562373e-01 6.575000000000e-08 -3.027339492126e-01 6.600000000000e-08 -1.200000000000e+00 6.625000000000e-08 -9.054678984252e-01 6.650000000000e-08 5.857864376270e-02 6.675000000000e-08 3.496605762666e-01 6.700000000000e-08 1.859623566247e-15 6.725000000000e-08 -3.363572758384e-02 6.750000000000e-08 2.585786437627e-01 6.775000000000e-08 2.198912367380e-01 6.800000000000e-08 -3.441691376338e-15 6.825000000000e-08 1.397824734759e-01 6.850000000000e-08 3.414213562373e-01 6.875000000000e-08 1.331821362081e-01 6.900000000000e-08 4.163336342344e-16 6.925000000000e-08 3.993211525331e-01 6.950000000000e-08 5.414213562373e-01 6.975000000000e-08 -3.027339492126e-01 7.000000000000e-08 -1.200000000000e+00 7.025000000000e-08 -9.054678984251e-01 7.050000000000e-08 5.857864376269e-02 7.075000000000e-08 3.496605762665e-01 7.100000000000e-08 3.511080315377e-15 7.125000000000e-08 -3.363572758384e-02 7.150000000000e-08 2.585786437627e-01 7.175000000000e-08 2.198912367379e-01 7.200000000000e-08 -1.942890293094e-15 7.225000000000e-08 1.397824734759e-01 7.250000000000e-08 3.414213562373e-01 7.275000000000e-08 1.331821362081e-01 7.300000000000e-08 1.762479051592e-15 7.325000000000e-08 3.993211525331e-01 7.350000000000e-08 5.414213562373e-01 7.375000000000e-08 -3.027339492126e-01 7.400000000000e-08 -1.200000000000e+00 7.425000000000e-08 -9.054678984251e-01 7.450000000000e-08 5.857864376268e-02 7.475000000000e-08 3.496605762665e-01 7.500000000000e-08 6.480926906249e-15 7.525000000000e-08 -3.363572758385e-02 7.550000000000e-08 2.585786437627e-01 7.575000000000e-08 2.198912367379e-01 7.600000000000e-08 -4.829470157119e-15 7.625000000000e-08 1.397824734759e-01 7.650000000000e-08 3.414213562373e-01 7.675000000000e-08 1.331821362081e-01 7.700000000000e-08 -1.398881011028e-14 7.725000000000e-08 3.993211525331e-01 7.750000000000e-08 5.414213562373e-01 7.775000000000e-08 -3.027339492126e-01 7.800000000000e-08 -1.200000000000e+00 7.825000000000e-08 -9.054678984252e-01 7.850000000000e-08 5.857864376271e-02 7.875000000000e-08 3.496605762665e-01 7.900000000000e-08 9.561795799584e-15 7.925000000000e-08 -3.363572758385e-02 7.950000000000e-08 2.585786437627e-01 7.975000000000e-08 2.198912367380e-01 8.000000000000e-08 -1.887379141863e-15 ]
VWL023 (wl023 0) vsource type=pwl wave=[ 0.000000000000e+00 0.000000000000e+00 2.500000000000e-10 1.801087632620e-01 5.000000000000e-10 -2.426406871193e-02 7.500000000000e-10 -2.336357275839e-01 1.000000000000e-09 9.714451465470e-17 1.250000000000e-09 5.033942373345e-02 1.500000000000e-09 -6.242640687119e-01 1.750000000000e-09 -1.105467898425e+00 2.000000000000e-09 -4.000000000000e-01 2.250000000000e-09 7.027339492126e-01 2.500000000000e-09 8.242640687119e-01 2.750000000000e-09 1.993211525331e-01 3.000000000000e-09 5.412337245048e-16 3.250000000000e-09 2.668178637919e-01 3.500000000000e-09 2.242640687119e-01 3.750000000000e-09 -6.021752652407e-02 4.000000000000e-09 1.193489751472e-15 4.250000000000e-09 1.801087632620e-01 4.500000000000e-09 -2.426406871193e-02 4.750000000000e-09 -2.336357275839e-01 5.000000000000e-09 -4.024558464266e-16 5.250000000000e-09 5.033942373345e-02 5.500000000000e-09 -6.242640687119e-01 5.750000000000e-09 -1.105467898425e+00 6.000000000000e-09 -4.000000000000e-01 6.250000000000e-09 7.027339492126e-01 6.500000000000e-09 8.242640687119e-01 6.750000000000e-09 1.993211525331e-01 7.000000000000e-09 8.743006318923e-16 7.250000000000e-09 2.668178637919e-01 7.500000000000e-09 2.242640687119e-01 7.750000000000e-09 -6.021752652407e-02 8.000000000000e-09 2.373101715136e-15 8.250000000000e-09 1.801087632620e-01 8.500000000000e-09 -2.426406871193e-02 8.750000000000e-09 -2.336357275839e-01 9.000000000000e-09 1.013078509970e-15 9.250000000000e-09 5.033942373345e-02 9.500000000000e-09 -6.242640687119e-01 9.750000000000e-09 -1.105467898425e+00 1.000000000000e-08 -4.000000000000e-01 1.025000000000e-08 7.027339492126e-01 1.050000000000e-08 8.242640687119e-01 1.075000000000e-08 1.993211525331e-01 1.100000000000e-08 7.632783294298e-16 1.125000000000e-08 2.668178637919e-01 1.150000000000e-08 2.242640687119e-01 1.175000000000e-08 -6.021752652407e-02 1.200000000000e-08 4.898859096159e-15 1.225000000000e-08 1.801087632620e-01 1.250000000000e-08 -2.426406871193e-02 1.275000000000e-08 -2.336357275839e-01 1.300000000000e-08 4.163336342344e-17 1.325000000000e-08 5.033942373345e-02 1.350000000000e-08 -6.242640687119e-01 1.375000000000e-08 -1.105467898425e+00 1.400000000000e-08 -4.000000000000e-01 1.425000000000e-08 7.027339492126e-01 1.450000000000e-08 8.242640687119e-01 1.475000000000e-08 1.993211525331e-01 1.500000000000e-08 3.191891195797e-15 1.525000000000e-08 2.668178637919e-01 1.550000000000e-08 2.242640687119e-01 1.575000000000e-08 -6.021752652407e-02 1.600000000000e-08 4.732325642465e-15 1.625000000000e-08 1.801087632620e-01 1.650000000000e-08 -2.426406871193e-02 1.675000000000e-08 -2.336357275839e-01 1.700000000000e-08 -1.110223024625e-16 1.725000000000e-08 5.033942373345e-02 1.750000000000e-08 -6.242640687119e-01 1.775000000000e-08 -1.105467898425e+00 1.800000000000e-08 -4.000000000000e-01 1.825000000000e-08 7.027339492126e-01 1.850000000000e-08 8.242640687119e-01 1.875000000000e-08 1.993211525331e-01 1.900000000000e-08 1.304512053935e-15 1.925000000000e-08 2.668178637919e-01 1.950000000000e-08 2.242640687119e-01 1.975000000000e-08 -6.021752652407e-02 2.000000000000e-08 1.387778780781e-15 2.025000000000e-08 1.801087632620e-01 2.050000000000e-08 -2.426406871193e-02 2.075000000000e-08 -2.336357275839e-01 2.100000000000e-08 4.024558464266e-16 2.125000000000e-08 5.033942373345e-02 2.150000000000e-08 -6.242640687119e-01 2.175000000000e-08 -1.105467898425e+00 2.200000000000e-08 -4.000000000000e-01 2.225000000000e-08 7.027339492126e-01 2.250000000000e-08 8.242640687119e-01 2.275000000000e-08 1.993211525331e-01 2.300000000000e-08 2.955968803064e-15 2.325000000000e-08 2.668178637919e-01 2.350000000000e-08 2.242640687119e-01 2.375000000000e-08 -6.021752652407e-02 2.400000000000e-08 9.769962616701e-15 2.425000000000e-08 1.801087632620e-01 2.450000000000e-08 -2.426406871193e-02 2.475000000000e-08 -2.336357275839e-01 2.500000000000e-08 -4.718447854657e-16 2.525000000000e-08 5.033942373345e-02 2.550000000000e-08 -6.242640687119e-01 2.575000000000e-08 -1.105467898425e+00 2.600000000000e-08 -4.000000000000e-01 2.625000000000e-08 7.027339492126e-01 2.650000000000e-08 8.242640687119e-01 2.675000000000e-08 1.993211525331e-01 2.700000000000e-08 -1.346145417358e-15 2.725000000000e-08 2.668178637919e-01 2.750000000000e-08 2.242640687119e-01 2.775000000000e-08 -6.021752652407e-02 2.800000000000e-08 7.494005416220e-15 2.825000000000e-08 1.801087632620e-01 2.850000000000e-08 -2.426406871193e-02 2.875000000000e-08 -2.336357275839e-01 2.900000000000e-08 -1.443289932013e-15 2.925000000000e-08 5.033942373345e-02 2.950000000000e-08 -6.242640687119e-01 2.975000000000e-08 -1.105467898425e+00 3.000000000000e-08 -4.000000000000e-01 3.025000000000e-08 7.027339492126e-01 3.050000000000e-08 8.242640687119e-01 3.075000000000e-08 1.993211525331e-01 3.100000000000e-08 -7.632783294298e-16 3.125000000000e-08 2.668178637919e-01 3.150000000000e-08 2.242640687119e-01 3.175000000000e-08 -6.021752652407e-02 3.200000000000e-08 9.478529072737e-15 3.225000000000e-08 1.801087632620e-01 3.250000000000e-08 -2.426406871193e-02 3.275000000000e-08 -2.336357275839e-01 3.300000000000e-08 4.052314039882e-15 3.325000000000e-08 5.033942373345e-02 3.350000000000e-08 -6.242640687119e-01 3.375000000000e-08 -1.105467898425e+00 3.400000000000e-08 -4.000000000000e-01 3.425000000000e-08 7.027339492126e-01 3.450000000000e-08 8.242640687119e-01 3.475000000000e-08 1.993211525331e-01 3.500000000000e-08 2.012279232133e-15 3.525000000000e-08 2.668178637919e-01 3.550000000000e-08 2.242640687119e-01 3.575000000000e-08 -6.021752652407e-02 3.600000000000e-08 2.942091015257e-15 3.625000000000e-08 1.801087632620e-01 3.650000000000e-08 -2.426406871193e-02 3.675000000000e-08 -2.336357275839e-01 3.700000000000e-08 -3.233524559221e-15 3.725000000000e-08 5.033942373346e-02 3.750000000000e-08 -6.242640687119e-01 3.775000000000e-08 -1.105467898425e+00 3.800000000000e-08 -4.000000000000e-01 3.825000000000e-08 7.027339492126e-01 3.850000000000e-08 8.242640687119e-01 3.875000000000e-08 1.993211525331e-01 3.900000000000e-08 7.591149930875e-15 3.925000000000e-08 2.668178637919e-01 3.950000000000e-08 2.242640687119e-01 3.975000000000e-08 -6.021752652407e-02 4.000000000000e-08 2.789435349371e-15 4.025000000000e-08 1.801087632620e-01 4.050000000000e-08 -2.426406871194e-02 4.075000000000e-08 -2.336357275839e-01 4.100000000000e-08 2.275957200482e-15 4.125000000000e-08 5.033942373345e-02 4.150000000000e-08 -6.242640687119e-01 4.175000000000e-08 -1.105467898425e+00 4.200000000000e-08 -4.000000000000e-01 4.225000000000e-08 7.027339492126e-01 4.250000000000e-08 8.242640687119e-01 4.275000000000e-08 1.993211525331e-01 4.300000000000e-08 -1.748601263785e-15 4.325000000000e-08 2.668178637919e-01 4.350000000000e-08 2.242640687119e-01 4.375000000000e-08 -6.021752652407e-02 4.400000000000e-08 6.911138328292e-15 4.425000000000e-08 1.801087632620e-01 4.450000000000e-08 -2.426406871193e-02 4.475000000000e-08 -2.336357275839e-01 4.500000000000e-08 7.716050021145e-15 4.525000000000e-08 5.033942373345e-02 4.550000000000e-08 -6.242640687119e-01 4.575000000000e-08 -1.105467898425e+00 4.600000000000e-08 -4.000000000000e-01 4.625000000000e-08 7.027339492126e-01 4.650000000000e-08 8.242640687119e-01 4.675000000000e-08 1.993211525331e-01 4.700000000000e-08 9.714451465470e-16 4.725000000000e-08 2.668178637919e-01 4.750000000000e-08 2.242640687119e-01 4.775000000000e-08 -6.021752652407e-02 4.800000000000e-08 1.955380302121e-14 4.825000000000e-08 1.801087632620e-01 4.850000000000e-08 -2.426406871194e-02 4.875000000000e-08 -2.336357275839e-01 4.900000000000e-08 4.302114220422e-16 4.925000000000e-08 5.033942373345e-02 4.950000000000e-08 -6.242640687119e-01 4.975000000000e-08 -1.105467898425e+00 5.000000000000e-08 -4.000000000000e-01 5.025000000000e-08 7.027339492126e-01 5.050000000000e-08 8.242640687119e-01 5.075000000000e-08 1.993211525331e-01 5.100000000000e-08 -5.551115123126e-16 5.125000000000e-08 2.668178637919e-01 5.150000000000e-08 2.242640687119e-01 5.175000000000e-08 -6.021752652407e-02 5.200000000000e-08 1.088018564133e-14 5.225000000000e-08 1.801087632620e-01 5.250000000000e-08 -2.426406871193e-02 5.275000000000e-08 -2.336357275839e-01 5.300000000000e-08 5.925815393937e-15 5.325000000000e-08 5.033942373345e-02 5.350000000000e-08 -6.242640687119e-01 5.375000000000e-08 -1.105467898425e+00 5.400000000000e-08 -4.000000000000e-01 5.425000000000e-08 7.027339492126e-01 5.450000000000e-08 8.242640687119e-01 5.475000000000e-08 1.993211525331e-01 5.500000000000e-08 5.065392549852e-15 5.525000000000e-08 2.668178637919e-01 5.550000000000e-08 2.242640687119e-01 5.575000000000e-08 -6.021752652407e-02 5.600000000000e-08 1.498801083244e-14 5.625000000000e-08 1.801087632620e-01 5.650000000000e-08 -2.426406871194e-02 5.675000000000e-08 -2.336357275839e-01 5.700000000000e-08 1.457167719821e-15 5.725000000000e-08 5.033942373345e-02 5.750000000000e-08 -6.242640687119e-01 5.775000000000e-08 -1.105467898425e+00 5.800000000000e-08 -4.000000000000e-01 5.825000000000e-08 7.027339492126e-01 5.850000000000e-08 8.242640687119e-01 5.875000000000e-08 1.993211525331e-01 5.900000000000e-08 4.968248035198e-15 5.925000000000e-08 2.668178637919e-01 5.950000000000e-08 2.242640687119e-01 5.975000000000e-08 -6.021752652407e-02 6.000000000000e-08 2.765843110097e-14 6.025000000000e-08 1.801087632620e-01 6.050000000000e-08 -2.426406871195e-02 6.075000000000e-08 -2.336357275839e-01 6.100000000000e-08 -2.942091015257e-15 6.125000000000e-08 5.033942373345e-02 6.150000000000e-08 -6.242640687119e-01 6.175000000000e-08 -1.105467898425e+00 6.200000000000e-08 -4.000000000000e-01 6.225000000000e-08 7.027339492126e-01 6.250000000000e-08 8.242640687119e-01 6.275000000000e-08 1.993211525331e-01 6.300000000000e-08 1.051936315832e-14 6.325000000000e-08 2.668178637919e-01 6.350000000000e-08 2.242640687119e-01 6.375000000000e-08 -6.021752652407e-02 6.400000000000e-08 1.897093593328e-14 6.425000000000e-08 1.801087632620e-01 6.450000000000e-08 -2.426406871195e-02 6.475000000000e-08 -2.336357275839e-01 6.500000000000e-08 -3.330669073875e-16 6.525000000000e-08 5.033942373345e-02 6.550000000000e-08 -6.242640687119e-01 6.575000000000e-08 -1.105467898425e+00 6.600000000000e-08 -4.000000000000e-01 6.625000000000e-08 7.027339492126e-01 6.650000000000e-08 8.242640687119e-01 6.675000000000e-08 1.993211525331e-01 6.700000000000e-08 6.161737786670e-15 6.725000000000e-08 2.668178637919e-01 6.750000000000e-08 2.242640687119e-01 6.775000000000e-08 -6.021752652407e-02 6.800000000000e-08 1.028344076559e-14 6.825000000000e-08 1.801087632620e-01 6.850000000000e-08 -2.426406871194e-02 6.875000000000e-08 -2.336357275839e-01 6.900000000000e-08 7.993605777301e-15 6.925000000000e-08 5.033942373346e-02 6.950000000000e-08 -6.242640687119e-01 6.975000000000e-08 -1.105467898425e+00 7.000000000000e-08 -4.000000000000e-01 7.025000000000e-08 7.027339492126e-01 7.050000000000e-08 8.242640687119e-01 7.075000000000e-08 1.993211525331e-01 7.100000000000e-08 1.817990202824e-15 7.125000000000e-08 2.668178637919e-01 7.150000000000e-08 2.242640687119e-01 7.175000000000e-08 -6.021752652407e-02 7.200000000000e-08 5.884182030513e-15 7.225000000000e-08 1.801087632620e-01 7.250000000000e-08 -2.426406871194e-02 7.275000000000e-08 -2.336357275839e-01 7.300000000000e-08 3.524958103185e-15 7.325000000000e-08 5.033942373344e-02 7.350000000000e-08 -6.242640687119e-01 7.375000000000e-08 -1.105467898425e+00 7.400000000000e-08 -4.000000000000e-01 7.425000000000e-08 7.027339492126e-01 7.450000000000e-08 8.242640687119e-01 7.475000000000e-08 1.993211525331e-01 7.500000000000e-08 7.369105325949e-15 7.525000000000e-08 2.668178637919e-01 7.550000000000e-08 2.242640687119e-01 7.575000000000e-08 -6.021752652407e-02 7.600000000000e-08 1.426636586643e-14 7.625000000000e-08 1.801087632620e-01 7.650000000000e-08 -2.426406871193e-02 7.675000000000e-08 -2.336357275839e-01 7.700000000000e-08 -6.647460359943e-15 7.725000000000e-08 5.033942373345e-02 7.750000000000e-08 -6.242640687119e-01 7.775000000000e-08 -1.105467898425e+00 7.800000000000e-08 -4.000000000000e-01 7.825000000000e-08 7.027339492126e-01 7.850000000000e-08 8.242640687119e-01 7.875000000000e-08 1.993211525331e-01 7.900000000000e-08 1.297573160031e-14 7.925000000000e-08 2.668178637919e-01 7.950000000000e-08 2.242640687119e-01 7.975000000000e-08 -6.021752652407e-02 8.000000000000e-08 5.578870698741e-15 ]
VWL024 (wl024 0) vsource type=pwl wave=[ 0.000000000000e+00 0.000000000000e+00 2.500000000000e-10 -1.397824734759e-01 5.000000000000e-10 -3.414213562373e-01 7.500000000000e-10 -1.331821362081e-01 1.000000000000e-09 9.714451465470e-17 1.250000000000e-09 -3.993211525331e-01 1.500000000000e-09 -5.414213562373e-01 1.750000000000e-09 3.027339492126e-01 2.000000000000e-09 1.200000000000e+00 2.250000000000e-09 9.054678984252e-01 2.500000000000e-09 -5.857864376269e-02 2.750000000000e-09 -3.496605762665e-01 3.000000000000e-09 -2.636779683485e-16 3.250000000000e-09 3.363572758386e-02 3.500000000000e-09 -2.585786437627e-01 3.750000000000e-09 -2.198912367380e-01 4.000000000000e-09 3.885780586188e-16 4.250000000000e-09 -1.397824734759e-01 4.500000000000e-09 -3.414213562373e-01 4.750000000000e-09 -1.331821362081e-01 5.000000000000e-09 6.522560269673e-16 5.250000000000e-09 -3.993211525331e-01 5.500000000000e-09 -5.414213562373e-01 5.750000000000e-09 3.027339492126e-01 6.000000000000e-09 1.200000000000e+00 6.250000000000e-09 9.054678984252e-01 6.500000000000e-09 -5.857864376269e-02 6.750000000000e-09 -3.496605762665e-01 7.000000000000e-09 2.775557561563e-17 7.250000000000e-09 3.363572758386e-02 7.500000000000e-09 -2.585786437627e-01 7.750000000000e-09 -2.198912367380e-01 8.000000000000e-09 8.326672684689e-16 8.250000000000e-09 -1.397824734759e-01 8.500000000000e-09 -3.414213562373e-01 8.750000000000e-09 -1.331821362081e-01 9.000000000000e-09 -4.579669976579e-16 9.250000000000e-09 -3.993211525331e-01 9.500000000000e-09 -5.414213562373e-01 9.750000000000e-09 3.027339492126e-01 1.000000000000e-08 1.200000000000e+00 1.025000000000e-08 9.054678984252e-01 1.050000000000e-08 -5.857864376269e-02 1.075000000000e-08 -3.496605762665e-01 1.100000000000e-08 -1.804112415016e-16 1.125000000000e-08 3.363572758386e-02 1.150000000000e-08 -2.585786437627e-01 1.175000000000e-08 -2.198912367380e-01 1.200000000000e-08 1.609823385706e-15 1.225000000000e-08 -1.397824734759e-01 1.250000000000e-08 -3.414213562373e-01 1.275000000000e-08 -1.331821362081e-01 1.300000000000e-08 1.706967900361e-15 1.325000000000e-08 -3.993211525331e-01 1.350000000000e-08 -5.414213562373e-01 1.375000000000e-08 3.027339492126e-01 1.400000000000e-08 1.200000000000e+00 1.425000000000e-08 9.054678984252e-01 1.450000000000e-08 -5.857864376269e-02 1.475000000000e-08 -3.496605762665e-01 1.500000000000e-08 -7.216449660064e-16 1.525000000000e-08 3.363572758386e-02 1.550000000000e-08 -2.585786437627e-01 1.575000000000e-08 -2.198912367380e-01 1.600000000000e-08 1.554312234475e-15 1.625000000000e-08 -1.397824734759e-01 1.650000000000e-08 -3.414213562373e-01 1.675000000000e-08 -1.331821362081e-01 1.700000000000e-08 1.804112415016e-15 1.725000000000e-08 -3.993211525331e-01 1.750000000000e-08 -5.414213562373e-01 1.775000000000e-08 3.027339492126e-01 1.800000000000e-08 1.200000000000e+00 1.825000000000e-08 9.054678984252e-01 1.850000000000e-08 -5.857864376269e-02 1.875000000000e-08 -3.496605762665e-01 1.900000000000e-08 -2.720046410332e-15 1.925000000000e-08 3.363572758386e-02 1.950000000000e-08 -2.585786437627e-01 1.975000000000e-08 -2.198912367380e-01 2.000000000000e-08 4.440892098501e-16 2.025000000000e-08 -1.397824734759e-01 2.050000000000e-08 -3.414213562373e-01 2.075000000000e-08 -1.331821362081e-01 2.100000000000e-08 -1.804112415016e-16 2.125000000000e-08 -3.993211525331e-01 2.150000000000e-08 -5.414213562373e-01 2.175000000000e-08 3.027339492126e-01 2.200000000000e-08 1.200000000000e+00 2.225000000000e-08 9.054678984252e-01 2.250000000000e-08 -5.857864376270e-02 2.275000000000e-08 -3.496605762665e-01 2.300000000000e-08 -1.137978600241e-15 2.325000000000e-08 3.363572758386e-02 2.350000000000e-08 -2.585786437627e-01 2.375000000000e-08 -2.198912367380e-01 2.400000000000e-08 3.275157922644e-15 2.425000000000e-08 -1.397824734759e-01 2.450000000000e-08 -3.414213562373e-01 2.475000000000e-08 -1.331821362081e-01 2.500000000000e-08 2.040034807749e-15 2.525000000000e-08 -3.993211525331e-01 2.550000000000e-08 -5.414213562373e-01 2.575000000000e-08 3.027339492126e-01 2.600000000000e-08 1.200000000000e+00 2.625000000000e-08 9.054678984252e-01 2.650000000000e-08 -5.857864376270e-02 2.675000000000e-08 -3.496605762665e-01 2.700000000000e-08 -2.775557561563e-15 2.725000000000e-08 3.363572758386e-02 2.750000000000e-08 -2.585786437627e-01 2.775000000000e-08 -2.198912367380e-01 2.800000000000e-08 2.442490654175e-15 2.825000000000e-08 -1.397824734759e-01 2.850000000000e-08 -3.414213562373e-01 2.875000000000e-08 -1.331821362081e-01 2.900000000000e-08 4.260480856999e-15 2.925000000000e-08 -3.993211525331e-01 2.950000000000e-08 -5.414213562373e-01 2.975000000000e-08 3.027339492126e-01 3.000000000000e-08 1.200000000000e+00 3.025000000000e-08 9.054678984252e-01 3.050000000000e-08 -5.857864376269e-02 3.075000000000e-08 -3.496605762665e-01 3.100000000000e-08 -5.065392549852e-15 3.125000000000e-08 3.363572758385e-02 3.150000000000e-08 -2.585786437627e-01 3.175000000000e-08 -2.198912367380e-01 3.200000000000e-08 3.219646771413e-15 3.225000000000e-08 -1.397824734759e-01 3.250000000000e-08 -3.414213562373e-01 3.275000000000e-08 -1.331821362081e-01 3.300000000000e-08 1.471045507628e-15 3.325000000000e-08 -3.993211525331e-01 3.350000000000e-08 -5.414213562373e-01 3.375000000000e-08 3.027339492126e-01 3.400000000000e-08 1.200000000000e+00 3.425000000000e-08 9.054678984252e-01 3.450000000000e-08 -5.857864376270e-02 3.475000000000e-08 -3.496605762665e-01 3.500000000000e-08 4.440892098501e-16 3.525000000000e-08 3.363572758385e-02 3.550000000000e-08 -2.585786437627e-01 3.575000000000e-08 -2.198912367380e-01 3.600000000000e-08 9.992007221626e-16 3.625000000000e-08 -1.397824734759e-01 3.650000000000e-08 -3.414213562373e-01 3.675000000000e-08 -1.331821362081e-01 3.700000000000e-08 8.701372955500e-15 3.725000000000e-08 -3.993211525331e-01 3.750000000000e-08 -5.414213562373e-01 3.775000000000e-08 3.027339492126e-01 3.800000000000e-08 1.200000000000e+00 3.825000000000e-08 9.054678984252e-01 3.850000000000e-08 -5.857864376268e-02 3.875000000000e-08 -3.496605762666e-01 3.900000000000e-08 -2.622901895677e-15 3.925000000000e-08 3.363572758385e-02 3.950000000000e-08 -2.585786437627e-01 3.975000000000e-08 -2.198912367380e-01 4.000000000000e-08 8.881784197001e-16 4.025000000000e-08 -1.397824734759e-01 4.050000000000e-08 -3.414213562373e-01 4.075000000000e-08 -1.331821362081e-01 4.100000000000e-08 5.981326545168e-15 4.125000000000e-08 -3.993211525331e-01 4.150000000000e-08 -5.414213562373e-01 4.175000000000e-08 3.027339492126e-01 4.200000000000e-08 1.200000000000e+00 4.225000000000e-08 9.054678984252e-01 4.250000000000e-08 -5.857864376269e-02 4.275000000000e-08 -3.496605762666e-01 4.300000000000e-08 -3.538835890993e-15 4.325000000000e-08 3.363572758386e-02 4.350000000000e-08 -2.585786437627e-01 4.375000000000e-08 -2.198912367380e-01 4.400000000000e-08 2.331468351713e-15 4.425000000000e-08 -1.397824734759e-01 4.450000000000e-08 -3.414213562373e-01 4.475000000000e-08 -1.331821362081e-01 4.500000000000e-08 3.191891195797e-15 4.525000000000e-08 -3.993211525331e-01 4.550000000000e-08 -5.414213562373e-01 4.575000000000e-08 3.027339492126e-01 4.600000000000e-08 1.200000000000e+00 4.625000000000e-08 9.054678984252e-01 4.650000000000e-08 -5.857864376270e-02 4.675000000000e-08 -3.496605762665e-01 4.700000000000e-08 1.970645868710e-15 4.725000000000e-08 3.363572758386e-02 4.750000000000e-08 -2.585786437627e-01 4.775000000000e-08 -2.198912367380e-01 4.800000000000e-08 6.550315845288e-15 4.825000000000e-08 -1.397824734759e-01 4.850000000000e-08 -3.414213562373e-01 4.875000000000e-08 -1.331821362081e-01 4.900000000000e-08 1.042221864367e-14 4.925000000000e-08 -3.993211525331e-01 4.950000000000e-08 -5.414213562373e-01 4.975000000000e-08 3.027339492126e-01 5.000000000000e-08 1.200000000000e+00 5.025000000000e-08 9.054678984252e-01 5.050000000000e-08 -5.857864376268e-02 5.075000000000e-08 -3.496605762666e-01 5.100000000000e-08 -8.146261443187e-15 5.125000000000e-08 3.363572758385e-02 5.150000000000e-08 -2.585786437627e-01 5.175000000000e-08 -2.198912367380e-01 5.200000000000e-08 3.608224830032e-15 5.225000000000e-08 -1.397824734759e-01 5.250000000000e-08 -3.414213562373e-01 5.275000000000e-08 -1.331821362081e-01 5.300000000000e-08 7.688294445529e-15 5.325000000000e-08 -3.993211525331e-01 5.350000000000e-08 -5.414213562373e-01 5.375000000000e-08 3.027339492126e-01 5.400000000000e-08 1.200000000000e+00 5.425000000000e-08 9.054678984252e-01 5.450000000000e-08 -5.857864376270e-02 5.475000000000e-08 -3.496605762665e-01 5.500000000000e-08 -1.121325254871e-14 5.525000000000e-08 3.363572758385e-02 5.550000000000e-08 -2.585786437627e-01 5.575000000000e-08 -2.198912367379e-01 5.600000000000e-08 5.051514762044e-15 5.625000000000e-08 -1.397824734759e-01 5.650000000000e-08 -3.414213562373e-01 5.675000000000e-08 -1.331821362081e-01 5.700000000000e-08 6.411537967210e-15 5.725000000000e-08 -3.993211525331e-01 5.750000000000e-08 -5.414213562373e-01 5.775000000000e-08 3.027339492126e-01 5.800000000000e-08 1.200000000000e+00 5.825000000000e-08 9.054678984252e-01 5.850000000000e-08 -5.857864376269e-02 5.875000000000e-08 -3.496605762665e-01 5.900000000000e-08 2.803313137179e-15 5.925000000000e-08 3.363572758384e-02 5.950000000000e-08 -2.585786437627e-01 5.975000000000e-08 -2.198912367380e-01 6.000000000000e-08 9.214851104389e-15 6.025000000000e-08 -1.397824734759e-01 6.050000000000e-08 -3.414213562373e-01 6.075000000000e-08 -1.331821362081e-01 6.100000000000e-08 5.051514762044e-15 6.125000000000e-08 -3.993211525331e-01 6.150000000000e-08 -5.414213562373e-01 6.175000000000e-08 3.027339492126e-01 6.200000000000e-08 1.200000000000e+00 6.225000000000e-08 9.054678984252e-01 6.250000000000e-08 -5.857864376272e-02 6.275000000000e-08 -3.496605762665e-01 6.300000000000e-08 -2.775557561563e-16 6.325000000000e-08 3.363572758385e-02 6.350000000000e-08 -2.585786437627e-01 6.375000000000e-08 -2.198912367380e-01 6.400000000000e-08 6.272760089132e-15 6.425000000000e-08 -1.397824734759e-01 6.450000000000e-08 -3.414213562373e-01 6.475000000000e-08 -1.331821362081e-01 6.500000000000e-08 1.079691891448e-14 6.525000000000e-08 -3.993211525331e-01 6.550000000000e-08 -5.414213562373e-01 6.575000000000e-08 3.027339492126e-01 6.600000000000e-08 1.200000000000e+00 6.625000000000e-08 9.054678984252e-01 6.650000000000e-08 -5.857864376270e-02 6.675000000000e-08 -3.496605762666e-01 6.700000000000e-08 -1.859623566247e-15 6.725000000000e-08 3.363572758384e-02 6.750000000000e-08 -2.585786437627e-01 6.775000000000e-08 -2.198912367380e-01 6.800000000000e-08 3.441691376338e-15 6.825000000000e-08 -1.397824734759e-01 6.850000000000e-08 -3.414213562373e-01 6.875000000000e-08 -1.331821362081e-01 6.900000000000e-08 -4.163336342344e-16 6.925000000000e-08 -3.993211525331e-01 6.950000000000e-08 -5.414213562373e-01 6.975000000000e-08 3.027339492126e-01 7.000000000000e-08 1.200000000000e+00 7.025000000000e-08 9.054678984251e-01 7.050000000000e-08 -5.857864376269e-02 7.075000000000e-08 -3.496605762665e-01 7.100000000000e-08 -3.511080315377e-15 7.125000000000e-08 3.363572758384e-02 7.150000000000e-08 -2.585786437627e-01 7.175000000000e-08 -2.198912367379e-01 7.200000000000e-08 1.942890293094e-15 7.225000000000e-08 -1.397824734759e-01 7.250000000000e-08 -3.414213562373e-01 7.275000000000e-08 -1.331821362081e-01 7.300000000000e-08 -1.762479051592e-15 7.325000000000e-08 -3.993211525331e-01 7.350000000000e-08 -5.414213562373e-01 7.375000000000e-08 3.027339492126e-01 7.400000000000e-08 1.200000000000e+00 7.425000000000e-08 9.054678984251e-01 7.450000000000e-08 -5.857864376268e-02 7.475000000000e-08 -3.496605762665e-01 7.500000000000e-08 -6.480926906249e-15 7.525000000000e-08 3.363572758385e-02 7.550000000000e-08 -2.585786437627e-01 7.575000000000e-08 -2.198912367379e-01 7.600000000000e-08 4.829470157119e-15 7.625000000000e-08 -1.397824734759e-01 7.650000000000e-08 -3.414213562373e-01 7.675000000000e-08 -1.331821362081e-01 7.700000000000e-08 1.398881011028e-14 7.725000000000e-08 -3.993211525331e-01 7.750000000000e-08 -5.414213562373e-01 7.775000000000e-08 3.027339492126e-01 7.800000000000e-08 1.200000000000e+00 7.825000000000e-08 9.054678984252e-01 7.850000000000e-08 -5.857864376271e-02 7.875000000000e-08 -3.496605762665e-01 7.900000000000e-08 -9.561795799584e-15 7.925000000000e-08 3.363572758385e-02 7.950000000000e-08 -2.585786437627e-01 7.975000000000e-08 -2.198912367380e-01 8.000000000000e-08 1.887379141863e-15 ]
VWL025 (wl025 0) vsource type=pwl wave=[ 0.000000000000e+00 0.000000000000e+00 2.500000000000e-10 -1.801087632620e-01 5.000000000000e-10 2.426406871193e-02 7.500000000000e-10 2.336357275839e-01 1.000000000000e-09 -9.714451465470e-17 1.250000000000e-09 -5.033942373345e-02 1.500000000000e-09 6.242640687119e-01 1.750000000000e-09 1.105467898425e+00 2.000000000000e-09 4.000000000000e-01 2.250000000000e-09 -7.027339492126e-01 2.500000000000e-09 -8.242640687119e-01 2.750000000000e-09 -1.993211525331e-01 3.000000000000e-09 -5.412337245048e-16 3.250000000000e-09 -2.668178637919e-01 3.500000000000e-09 -2.242640687119e-01 3.750000000000e-09 6.021752652407e-02 4.000000000000e-09 -1.193489751472e-15 4.250000000000e-09 -1.801087632620e-01 4.500000000000e-09 2.426406871193e-02 4.750000000000e-09 2.336357275839e-01 5.000000000000e-09 4.024558464266e-16 5.250000000000e-09 -5.033942373345e-02 5.500000000000e-09 6.242640687119e-01 5.750000000000e-09 1.105467898425e+00 6.000000000000e-09 4.000000000000e-01 6.250000000000e-09 -7.027339492126e-01 6.500000000000e-09 -8.242640687119e-01 6.750000000000e-09 -1.993211525331e-01 7.000000000000e-09 -8.743006318923e-16 7.250000000000e-09 -2.668178637919e-01 7.500000000000e-09 -2.242640687119e-01 7.750000000000e-09 6.021752652407e-02 8.000000000000e-09 -2.373101715136e-15 8.250000000000e-09 -1.801087632620e-01 8.500000000000e-09 2.426406871193e-02 8.750000000000e-09 2.336357275839e-01 9.000000000000e-09 -1.013078509970e-15 9.250000000000e-09 -5.033942373345e-02 9.500000000000e-09 6.242640687119e-01 9.750000000000e-09 1.105467898425e+00 1.000000000000e-08 4.000000000000e-01 1.025000000000e-08 -7.027339492126e-01 1.050000000000e-08 -8.242640687119e-01 1.075000000000e-08 -1.993211525331e-01 1.100000000000e-08 -7.632783294298e-16 1.125000000000e-08 -2.668178637919e-01 1.150000000000e-08 -2.242640687119e-01 1.175000000000e-08 6.021752652407e-02 1.200000000000e-08 -4.898859096159e-15 1.225000000000e-08 -1.801087632620e-01 1.250000000000e-08 2.426406871193e-02 1.275000000000e-08 2.336357275839e-01 1.300000000000e-08 -4.163336342344e-17 1.325000000000e-08 -5.033942373345e-02 1.350000000000e-08 6.242640687119e-01 1.375000000000e-08 1.105467898425e+00 1.400000000000e-08 4.000000000000e-01 1.425000000000e-08 -7.027339492126e-01 1.450000000000e-08 -8.242640687119e-01 1.475000000000e-08 -1.993211525331e-01 1.500000000000e-08 -3.191891195797e-15 1.525000000000e-08 -2.668178637919e-01 1.550000000000e-08 -2.242640687119e-01 1.575000000000e-08 6.021752652407e-02 1.600000000000e-08 -4.732325642465e-15 1.625000000000e-08 -1.801087632620e-01 1.650000000000e-08 2.426406871193e-02 1.675000000000e-08 2.336357275839e-01 1.700000000000e-08 1.110223024625e-16 1.725000000000e-08 -5.033942373345e-02 1.750000000000e-08 6.242640687119e-01 1.775000000000e-08 1.105467898425e+00 1.800000000000e-08 4.000000000000e-01 1.825000000000e-08 -7.027339492126e-01 1.850000000000e-08 -8.242640687119e-01 1.875000000000e-08 -1.993211525331e-01 1.900000000000e-08 -1.304512053935e-15 1.925000000000e-08 -2.668178637919e-01 1.950000000000e-08 -2.242640687119e-01 1.975000000000e-08 6.021752652407e-02 2.000000000000e-08 -1.387778780781e-15 2.025000000000e-08 -1.801087632620e-01 2.050000000000e-08 2.426406871193e-02 2.075000000000e-08 2.336357275839e-01 2.100000000000e-08 -4.024558464266e-16 2.125000000000e-08 -5.033942373345e-02 2.150000000000e-08 6.242640687119e-01 2.175000000000e-08 1.105467898425e+00 2.200000000000e-08 4.000000000000e-01 2.225000000000e-08 -7.027339492126e-01 2.250000000000e-08 -8.242640687119e-01 2.275000000000e-08 -1.993211525331e-01 2.300000000000e-08 -2.955968803064e-15 2.325000000000e-08 -2.668178637919e-01 2.350000000000e-08 -2.242640687119e-01 2.375000000000e-08 6.021752652407e-02 2.400000000000e-08 -9.769962616701e-15 2.425000000000e-08 -1.801087632620e-01 2.450000000000e-08 2.426406871193e-02 2.475000000000e-08 2.336357275839e-01 2.500000000000e-08 4.718447854657e-16 2.525000000000e-08 -5.033942373345e-02 2.550000000000e-08 6.242640687119e-01 2.575000000000e-08 1.105467898425e+00 2.600000000000e-08 4.000000000000e-01 2.625000000000e-08 -7.027339492126e-01 2.650000000000e-08 -8.242640687119e-01 2.675000000000e-08 -1.993211525331e-01 2.700000000000e-08 1.346145417358e-15 2.725000000000e-08 -2.668178637919e-01 2.750000000000e-08 -2.242640687119e-01 2.775000000000e-08 6.021752652407e-02 2.800000000000e-08 -7.494005416220e-15 2.825000000000e-08 -1.801087632620e-01 2.850000000000e-08 2.426406871193e-02 2.875000000000e-08 2.336357275839e-01 2.900000000000e-08 1.443289932013e-15 2.925000000000e-08 -5.033942373345e-02 2.950000000000e-08 6.242640687119e-01 2.975000000000e-08 1.105467898425e+00 3.000000000000e-08 4.000000000000e-01 3.025000000000e-08 -7.027339492126e-01 3.050000000000e-08 -8.242640687119e-01 3.075000000000e-08 -1.993211525331e-01 3.100000000000e-08 7.632783294298e-16 3.125000000000e-08 -2.668178637919e-01 3.150000000000e-08 -2.242640687119e-01 3.175000000000e-08 6.021752652407e-02 3.200000000000e-08 -9.478529072737e-15 3.225000000000e-08 -1.801087632620e-01 3.250000000000e-08 2.426406871193e-02 3.275000000000e-08 2.336357275839e-01 3.300000000000e-08 -4.052314039882e-15 3.325000000000e-08 -5.033942373345e-02 3.350000000000e-08 6.242640687119e-01 3.375000000000e-08 1.105467898425e+00 3.400000000000e-08 4.000000000000e-01 3.425000000000e-08 -7.027339492126e-01 3.450000000000e-08 -8.242640687119e-01 3.475000000000e-08 -1.993211525331e-01 3.500000000000e-08 -2.012279232133e-15 3.525000000000e-08 -2.668178637919e-01 3.550000000000e-08 -2.242640687119e-01 3.575000000000e-08 6.021752652407e-02 3.600000000000e-08 -2.942091015257e-15 3.625000000000e-08 -1.801087632620e-01 3.650000000000e-08 2.426406871193e-02 3.675000000000e-08 2.336357275839e-01 3.700000000000e-08 3.233524559221e-15 3.725000000000e-08 -5.033942373346e-02 3.750000000000e-08 6.242640687119e-01 3.775000000000e-08 1.105467898425e+00 3.800000000000e-08 4.000000000000e-01 3.825000000000e-08 -7.027339492126e-01 3.850000000000e-08 -8.242640687119e-01 3.875000000000e-08 -1.993211525331e-01 3.900000000000e-08 -7.591149930875e-15 3.925000000000e-08 -2.668178637919e-01 3.950000000000e-08 -2.242640687119e-01 3.975000000000e-08 6.021752652407e-02 4.000000000000e-08 -2.789435349371e-15 4.025000000000e-08 -1.801087632620e-01 4.050000000000e-08 2.426406871194e-02 4.075000000000e-08 2.336357275839e-01 4.100000000000e-08 -2.275957200482e-15 4.125000000000e-08 -5.033942373345e-02 4.150000000000e-08 6.242640687119e-01 4.175000000000e-08 1.105467898425e+00 4.200000000000e-08 4.000000000000e-01 4.225000000000e-08 -7.027339492126e-01 4.250000000000e-08 -8.242640687119e-01 4.275000000000e-08 -1.993211525331e-01 4.300000000000e-08 1.748601263785e-15 4.325000000000e-08 -2.668178637919e-01 4.350000000000e-08 -2.242640687119e-01 4.375000000000e-08 6.021752652407e-02 4.400000000000e-08 -6.911138328292e-15 4.425000000000e-08 -1.801087632620e-01 4.450000000000e-08 2.426406871193e-02 4.475000000000e-08 2.336357275839e-01 4.500000000000e-08 -7.716050021145e-15 4.525000000000e-08 -5.033942373345e-02 4.550000000000e-08 6.242640687119e-01 4.575000000000e-08 1.105467898425e+00 4.600000000000e-08 4.000000000000e-01 4.625000000000e-08 -7.027339492126e-01 4.650000000000e-08 -8.242640687119e-01 4.675000000000e-08 -1.993211525331e-01 4.700000000000e-08 -9.714451465470e-16 4.725000000000e-08 -2.668178637919e-01 4.750000000000e-08 -2.242640687119e-01 4.775000000000e-08 6.021752652407e-02 4.800000000000e-08 -1.955380302121e-14 4.825000000000e-08 -1.801087632620e-01 4.850000000000e-08 2.426406871194e-02 4.875000000000e-08 2.336357275839e-01 4.900000000000e-08 -4.302114220422e-16 4.925000000000e-08 -5.033942373345e-02 4.950000000000e-08 6.242640687119e-01 4.975000000000e-08 1.105467898425e+00 5.000000000000e-08 4.000000000000e-01 5.025000000000e-08 -7.027339492126e-01 5.050000000000e-08 -8.242640687119e-01 5.075000000000e-08 -1.993211525331e-01 5.100000000000e-08 5.551115123126e-16 5.125000000000e-08 -2.668178637919e-01 5.150000000000e-08 -2.242640687119e-01 5.175000000000e-08 6.021752652407e-02 5.200000000000e-08 -1.088018564133e-14 5.225000000000e-08 -1.801087632620e-01 5.250000000000e-08 2.426406871193e-02 5.275000000000e-08 2.336357275839e-01 5.300000000000e-08 -5.925815393937e-15 5.325000000000e-08 -5.033942373345e-02 5.350000000000e-08 6.242640687119e-01 5.375000000000e-08 1.105467898425e+00 5.400000000000e-08 4.000000000000e-01 5.425000000000e-08 -7.027339492126e-01 5.450000000000e-08 -8.242640687119e-01 5.475000000000e-08 -1.993211525331e-01 5.500000000000e-08 -5.065392549852e-15 5.525000000000e-08 -2.668178637919e-01 5.550000000000e-08 -2.242640687119e-01 5.575000000000e-08 6.021752652407e-02 5.600000000000e-08 -1.498801083244e-14 5.625000000000e-08 -1.801087632620e-01 5.650000000000e-08 2.426406871194e-02 5.675000000000e-08 2.336357275839e-01 5.700000000000e-08 -1.457167719821e-15 5.725000000000e-08 -5.033942373345e-02 5.750000000000e-08 6.242640687119e-01 5.775000000000e-08 1.105467898425e+00 5.800000000000e-08 4.000000000000e-01 5.825000000000e-08 -7.027339492126e-01 5.850000000000e-08 -8.242640687119e-01 5.875000000000e-08 -1.993211525331e-01 5.900000000000e-08 -4.968248035198e-15 5.925000000000e-08 -2.668178637919e-01 5.950000000000e-08 -2.242640687119e-01 5.975000000000e-08 6.021752652407e-02 6.000000000000e-08 -2.765843110097e-14 6.025000000000e-08 -1.801087632620e-01 6.050000000000e-08 2.426406871195e-02 6.075000000000e-08 2.336357275839e-01 6.100000000000e-08 2.942091015257e-15 6.125000000000e-08 -5.033942373345e-02 6.150000000000e-08 6.242640687119e-01 6.175000000000e-08 1.105467898425e+00 6.200000000000e-08 4.000000000000e-01 6.225000000000e-08 -7.027339492126e-01 6.250000000000e-08 -8.242640687119e-01 6.275000000000e-08 -1.993211525331e-01 6.300000000000e-08 -1.051936315832e-14 6.325000000000e-08 -2.668178637919e-01 6.350000000000e-08 -2.242640687119e-01 6.375000000000e-08 6.021752652407e-02 6.400000000000e-08 -1.897093593328e-14 6.425000000000e-08 -1.801087632620e-01 6.450000000000e-08 2.426406871195e-02 6.475000000000e-08 2.336357275839e-01 6.500000000000e-08 3.330669073875e-16 6.525000000000e-08 -5.033942373345e-02 6.550000000000e-08 6.242640687119e-01 6.575000000000e-08 1.105467898425e+00 6.600000000000e-08 4.000000000000e-01 6.625000000000e-08 -7.027339492126e-01 6.650000000000e-08 -8.242640687119e-01 6.675000000000e-08 -1.993211525331e-01 6.700000000000e-08 -6.161737786670e-15 6.725000000000e-08 -2.668178637919e-01 6.750000000000e-08 -2.242640687119e-01 6.775000000000e-08 6.021752652407e-02 6.800000000000e-08 -1.028344076559e-14 6.825000000000e-08 -1.801087632620e-01 6.850000000000e-08 2.426406871194e-02 6.875000000000e-08 2.336357275839e-01 6.900000000000e-08 -7.993605777301e-15 6.925000000000e-08 -5.033942373346e-02 6.950000000000e-08 6.242640687119e-01 6.975000000000e-08 1.105467898425e+00 7.000000000000e-08 4.000000000000e-01 7.025000000000e-08 -7.027339492126e-01 7.050000000000e-08 -8.242640687119e-01 7.075000000000e-08 -1.993211525331e-01 7.100000000000e-08 -1.817990202824e-15 7.125000000000e-08 -2.668178637919e-01 7.150000000000e-08 -2.242640687119e-01 7.175000000000e-08 6.021752652407e-02 7.200000000000e-08 -5.884182030513e-15 7.225000000000e-08 -1.801087632620e-01 7.250000000000e-08 2.426406871194e-02 7.275000000000e-08 2.336357275839e-01 7.300000000000e-08 -3.524958103185e-15 7.325000000000e-08 -5.033942373344e-02 7.350000000000e-08 6.242640687119e-01 7.375000000000e-08 1.105467898425e+00 7.400000000000e-08 4.000000000000e-01 7.425000000000e-08 -7.027339492126e-01 7.450000000000e-08 -8.242640687119e-01 7.475000000000e-08 -1.993211525331e-01 7.500000000000e-08 -7.369105325949e-15 7.525000000000e-08 -2.668178637919e-01 7.550000000000e-08 -2.242640687119e-01 7.575000000000e-08 6.021752652407e-02 7.600000000000e-08 -1.426636586643e-14 7.625000000000e-08 -1.801087632620e-01 7.650000000000e-08 2.426406871193e-02 7.675000000000e-08 2.336357275839e-01 7.700000000000e-08 6.647460359943e-15 7.725000000000e-08 -5.033942373345e-02 7.750000000000e-08 6.242640687119e-01 7.775000000000e-08 1.105467898425e+00 7.800000000000e-08 4.000000000000e-01 7.825000000000e-08 -7.027339492126e-01 7.850000000000e-08 -8.242640687119e-01 7.875000000000e-08 -1.993211525331e-01 7.900000000000e-08 -1.297573160031e-14 7.925000000000e-08 -2.668178637919e-01 7.950000000000e-08 -2.242640687119e-01 7.975000000000e-08 6.021752652407e-02 8.000000000000e-08 -5.578870698741e-15 ]
VWL026 (wl026 0) vsource type=pwl wave=[ 0.000000000000e+00 0.000000000000e+00 2.500000000000e-10 1.397824734759e-01 5.000000000000e-10 3.414213562373e-01 7.500000000000e-10 1.331821362081e-01 1.000000000000e-09 -9.714451465470e-17 1.250000000000e-09 3.993211525331e-01 1.500000000000e-09 5.414213562373e-01 1.750000000000e-09 -3.027339492126e-01 2.000000000000e-09 -1.200000000000e+00 2.250000000000e-09 -9.054678984252e-01 2.500000000000e-09 5.857864376269e-02 2.750000000000e-09 3.496605762665e-01 3.000000000000e-09 2.636779683485e-16 3.250000000000e-09 -3.363572758386e-02 3.500000000000e-09 2.585786437627e-01 3.750000000000e-09 2.198912367380e-01 4.000000000000e-09 -3.885780586188e-16 4.250000000000e-09 1.397824734759e-01 4.500000000000e-09 3.414213562373e-01 4.750000000000e-09 1.331821362081e-01 5.000000000000e-09 -6.522560269673e-16 5.250000000000e-09 3.993211525331e-01 5.500000000000e-09 5.414213562373e-01 5.750000000000e-09 -3.027339492126e-01 6.000000000000e-09 -1.200000000000e+00 6.250000000000e-09 -9.054678984252e-01 6.500000000000e-09 5.857864376269e-02 6.750000000000e-09 3.496605762665e-01 7.000000000000e-09 -2.775557561563e-17 7.250000000000e-09 -3.363572758386e-02 7.500000000000e-09 2.585786437627e-01 7.750000000000e-09 2.198912367380e-01 8.000000000000e-09 -8.326672684689e-16 8.250000000000e-09 1.397824734759e-01 8.500000000000e-09 3.414213562373e-01 8.750000000000e-09 1.331821362081e-01 9.000000000000e-09 4.579669976579e-16 9.250000000000e-09 3.993211525331e-01 9.500000000000e-09 5.414213562373e-01 9.750000000000e-09 -3.027339492126e-01 1.000000000000e-08 -1.200000000000e+00 1.025000000000e-08 -9.054678984252e-01 1.050000000000e-08 5.857864376269e-02 1.075000000000e-08 3.496605762665e-01 1.100000000000e-08 1.804112415016e-16 1.125000000000e-08 -3.363572758386e-02 1.150000000000e-08 2.585786437627e-01 1.175000000000e-08 2.198912367380e-01 1.200000000000e-08 -1.609823385706e-15 1.225000000000e-08 1.397824734759e-01 1.250000000000e-08 3.414213562373e-01 1.275000000000e-08 1.331821362081e-01 1.300000000000e-08 -1.706967900361e-15 1.325000000000e-08 3.993211525331e-01 1.350000000000e-08 5.414213562373e-01 1.375000000000e-08 -3.027339492126e-01 1.400000000000e-08 -1.200000000000e+00 1.425000000000e-08 -9.054678984252e-01 1.450000000000e-08 5.857864376269e-02 1.475000000000e-08 3.496605762665e-01 1.500000000000e-08 7.216449660064e-16 1.525000000000e-08 -3.363572758386e-02 1.550000000000e-08 2.585786437627e-01 1.575000000000e-08 2.198912367380e-01 1.600000000000e-08 -1.554312234475e-15 1.625000000000e-08 1.397824734759e-01 1.650000000000e-08 3.414213562373e-01 1.675000000000e-08 1.331821362081e-01 1.700000000000e-08 -1.804112415016e-15 1.725000000000e-08 3.993211525331e-01 1.750000000000e-08 5.414213562373e-01 1.775000000000e-08 -3.027339492126e-01 1.800000000000e-08 -1.200000000000e+00 1.825000000000e-08 -9.054678984252e-01 1.850000000000e-08 5.857864376269e-02 1.875000000000e-08 3.496605762665e-01 1.900000000000e-08 2.720046410332e-15 1.925000000000e-08 -3.363572758386e-02 1.950000000000e-08 2.585786437627e-01 1.975000000000e-08 2.198912367380e-01 2.000000000000e-08 -4.440892098501e-16 2.025000000000e-08 1.397824734759e-01 2.050000000000e-08 3.414213562373e-01 2.075000000000e-08 1.331821362081e-01 2.100000000000e-08 1.804112415016e-16 2.125000000000e-08 3.993211525331e-01 2.150000000000e-08 5.414213562373e-01 2.175000000000e-08 -3.027339492126e-01 2.200000000000e-08 -1.200000000000e+00 2.225000000000e-08 -9.054678984252e-01 2.250000000000e-08 5.857864376270e-02 2.275000000000e-08 3.496605762665e-01 2.300000000000e-08 1.137978600241e-15 2.325000000000e-08 -3.363572758386e-02 2.350000000000e-08 2.585786437627e-01 2.375000000000e-08 2.198912367380e-01 2.400000000000e-08 -3.275157922644e-15 2.425000000000e-08 1.397824734759e-01 2.450000000000e-08 3.414213562373e-01 2.475000000000e-08 1.331821362081e-01 2.500000000000e-08 -2.040034807749e-15 2.525000000000e-08 3.993211525331e-01 2.550000000000e-08 5.414213562373e-01 2.575000000000e-08 -3.027339492126e-01 2.600000000000e-08 -1.200000000000e+00 2.625000000000e-08 -9.054678984252e-01 2.650000000000e-08 5.857864376270e-02 2.675000000000e-08 3.496605762665e-01 2.700000000000e-08 2.775557561563e-15 2.725000000000e-08 -3.363572758386e-02 2.750000000000e-08 2.585786437627e-01 2.775000000000e-08 2.198912367380e-01 2.800000000000e-08 -2.442490654175e-15 2.825000000000e-08 1.397824734759e-01 2.850000000000e-08 3.414213562373e-01 2.875000000000e-08 1.331821362081e-01 2.900000000000e-08 -4.260480856999e-15 2.925000000000e-08 3.993211525331e-01 2.950000000000e-08 5.414213562373e-01 2.975000000000e-08 -3.027339492126e-01 3.000000000000e-08 -1.200000000000e+00 3.025000000000e-08 -9.054678984252e-01 3.050000000000e-08 5.857864376269e-02 3.075000000000e-08 3.496605762665e-01 3.100000000000e-08 5.065392549852e-15 3.125000000000e-08 -3.363572758385e-02 3.150000000000e-08 2.585786437627e-01 3.175000000000e-08 2.198912367380e-01 3.200000000000e-08 -3.219646771413e-15 3.225000000000e-08 1.397824734759e-01 3.250000000000e-08 3.414213562373e-01 3.275000000000e-08 1.331821362081e-01 3.300000000000e-08 -1.471045507628e-15 3.325000000000e-08 3.993211525331e-01 3.350000000000e-08 5.414213562373e-01 3.375000000000e-08 -3.027339492126e-01 3.400000000000e-08 -1.200000000000e+00 3.425000000000e-08 -9.054678984252e-01 3.450000000000e-08 5.857864376270e-02 3.475000000000e-08 3.496605762665e-01 3.500000000000e-08 -4.440892098501e-16 3.525000000000e-08 -3.363572758385e-02 3.550000000000e-08 2.585786437627e-01 3.575000000000e-08 2.198912367380e-01 3.600000000000e-08 -9.992007221626e-16 3.625000000000e-08 1.397824734759e-01 3.650000000000e-08 3.414213562373e-01 3.675000000000e-08 1.331821362081e-01 3.700000000000e-08 -8.701372955500e-15 3.725000000000e-08 3.993211525331e-01 3.750000000000e-08 5.414213562373e-01 3.775000000000e-08 -3.027339492126e-01 3.800000000000e-08 -1.200000000000e+00 3.825000000000e-08 -9.054678984252e-01 3.850000000000e-08 5.857864376268e-02 3.875000000000e-08 3.496605762666e-01 3.900000000000e-08 2.622901895677e-15 3.925000000000e-08 -3.363572758385e-02 3.950000000000e-08 2.585786437627e-01 3.975000000000e-08 2.198912367380e-01 4.000000000000e-08 -8.881784197001e-16 4.025000000000e-08 1.397824734759e-01 4.050000000000e-08 3.414213562373e-01 4.075000000000e-08 1.331821362081e-01 4.100000000000e-08 -5.981326545168e-15 4.125000000000e-08 3.993211525331e-01 4.150000000000e-08 5.414213562373e-01 4.175000000000e-08 -3.027339492126e-01 4.200000000000e-08 -1.200000000000e+00 4.225000000000e-08 -9.054678984252e-01 4.250000000000e-08 5.857864376269e-02 4.275000000000e-08 3.496605762666e-01 4.300000000000e-08 3.538835890993e-15 4.325000000000e-08 -3.363572758386e-02 4.350000000000e-08 2.585786437627e-01 4.375000000000e-08 2.198912367380e-01 4.400000000000e-08 -2.331468351713e-15 4.425000000000e-08 1.397824734759e-01 4.450000000000e-08 3.414213562373e-01 4.475000000000e-08 1.331821362081e-01 4.500000000000e-08 -3.191891195797e-15 4.525000000000e-08 3.993211525331e-01 4.550000000000e-08 5.414213562373e-01 4.575000000000e-08 -3.027339492126e-01 4.600000000000e-08 -1.200000000000e+00 4.625000000000e-08 -9.054678984252e-01 4.650000000000e-08 5.857864376270e-02 4.675000000000e-08 3.496605762665e-01 4.700000000000e-08 -1.970645868710e-15 4.725000000000e-08 -3.363572758386e-02 4.750000000000e-08 2.585786437627e-01 4.775000000000e-08 2.198912367380e-01 4.800000000000e-08 -6.550315845288e-15 4.825000000000e-08 1.397824734759e-01 4.850000000000e-08 3.414213562373e-01 4.875000000000e-08 1.331821362081e-01 4.900000000000e-08 -1.042221864367e-14 4.925000000000e-08 3.993211525331e-01 4.950000000000e-08 5.414213562373e-01 4.975000000000e-08 -3.027339492126e-01 5.000000000000e-08 -1.200000000000e+00 5.025000000000e-08 -9.054678984252e-01 5.050000000000e-08 5.857864376268e-02 5.075000000000e-08 3.496605762666e-01 5.100000000000e-08 8.146261443187e-15 5.125000000000e-08 -3.363572758385e-02 5.150000000000e-08 2.585786437627e-01 5.175000000000e-08 2.198912367380e-01 5.200000000000e-08 -3.608224830032e-15 5.225000000000e-08 1.397824734759e-01 5.250000000000e-08 3.414213562373e-01 5.275000000000e-08 1.331821362081e-01 5.300000000000e-08 -7.688294445529e-15 5.325000000000e-08 3.993211525331e-01 5.350000000000e-08 5.414213562373e-01 5.375000000000e-08 -3.027339492126e-01 5.400000000000e-08 -1.200000000000e+00 5.425000000000e-08 -9.054678984252e-01 5.450000000000e-08 5.857864376270e-02 5.475000000000e-08 3.496605762665e-01 5.500000000000e-08 1.121325254871e-14 5.525000000000e-08 -3.363572758385e-02 5.550000000000e-08 2.585786437627e-01 5.575000000000e-08 2.198912367379e-01 5.600000000000e-08 -5.051514762044e-15 5.625000000000e-08 1.397824734759e-01 5.650000000000e-08 3.414213562373e-01 5.675000000000e-08 1.331821362081e-01 5.700000000000e-08 -6.411537967210e-15 5.725000000000e-08 3.993211525331e-01 5.750000000000e-08 5.414213562373e-01 5.775000000000e-08 -3.027339492126e-01 5.800000000000e-08 -1.200000000000e+00 5.825000000000e-08 -9.054678984252e-01 5.850000000000e-08 5.857864376269e-02 5.875000000000e-08 3.496605762665e-01 5.900000000000e-08 -2.803313137179e-15 5.925000000000e-08 -3.363572758384e-02 5.950000000000e-08 2.585786437627e-01 5.975000000000e-08 2.198912367380e-01 6.000000000000e-08 -9.214851104389e-15 6.025000000000e-08 1.397824734759e-01 6.050000000000e-08 3.414213562373e-01 6.075000000000e-08 1.331821362081e-01 6.100000000000e-08 -5.051514762044e-15 6.125000000000e-08 3.993211525331e-01 6.150000000000e-08 5.414213562373e-01 6.175000000000e-08 -3.027339492126e-01 6.200000000000e-08 -1.200000000000e+00 6.225000000000e-08 -9.054678984252e-01 6.250000000000e-08 5.857864376272e-02 6.275000000000e-08 3.496605762665e-01 6.300000000000e-08 2.775557561563e-16 6.325000000000e-08 -3.363572758385e-02 6.350000000000e-08 2.585786437627e-01 6.375000000000e-08 2.198912367380e-01 6.400000000000e-08 -6.272760089132e-15 6.425000000000e-08 1.397824734759e-01 6.450000000000e-08 3.414213562373e-01 6.475000000000e-08 1.331821362081e-01 6.500000000000e-08 -1.079691891448e-14 6.525000000000e-08 3.993211525331e-01 6.550000000000e-08 5.414213562373e-01 6.575000000000e-08 -3.027339492126e-01 6.600000000000e-08 -1.200000000000e+00 6.625000000000e-08 -9.054678984252e-01 6.650000000000e-08 5.857864376270e-02 6.675000000000e-08 3.496605762666e-01 6.700000000000e-08 1.859623566247e-15 6.725000000000e-08 -3.363572758384e-02 6.750000000000e-08 2.585786437627e-01 6.775000000000e-08 2.198912367380e-01 6.800000000000e-08 -3.441691376338e-15 6.825000000000e-08 1.397824734759e-01 6.850000000000e-08 3.414213562373e-01 6.875000000000e-08 1.331821362081e-01 6.900000000000e-08 4.163336342344e-16 6.925000000000e-08 3.993211525331e-01 6.950000000000e-08 5.414213562373e-01 6.975000000000e-08 -3.027339492126e-01 7.000000000000e-08 -1.200000000000e+00 7.025000000000e-08 -9.054678984251e-01 7.050000000000e-08 5.857864376269e-02 7.075000000000e-08 3.496605762665e-01 7.100000000000e-08 3.511080315377e-15 7.125000000000e-08 -3.363572758384e-02 7.150000000000e-08 2.585786437627e-01 7.175000000000e-08 2.198912367379e-01 7.200000000000e-08 -1.942890293094e-15 7.225000000000e-08 1.397824734759e-01 7.250000000000e-08 3.414213562373e-01 7.275000000000e-08 1.331821362081e-01 7.300000000000e-08 1.762479051592e-15 7.325000000000e-08 3.993211525331e-01 7.350000000000e-08 5.414213562373e-01 7.375000000000e-08 -3.027339492126e-01 7.400000000000e-08 -1.200000000000e+00 7.425000000000e-08 -9.054678984251e-01 7.450000000000e-08 5.857864376268e-02 7.475000000000e-08 3.496605762665e-01 7.500000000000e-08 6.480926906249e-15 7.525000000000e-08 -3.363572758385e-02 7.550000000000e-08 2.585786437627e-01 7.575000000000e-08 2.198912367379e-01 7.600000000000e-08 -4.829470157119e-15 7.625000000000e-08 1.397824734759e-01 7.650000000000e-08 3.414213562373e-01 7.675000000000e-08 1.331821362081e-01 7.700000000000e-08 -1.398881011028e-14 7.725000000000e-08 3.993211525331e-01 7.750000000000e-08 5.414213562373e-01 7.775000000000e-08 -3.027339492126e-01 7.800000000000e-08 -1.200000000000e+00 7.825000000000e-08 -9.054678984252e-01 7.850000000000e-08 5.857864376271e-02 7.875000000000e-08 3.496605762665e-01 7.900000000000e-08 9.561795799584e-15 7.925000000000e-08 -3.363572758385e-02 7.950000000000e-08 2.585786437627e-01 7.975000000000e-08 2.198912367380e-01 8.000000000000e-08 -1.887379141863e-15 ]
VWL027 (wl027 0) vsource type=pwl wave=[ 0.000000000000e+00 0.000000000000e+00 2.500000000000e-10 1.801087632620e-01 5.000000000000e-10 -2.426406871193e-02 7.500000000000e-10 -2.336357275839e-01 1.000000000000e-09 9.714451465470e-17 1.250000000000e-09 5.033942373345e-02 1.500000000000e-09 -6.242640687119e-01 1.750000000000e-09 -1.105467898425e+00 2.000000000000e-09 -4.000000000000e-01 2.250000000000e-09 7.027339492126e-01 2.500000000000e-09 8.242640687119e-01 2.750000000000e-09 1.993211525331e-01 3.000000000000e-09 5.412337245048e-16 3.250000000000e-09 2.668178637919e-01 3.500000000000e-09 2.242640687119e-01 3.750000000000e-09 -6.021752652407e-02 4.000000000000e-09 1.193489751472e-15 4.250000000000e-09 1.801087632620e-01 4.500000000000e-09 -2.426406871193e-02 4.750000000000e-09 -2.336357275839e-01 5.000000000000e-09 -4.024558464266e-16 5.250000000000e-09 5.033942373345e-02 5.500000000000e-09 -6.242640687119e-01 5.750000000000e-09 -1.105467898425e+00 6.000000000000e-09 -4.000000000000e-01 6.250000000000e-09 7.027339492126e-01 6.500000000000e-09 8.242640687119e-01 6.750000000000e-09 1.993211525331e-01 7.000000000000e-09 8.743006318923e-16 7.250000000000e-09 2.668178637919e-01 7.500000000000e-09 2.242640687119e-01 7.750000000000e-09 -6.021752652407e-02 8.000000000000e-09 2.373101715136e-15 8.250000000000e-09 1.801087632620e-01 8.500000000000e-09 -2.426406871193e-02 8.750000000000e-09 -2.336357275839e-01 9.000000000000e-09 1.013078509970e-15 9.250000000000e-09 5.033942373345e-02 9.500000000000e-09 -6.242640687119e-01 9.750000000000e-09 -1.105467898425e+00 1.000000000000e-08 -4.000000000000e-01 1.025000000000e-08 7.027339492126e-01 1.050000000000e-08 8.242640687119e-01 1.075000000000e-08 1.993211525331e-01 1.100000000000e-08 7.632783294298e-16 1.125000000000e-08 2.668178637919e-01 1.150000000000e-08 2.242640687119e-01 1.175000000000e-08 -6.021752652407e-02 1.200000000000e-08 4.898859096159e-15 1.225000000000e-08 1.801087632620e-01 1.250000000000e-08 -2.426406871193e-02 1.275000000000e-08 -2.336357275839e-01 1.300000000000e-08 4.163336342344e-17 1.325000000000e-08 5.033942373345e-02 1.350000000000e-08 -6.242640687119e-01 1.375000000000e-08 -1.105467898425e+00 1.400000000000e-08 -4.000000000000e-01 1.425000000000e-08 7.027339492126e-01 1.450000000000e-08 8.242640687119e-01 1.475000000000e-08 1.993211525331e-01 1.500000000000e-08 3.191891195797e-15 1.525000000000e-08 2.668178637919e-01 1.550000000000e-08 2.242640687119e-01 1.575000000000e-08 -6.021752652407e-02 1.600000000000e-08 4.732325642465e-15 1.625000000000e-08 1.801087632620e-01 1.650000000000e-08 -2.426406871193e-02 1.675000000000e-08 -2.336357275839e-01 1.700000000000e-08 -1.110223024625e-16 1.725000000000e-08 5.033942373345e-02 1.750000000000e-08 -6.242640687119e-01 1.775000000000e-08 -1.105467898425e+00 1.800000000000e-08 -4.000000000000e-01 1.825000000000e-08 7.027339492126e-01 1.850000000000e-08 8.242640687119e-01 1.875000000000e-08 1.993211525331e-01 1.900000000000e-08 1.304512053935e-15 1.925000000000e-08 2.668178637919e-01 1.950000000000e-08 2.242640687119e-01 1.975000000000e-08 -6.021752652407e-02 2.000000000000e-08 1.387778780781e-15 2.025000000000e-08 1.801087632620e-01 2.050000000000e-08 -2.426406871193e-02 2.075000000000e-08 -2.336357275839e-01 2.100000000000e-08 4.024558464266e-16 2.125000000000e-08 5.033942373345e-02 2.150000000000e-08 -6.242640687119e-01 2.175000000000e-08 -1.105467898425e+00 2.200000000000e-08 -4.000000000000e-01 2.225000000000e-08 7.027339492126e-01 2.250000000000e-08 8.242640687119e-01 2.275000000000e-08 1.993211525331e-01 2.300000000000e-08 2.955968803064e-15 2.325000000000e-08 2.668178637919e-01 2.350000000000e-08 2.242640687119e-01 2.375000000000e-08 -6.021752652407e-02 2.400000000000e-08 9.769962616701e-15 2.425000000000e-08 1.801087632620e-01 2.450000000000e-08 -2.426406871193e-02 2.475000000000e-08 -2.336357275839e-01 2.500000000000e-08 -4.718447854657e-16 2.525000000000e-08 5.033942373345e-02 2.550000000000e-08 -6.242640687119e-01 2.575000000000e-08 -1.105467898425e+00 2.600000000000e-08 -4.000000000000e-01 2.625000000000e-08 7.027339492126e-01 2.650000000000e-08 8.242640687119e-01 2.675000000000e-08 1.993211525331e-01 2.700000000000e-08 -1.346145417358e-15 2.725000000000e-08 2.668178637919e-01 2.750000000000e-08 2.242640687119e-01 2.775000000000e-08 -6.021752652407e-02 2.800000000000e-08 7.494005416220e-15 2.825000000000e-08 1.801087632620e-01 2.850000000000e-08 -2.426406871193e-02 2.875000000000e-08 -2.336357275839e-01 2.900000000000e-08 -1.443289932013e-15 2.925000000000e-08 5.033942373345e-02 2.950000000000e-08 -6.242640687119e-01 2.975000000000e-08 -1.105467898425e+00 3.000000000000e-08 -4.000000000000e-01 3.025000000000e-08 7.027339492126e-01 3.050000000000e-08 8.242640687119e-01 3.075000000000e-08 1.993211525331e-01 3.100000000000e-08 -7.632783294298e-16 3.125000000000e-08 2.668178637919e-01 3.150000000000e-08 2.242640687119e-01 3.175000000000e-08 -6.021752652407e-02 3.200000000000e-08 9.478529072737e-15 3.225000000000e-08 1.801087632620e-01 3.250000000000e-08 -2.426406871193e-02 3.275000000000e-08 -2.336357275839e-01 3.300000000000e-08 4.052314039882e-15 3.325000000000e-08 5.033942373345e-02 3.350000000000e-08 -6.242640687119e-01 3.375000000000e-08 -1.105467898425e+00 3.400000000000e-08 -4.000000000000e-01 3.425000000000e-08 7.027339492126e-01 3.450000000000e-08 8.242640687119e-01 3.475000000000e-08 1.993211525331e-01 3.500000000000e-08 2.012279232133e-15 3.525000000000e-08 2.668178637919e-01 3.550000000000e-08 2.242640687119e-01 3.575000000000e-08 -6.021752652407e-02 3.600000000000e-08 2.942091015257e-15 3.625000000000e-08 1.801087632620e-01 3.650000000000e-08 -2.426406871193e-02 3.675000000000e-08 -2.336357275839e-01 3.700000000000e-08 -3.233524559221e-15 3.725000000000e-08 5.033942373346e-02 3.750000000000e-08 -6.242640687119e-01 3.775000000000e-08 -1.105467898425e+00 3.800000000000e-08 -4.000000000000e-01 3.825000000000e-08 7.027339492126e-01 3.850000000000e-08 8.242640687119e-01 3.875000000000e-08 1.993211525331e-01 3.900000000000e-08 7.591149930875e-15 3.925000000000e-08 2.668178637919e-01 3.950000000000e-08 2.242640687119e-01 3.975000000000e-08 -6.021752652407e-02 4.000000000000e-08 2.789435349371e-15 4.025000000000e-08 1.801087632620e-01 4.050000000000e-08 -2.426406871194e-02 4.075000000000e-08 -2.336357275839e-01 4.100000000000e-08 2.275957200482e-15 4.125000000000e-08 5.033942373345e-02 4.150000000000e-08 -6.242640687119e-01 4.175000000000e-08 -1.105467898425e+00 4.200000000000e-08 -4.000000000000e-01 4.225000000000e-08 7.027339492126e-01 4.250000000000e-08 8.242640687119e-01 4.275000000000e-08 1.993211525331e-01 4.300000000000e-08 -1.748601263785e-15 4.325000000000e-08 2.668178637919e-01 4.350000000000e-08 2.242640687119e-01 4.375000000000e-08 -6.021752652407e-02 4.400000000000e-08 6.911138328292e-15 4.425000000000e-08 1.801087632620e-01 4.450000000000e-08 -2.426406871193e-02 4.475000000000e-08 -2.336357275839e-01 4.500000000000e-08 7.716050021145e-15 4.525000000000e-08 5.033942373345e-02 4.550000000000e-08 -6.242640687119e-01 4.575000000000e-08 -1.105467898425e+00 4.600000000000e-08 -4.000000000000e-01 4.625000000000e-08 7.027339492126e-01 4.650000000000e-08 8.242640687119e-01 4.675000000000e-08 1.993211525331e-01 4.700000000000e-08 9.714451465470e-16 4.725000000000e-08 2.668178637919e-01 4.750000000000e-08 2.242640687119e-01 4.775000000000e-08 -6.021752652407e-02 4.800000000000e-08 1.955380302121e-14 4.825000000000e-08 1.801087632620e-01 4.850000000000e-08 -2.426406871194e-02 4.875000000000e-08 -2.336357275839e-01 4.900000000000e-08 4.302114220422e-16 4.925000000000e-08 5.033942373345e-02 4.950000000000e-08 -6.242640687119e-01 4.975000000000e-08 -1.105467898425e+00 5.000000000000e-08 -4.000000000000e-01 5.025000000000e-08 7.027339492126e-01 5.050000000000e-08 8.242640687119e-01 5.075000000000e-08 1.993211525331e-01 5.100000000000e-08 -5.551115123126e-16 5.125000000000e-08 2.668178637919e-01 5.150000000000e-08 2.242640687119e-01 5.175000000000e-08 -6.021752652407e-02 5.200000000000e-08 1.088018564133e-14 5.225000000000e-08 1.801087632620e-01 5.250000000000e-08 -2.426406871193e-02 5.275000000000e-08 -2.336357275839e-01 5.300000000000e-08 5.925815393937e-15 5.325000000000e-08 5.033942373345e-02 5.350000000000e-08 -6.242640687119e-01 5.375000000000e-08 -1.105467898425e+00 5.400000000000e-08 -4.000000000000e-01 5.425000000000e-08 7.027339492126e-01 5.450000000000e-08 8.242640687119e-01 5.475000000000e-08 1.993211525331e-01 5.500000000000e-08 5.065392549852e-15 5.525000000000e-08 2.668178637919e-01 5.550000000000e-08 2.242640687119e-01 5.575000000000e-08 -6.021752652407e-02 5.600000000000e-08 1.498801083244e-14 5.625000000000e-08 1.801087632620e-01 5.650000000000e-08 -2.426406871194e-02 5.675000000000e-08 -2.336357275839e-01 5.700000000000e-08 1.457167719821e-15 5.725000000000e-08 5.033942373345e-02 5.750000000000e-08 -6.242640687119e-01 5.775000000000e-08 -1.105467898425e+00 5.800000000000e-08 -4.000000000000e-01 5.825000000000e-08 7.027339492126e-01 5.850000000000e-08 8.242640687119e-01 5.875000000000e-08 1.993211525331e-01 5.900000000000e-08 4.968248035198e-15 5.925000000000e-08 2.668178637919e-01 5.950000000000e-08 2.242640687119e-01 5.975000000000e-08 -6.021752652407e-02 6.000000000000e-08 2.765843110097e-14 6.025000000000e-08 1.801087632620e-01 6.050000000000e-08 -2.426406871195e-02 6.075000000000e-08 -2.336357275839e-01 6.100000000000e-08 -2.942091015257e-15 6.125000000000e-08 5.033942373345e-02 6.150000000000e-08 -6.242640687119e-01 6.175000000000e-08 -1.105467898425e+00 6.200000000000e-08 -4.000000000000e-01 6.225000000000e-08 7.027339492126e-01 6.250000000000e-08 8.242640687119e-01 6.275000000000e-08 1.993211525331e-01 6.300000000000e-08 1.051936315832e-14 6.325000000000e-08 2.668178637919e-01 6.350000000000e-08 2.242640687119e-01 6.375000000000e-08 -6.021752652407e-02 6.400000000000e-08 1.897093593328e-14 6.425000000000e-08 1.801087632620e-01 6.450000000000e-08 -2.426406871195e-02 6.475000000000e-08 -2.336357275839e-01 6.500000000000e-08 -3.330669073875e-16 6.525000000000e-08 5.033942373345e-02 6.550000000000e-08 -6.242640687119e-01 6.575000000000e-08 -1.105467898425e+00 6.600000000000e-08 -4.000000000000e-01 6.625000000000e-08 7.027339492126e-01 6.650000000000e-08 8.242640687119e-01 6.675000000000e-08 1.993211525331e-01 6.700000000000e-08 6.161737786670e-15 6.725000000000e-08 2.668178637919e-01 6.750000000000e-08 2.242640687119e-01 6.775000000000e-08 -6.021752652407e-02 6.800000000000e-08 1.028344076559e-14 6.825000000000e-08 1.801087632620e-01 6.850000000000e-08 -2.426406871194e-02 6.875000000000e-08 -2.336357275839e-01 6.900000000000e-08 7.993605777301e-15 6.925000000000e-08 5.033942373346e-02 6.950000000000e-08 -6.242640687119e-01 6.975000000000e-08 -1.105467898425e+00 7.000000000000e-08 -4.000000000000e-01 7.025000000000e-08 7.027339492126e-01 7.050000000000e-08 8.242640687119e-01 7.075000000000e-08 1.993211525331e-01 7.100000000000e-08 1.817990202824e-15 7.125000000000e-08 2.668178637919e-01 7.150000000000e-08 2.242640687119e-01 7.175000000000e-08 -6.021752652407e-02 7.200000000000e-08 5.884182030513e-15 7.225000000000e-08 1.801087632620e-01 7.250000000000e-08 -2.426406871194e-02 7.275000000000e-08 -2.336357275839e-01 7.300000000000e-08 3.524958103185e-15 7.325000000000e-08 5.033942373344e-02 7.350000000000e-08 -6.242640687119e-01 7.375000000000e-08 -1.105467898425e+00 7.400000000000e-08 -4.000000000000e-01 7.425000000000e-08 7.027339492126e-01 7.450000000000e-08 8.242640687119e-01 7.475000000000e-08 1.993211525331e-01 7.500000000000e-08 7.369105325949e-15 7.525000000000e-08 2.668178637919e-01 7.550000000000e-08 2.242640687119e-01 7.575000000000e-08 -6.021752652407e-02 7.600000000000e-08 1.426636586643e-14 7.625000000000e-08 1.801087632620e-01 7.650000000000e-08 -2.426406871193e-02 7.675000000000e-08 -2.336357275839e-01 7.700000000000e-08 -6.647460359943e-15 7.725000000000e-08 5.033942373345e-02 7.750000000000e-08 -6.242640687119e-01 7.775000000000e-08 -1.105467898425e+00 7.800000000000e-08 -4.000000000000e-01 7.825000000000e-08 7.027339492126e-01 7.850000000000e-08 8.242640687119e-01 7.875000000000e-08 1.993211525331e-01 7.900000000000e-08 1.297573160031e-14 7.925000000000e-08 2.668178637919e-01 7.950000000000e-08 2.242640687119e-01 7.975000000000e-08 -6.021752652407e-02 8.000000000000e-08 5.578870698741e-15 ]
VWL028 (wl028 0) vsource type=pwl wave=[ 0.000000000000e+00 0.000000000000e+00 2.500000000000e-10 -1.397824734759e-01 5.000000000000e-10 -3.414213562373e-01 7.500000000000e-10 -1.331821362081e-01 1.000000000000e-09 9.714451465470e-17 1.250000000000e-09 -3.993211525331e-01 1.500000000000e-09 -5.414213562373e-01 1.750000000000e-09 3.027339492126e-01 2.000000000000e-09 1.200000000000e+00 2.250000000000e-09 9.054678984252e-01 2.500000000000e-09 -5.857864376269e-02 2.750000000000e-09 -3.496605762665e-01 3.000000000000e-09 -2.636779683485e-16 3.250000000000e-09 3.363572758386e-02 3.500000000000e-09 -2.585786437627e-01 3.750000000000e-09 -2.198912367380e-01 4.000000000000e-09 3.885780586188e-16 4.250000000000e-09 -1.397824734759e-01 4.500000000000e-09 -3.414213562373e-01 4.750000000000e-09 -1.331821362081e-01 5.000000000000e-09 6.522560269673e-16 5.250000000000e-09 -3.993211525331e-01 5.500000000000e-09 -5.414213562373e-01 5.750000000000e-09 3.027339492126e-01 6.000000000000e-09 1.200000000000e+00 6.250000000000e-09 9.054678984252e-01 6.500000000000e-09 -5.857864376269e-02 6.750000000000e-09 -3.496605762665e-01 7.000000000000e-09 2.775557561563e-17 7.250000000000e-09 3.363572758386e-02 7.500000000000e-09 -2.585786437627e-01 7.750000000000e-09 -2.198912367380e-01 8.000000000000e-09 8.326672684689e-16 8.250000000000e-09 -1.397824734759e-01 8.500000000000e-09 -3.414213562373e-01 8.750000000000e-09 -1.331821362081e-01 9.000000000000e-09 -4.579669976579e-16 9.250000000000e-09 -3.993211525331e-01 9.500000000000e-09 -5.414213562373e-01 9.750000000000e-09 3.027339492126e-01 1.000000000000e-08 1.200000000000e+00 1.025000000000e-08 9.054678984252e-01 1.050000000000e-08 -5.857864376269e-02 1.075000000000e-08 -3.496605762665e-01 1.100000000000e-08 -1.804112415016e-16 1.125000000000e-08 3.363572758386e-02 1.150000000000e-08 -2.585786437627e-01 1.175000000000e-08 -2.198912367380e-01 1.200000000000e-08 1.609823385706e-15 1.225000000000e-08 -1.397824734759e-01 1.250000000000e-08 -3.414213562373e-01 1.275000000000e-08 -1.331821362081e-01 1.300000000000e-08 1.706967900361e-15 1.325000000000e-08 -3.993211525331e-01 1.350000000000e-08 -5.414213562373e-01 1.375000000000e-08 3.027339492126e-01 1.400000000000e-08 1.200000000000e+00 1.425000000000e-08 9.054678984252e-01 1.450000000000e-08 -5.857864376269e-02 1.475000000000e-08 -3.496605762665e-01 1.500000000000e-08 -7.216449660064e-16 1.525000000000e-08 3.363572758386e-02 1.550000000000e-08 -2.585786437627e-01 1.575000000000e-08 -2.198912367380e-01 1.600000000000e-08 1.554312234475e-15 1.625000000000e-08 -1.397824734759e-01 1.650000000000e-08 -3.414213562373e-01 1.675000000000e-08 -1.331821362081e-01 1.700000000000e-08 1.804112415016e-15 1.725000000000e-08 -3.993211525331e-01 1.750000000000e-08 -5.414213562373e-01 1.775000000000e-08 3.027339492126e-01 1.800000000000e-08 1.200000000000e+00 1.825000000000e-08 9.054678984252e-01 1.850000000000e-08 -5.857864376269e-02 1.875000000000e-08 -3.496605762665e-01 1.900000000000e-08 -2.720046410332e-15 1.925000000000e-08 3.363572758386e-02 1.950000000000e-08 -2.585786437627e-01 1.975000000000e-08 -2.198912367380e-01 2.000000000000e-08 4.440892098501e-16 2.025000000000e-08 -1.397824734759e-01 2.050000000000e-08 -3.414213562373e-01 2.075000000000e-08 -1.331821362081e-01 2.100000000000e-08 -1.804112415016e-16 2.125000000000e-08 -3.993211525331e-01 2.150000000000e-08 -5.414213562373e-01 2.175000000000e-08 3.027339492126e-01 2.200000000000e-08 1.200000000000e+00 2.225000000000e-08 9.054678984252e-01 2.250000000000e-08 -5.857864376270e-02 2.275000000000e-08 -3.496605762665e-01 2.300000000000e-08 -1.137978600241e-15 2.325000000000e-08 3.363572758386e-02 2.350000000000e-08 -2.585786437627e-01 2.375000000000e-08 -2.198912367380e-01 2.400000000000e-08 3.275157922644e-15 2.425000000000e-08 -1.397824734759e-01 2.450000000000e-08 -3.414213562373e-01 2.475000000000e-08 -1.331821362081e-01 2.500000000000e-08 2.040034807749e-15 2.525000000000e-08 -3.993211525331e-01 2.550000000000e-08 -5.414213562373e-01 2.575000000000e-08 3.027339492126e-01 2.600000000000e-08 1.200000000000e+00 2.625000000000e-08 9.054678984252e-01 2.650000000000e-08 -5.857864376270e-02 2.675000000000e-08 -3.496605762665e-01 2.700000000000e-08 -2.775557561563e-15 2.725000000000e-08 3.363572758386e-02 2.750000000000e-08 -2.585786437627e-01 2.775000000000e-08 -2.198912367380e-01 2.800000000000e-08 2.442490654175e-15 2.825000000000e-08 -1.397824734759e-01 2.850000000000e-08 -3.414213562373e-01 2.875000000000e-08 -1.331821362081e-01 2.900000000000e-08 4.260480856999e-15 2.925000000000e-08 -3.993211525331e-01 2.950000000000e-08 -5.414213562373e-01 2.975000000000e-08 3.027339492126e-01 3.000000000000e-08 1.200000000000e+00 3.025000000000e-08 9.054678984252e-01 3.050000000000e-08 -5.857864376269e-02 3.075000000000e-08 -3.496605762665e-01 3.100000000000e-08 -5.065392549852e-15 3.125000000000e-08 3.363572758385e-02 3.150000000000e-08 -2.585786437627e-01 3.175000000000e-08 -2.198912367380e-01 3.200000000000e-08 3.219646771413e-15 3.225000000000e-08 -1.397824734759e-01 3.250000000000e-08 -3.414213562373e-01 3.275000000000e-08 -1.331821362081e-01 3.300000000000e-08 1.471045507628e-15 3.325000000000e-08 -3.993211525331e-01 3.350000000000e-08 -5.414213562373e-01 3.375000000000e-08 3.027339492126e-01 3.400000000000e-08 1.200000000000e+00 3.425000000000e-08 9.054678984252e-01 3.450000000000e-08 -5.857864376270e-02 3.475000000000e-08 -3.496605762665e-01 3.500000000000e-08 4.440892098501e-16 3.525000000000e-08 3.363572758385e-02 3.550000000000e-08 -2.585786437627e-01 3.575000000000e-08 -2.198912367380e-01 3.600000000000e-08 9.992007221626e-16 3.625000000000e-08 -1.397824734759e-01 3.650000000000e-08 -3.414213562373e-01 3.675000000000e-08 -1.331821362081e-01 3.700000000000e-08 8.701372955500e-15 3.725000000000e-08 -3.993211525331e-01 3.750000000000e-08 -5.414213562373e-01 3.775000000000e-08 3.027339492126e-01 3.800000000000e-08 1.200000000000e+00 3.825000000000e-08 9.054678984252e-01 3.850000000000e-08 -5.857864376268e-02 3.875000000000e-08 -3.496605762666e-01 3.900000000000e-08 -2.622901895677e-15 3.925000000000e-08 3.363572758385e-02 3.950000000000e-08 -2.585786437627e-01 3.975000000000e-08 -2.198912367380e-01 4.000000000000e-08 8.881784197001e-16 4.025000000000e-08 -1.397824734759e-01 4.050000000000e-08 -3.414213562373e-01 4.075000000000e-08 -1.331821362081e-01 4.100000000000e-08 5.981326545168e-15 4.125000000000e-08 -3.993211525331e-01 4.150000000000e-08 -5.414213562373e-01 4.175000000000e-08 3.027339492126e-01 4.200000000000e-08 1.200000000000e+00 4.225000000000e-08 9.054678984252e-01 4.250000000000e-08 -5.857864376269e-02 4.275000000000e-08 -3.496605762666e-01 4.300000000000e-08 -3.538835890993e-15 4.325000000000e-08 3.363572758386e-02 4.350000000000e-08 -2.585786437627e-01 4.375000000000e-08 -2.198912367380e-01 4.400000000000e-08 2.331468351713e-15 4.425000000000e-08 -1.397824734759e-01 4.450000000000e-08 -3.414213562373e-01 4.475000000000e-08 -1.331821362081e-01 4.500000000000e-08 3.191891195797e-15 4.525000000000e-08 -3.993211525331e-01 4.550000000000e-08 -5.414213562373e-01 4.575000000000e-08 3.027339492126e-01 4.600000000000e-08 1.200000000000e+00 4.625000000000e-08 9.054678984252e-01 4.650000000000e-08 -5.857864376270e-02 4.675000000000e-08 -3.496605762665e-01 4.700000000000e-08 1.970645868710e-15 4.725000000000e-08 3.363572758386e-02 4.750000000000e-08 -2.585786437627e-01 4.775000000000e-08 -2.198912367380e-01 4.800000000000e-08 6.550315845288e-15 4.825000000000e-08 -1.397824734759e-01 4.850000000000e-08 -3.414213562373e-01 4.875000000000e-08 -1.331821362081e-01 4.900000000000e-08 1.042221864367e-14 4.925000000000e-08 -3.993211525331e-01 4.950000000000e-08 -5.414213562373e-01 4.975000000000e-08 3.027339492126e-01 5.000000000000e-08 1.200000000000e+00 5.025000000000e-08 9.054678984252e-01 5.050000000000e-08 -5.857864376268e-02 5.075000000000e-08 -3.496605762666e-01 5.100000000000e-08 -8.146261443187e-15 5.125000000000e-08 3.363572758385e-02 5.150000000000e-08 -2.585786437627e-01 5.175000000000e-08 -2.198912367380e-01 5.200000000000e-08 3.608224830032e-15 5.225000000000e-08 -1.397824734759e-01 5.250000000000e-08 -3.414213562373e-01 5.275000000000e-08 -1.331821362081e-01 5.300000000000e-08 7.688294445529e-15 5.325000000000e-08 -3.993211525331e-01 5.350000000000e-08 -5.414213562373e-01 5.375000000000e-08 3.027339492126e-01 5.400000000000e-08 1.200000000000e+00 5.425000000000e-08 9.054678984252e-01 5.450000000000e-08 -5.857864376270e-02 5.475000000000e-08 -3.496605762665e-01 5.500000000000e-08 -1.121325254871e-14 5.525000000000e-08 3.363572758385e-02 5.550000000000e-08 -2.585786437627e-01 5.575000000000e-08 -2.198912367379e-01 5.600000000000e-08 5.051514762044e-15 5.625000000000e-08 -1.397824734759e-01 5.650000000000e-08 -3.414213562373e-01 5.675000000000e-08 -1.331821362081e-01 5.700000000000e-08 6.411537967210e-15 5.725000000000e-08 -3.993211525331e-01 5.750000000000e-08 -5.414213562373e-01 5.775000000000e-08 3.027339492126e-01 5.800000000000e-08 1.200000000000e+00 5.825000000000e-08 9.054678984252e-01 5.850000000000e-08 -5.857864376269e-02 5.875000000000e-08 -3.496605762665e-01 5.900000000000e-08 2.803313137179e-15 5.925000000000e-08 3.363572758384e-02 5.950000000000e-08 -2.585786437627e-01 5.975000000000e-08 -2.198912367380e-01 6.000000000000e-08 9.214851104389e-15 6.025000000000e-08 -1.397824734759e-01 6.050000000000e-08 -3.414213562373e-01 6.075000000000e-08 -1.331821362081e-01 6.100000000000e-08 5.051514762044e-15 6.125000000000e-08 -3.993211525331e-01 6.150000000000e-08 -5.414213562373e-01 6.175000000000e-08 3.027339492126e-01 6.200000000000e-08 1.200000000000e+00 6.225000000000e-08 9.054678984252e-01 6.250000000000e-08 -5.857864376272e-02 6.275000000000e-08 -3.496605762665e-01 6.300000000000e-08 -2.775557561563e-16 6.325000000000e-08 3.363572758385e-02 6.350000000000e-08 -2.585786437627e-01 6.375000000000e-08 -2.198912367380e-01 6.400000000000e-08 6.272760089132e-15 6.425000000000e-08 -1.397824734759e-01 6.450000000000e-08 -3.414213562373e-01 6.475000000000e-08 -1.331821362081e-01 6.500000000000e-08 1.079691891448e-14 6.525000000000e-08 -3.993211525331e-01 6.550000000000e-08 -5.414213562373e-01 6.575000000000e-08 3.027339492126e-01 6.600000000000e-08 1.200000000000e+00 6.625000000000e-08 9.054678984252e-01 6.650000000000e-08 -5.857864376270e-02 6.675000000000e-08 -3.496605762666e-01 6.700000000000e-08 -1.859623566247e-15 6.725000000000e-08 3.363572758384e-02 6.750000000000e-08 -2.585786437627e-01 6.775000000000e-08 -2.198912367380e-01 6.800000000000e-08 3.441691376338e-15 6.825000000000e-08 -1.397824734759e-01 6.850000000000e-08 -3.414213562373e-01 6.875000000000e-08 -1.331821362081e-01 6.900000000000e-08 -4.163336342344e-16 6.925000000000e-08 -3.993211525331e-01 6.950000000000e-08 -5.414213562373e-01 6.975000000000e-08 3.027339492126e-01 7.000000000000e-08 1.200000000000e+00 7.025000000000e-08 9.054678984251e-01 7.050000000000e-08 -5.857864376269e-02 7.075000000000e-08 -3.496605762665e-01 7.100000000000e-08 -3.511080315377e-15 7.125000000000e-08 3.363572758384e-02 7.150000000000e-08 -2.585786437627e-01 7.175000000000e-08 -2.198912367379e-01 7.200000000000e-08 1.942890293094e-15 7.225000000000e-08 -1.397824734759e-01 7.250000000000e-08 -3.414213562373e-01 7.275000000000e-08 -1.331821362081e-01 7.300000000000e-08 -1.762479051592e-15 7.325000000000e-08 -3.993211525331e-01 7.350000000000e-08 -5.414213562373e-01 7.375000000000e-08 3.027339492126e-01 7.400000000000e-08 1.200000000000e+00 7.425000000000e-08 9.054678984251e-01 7.450000000000e-08 -5.857864376268e-02 7.475000000000e-08 -3.496605762665e-01 7.500000000000e-08 -6.480926906249e-15 7.525000000000e-08 3.363572758385e-02 7.550000000000e-08 -2.585786437627e-01 7.575000000000e-08 -2.198912367379e-01 7.600000000000e-08 4.829470157119e-15 7.625000000000e-08 -1.397824734759e-01 7.650000000000e-08 -3.414213562373e-01 7.675000000000e-08 -1.331821362081e-01 7.700000000000e-08 1.398881011028e-14 7.725000000000e-08 -3.993211525331e-01 7.750000000000e-08 -5.414213562373e-01 7.775000000000e-08 3.027339492126e-01 7.800000000000e-08 1.200000000000e+00 7.825000000000e-08 9.054678984252e-01 7.850000000000e-08 -5.857864376271e-02 7.875000000000e-08 -3.496605762665e-01 7.900000000000e-08 -9.561795799584e-15 7.925000000000e-08 3.363572758385e-02 7.950000000000e-08 -2.585786437627e-01 7.975000000000e-08 -2.198912367380e-01 8.000000000000e-08 1.887379141863e-15 ]
VWL029 (wl029 0) vsource type=pwl wave=[ 0.000000000000e+00 0.000000000000e+00 2.500000000000e-10 -1.801087632620e-01 5.000000000000e-10 2.426406871193e-02 7.500000000000e-10 2.336357275839e-01 1.000000000000e-09 -9.714451465470e-17 1.250000000000e-09 -5.033942373345e-02 1.500000000000e-09 6.242640687119e-01 1.750000000000e-09 1.105467898425e+00 2.000000000000e-09 4.000000000000e-01 2.250000000000e-09 -7.027339492126e-01 2.500000000000e-09 -8.242640687119e-01 2.750000000000e-09 -1.993211525331e-01 3.000000000000e-09 -5.412337245048e-16 3.250000000000e-09 -2.668178637919e-01 3.500000000000e-09 -2.242640687119e-01 3.750000000000e-09 6.021752652407e-02 4.000000000000e-09 -1.193489751472e-15 4.250000000000e-09 -1.801087632620e-01 4.500000000000e-09 2.426406871193e-02 4.750000000000e-09 2.336357275839e-01 5.000000000000e-09 4.024558464266e-16 5.250000000000e-09 -5.033942373345e-02 5.500000000000e-09 6.242640687119e-01 5.750000000000e-09 1.105467898425e+00 6.000000000000e-09 4.000000000000e-01 6.250000000000e-09 -7.027339492126e-01 6.500000000000e-09 -8.242640687119e-01 6.750000000000e-09 -1.993211525331e-01 7.000000000000e-09 -8.743006318923e-16 7.250000000000e-09 -2.668178637919e-01 7.500000000000e-09 -2.242640687119e-01 7.750000000000e-09 6.021752652407e-02 8.000000000000e-09 -2.373101715136e-15 8.250000000000e-09 -1.801087632620e-01 8.500000000000e-09 2.426406871193e-02 8.750000000000e-09 2.336357275839e-01 9.000000000000e-09 -1.013078509970e-15 9.250000000000e-09 -5.033942373345e-02 9.500000000000e-09 6.242640687119e-01 9.750000000000e-09 1.105467898425e+00 1.000000000000e-08 4.000000000000e-01 1.025000000000e-08 -7.027339492126e-01 1.050000000000e-08 -8.242640687119e-01 1.075000000000e-08 -1.993211525331e-01 1.100000000000e-08 -7.632783294298e-16 1.125000000000e-08 -2.668178637919e-01 1.150000000000e-08 -2.242640687119e-01 1.175000000000e-08 6.021752652407e-02 1.200000000000e-08 -4.898859096159e-15 1.225000000000e-08 -1.801087632620e-01 1.250000000000e-08 2.426406871193e-02 1.275000000000e-08 2.336357275839e-01 1.300000000000e-08 -4.163336342344e-17 1.325000000000e-08 -5.033942373345e-02 1.350000000000e-08 6.242640687119e-01 1.375000000000e-08 1.105467898425e+00 1.400000000000e-08 4.000000000000e-01 1.425000000000e-08 -7.027339492126e-01 1.450000000000e-08 -8.242640687119e-01 1.475000000000e-08 -1.993211525331e-01 1.500000000000e-08 -3.191891195797e-15 1.525000000000e-08 -2.668178637919e-01 1.550000000000e-08 -2.242640687119e-01 1.575000000000e-08 6.021752652407e-02 1.600000000000e-08 -4.732325642465e-15 1.625000000000e-08 -1.801087632620e-01 1.650000000000e-08 2.426406871193e-02 1.675000000000e-08 2.336357275839e-01 1.700000000000e-08 1.110223024625e-16 1.725000000000e-08 -5.033942373345e-02 1.750000000000e-08 6.242640687119e-01 1.775000000000e-08 1.105467898425e+00 1.800000000000e-08 4.000000000000e-01 1.825000000000e-08 -7.027339492126e-01 1.850000000000e-08 -8.242640687119e-01 1.875000000000e-08 -1.993211525331e-01 1.900000000000e-08 -1.304512053935e-15 1.925000000000e-08 -2.668178637919e-01 1.950000000000e-08 -2.242640687119e-01 1.975000000000e-08 6.021752652407e-02 2.000000000000e-08 -1.387778780781e-15 2.025000000000e-08 -1.801087632620e-01 2.050000000000e-08 2.426406871193e-02 2.075000000000e-08 2.336357275839e-01 2.100000000000e-08 -4.024558464266e-16 2.125000000000e-08 -5.033942373345e-02 2.150000000000e-08 6.242640687119e-01 2.175000000000e-08 1.105467898425e+00 2.200000000000e-08 4.000000000000e-01 2.225000000000e-08 -7.027339492126e-01 2.250000000000e-08 -8.242640687119e-01 2.275000000000e-08 -1.993211525331e-01 2.300000000000e-08 -2.955968803064e-15 2.325000000000e-08 -2.668178637919e-01 2.350000000000e-08 -2.242640687119e-01 2.375000000000e-08 6.021752652407e-02 2.400000000000e-08 -9.769962616701e-15 2.425000000000e-08 -1.801087632620e-01 2.450000000000e-08 2.426406871193e-02 2.475000000000e-08 2.336357275839e-01 2.500000000000e-08 4.718447854657e-16 2.525000000000e-08 -5.033942373345e-02 2.550000000000e-08 6.242640687119e-01 2.575000000000e-08 1.105467898425e+00 2.600000000000e-08 4.000000000000e-01 2.625000000000e-08 -7.027339492126e-01 2.650000000000e-08 -8.242640687119e-01 2.675000000000e-08 -1.993211525331e-01 2.700000000000e-08 1.346145417358e-15 2.725000000000e-08 -2.668178637919e-01 2.750000000000e-08 -2.242640687119e-01 2.775000000000e-08 6.021752652407e-02 2.800000000000e-08 -7.494005416220e-15 2.825000000000e-08 -1.801087632620e-01 2.850000000000e-08 2.426406871193e-02 2.875000000000e-08 2.336357275839e-01 2.900000000000e-08 1.443289932013e-15 2.925000000000e-08 -5.033942373345e-02 2.950000000000e-08 6.242640687119e-01 2.975000000000e-08 1.105467898425e+00 3.000000000000e-08 4.000000000000e-01 3.025000000000e-08 -7.027339492126e-01 3.050000000000e-08 -8.242640687119e-01 3.075000000000e-08 -1.993211525331e-01 3.100000000000e-08 7.632783294298e-16 3.125000000000e-08 -2.668178637919e-01 3.150000000000e-08 -2.242640687119e-01 3.175000000000e-08 6.021752652407e-02 3.200000000000e-08 -9.478529072737e-15 3.225000000000e-08 -1.801087632620e-01 3.250000000000e-08 2.426406871193e-02 3.275000000000e-08 2.336357275839e-01 3.300000000000e-08 -4.052314039882e-15 3.325000000000e-08 -5.033942373345e-02 3.350000000000e-08 6.242640687119e-01 3.375000000000e-08 1.105467898425e+00 3.400000000000e-08 4.000000000000e-01 3.425000000000e-08 -7.027339492126e-01 3.450000000000e-08 -8.242640687119e-01 3.475000000000e-08 -1.993211525331e-01 3.500000000000e-08 -2.012279232133e-15 3.525000000000e-08 -2.668178637919e-01 3.550000000000e-08 -2.242640687119e-01 3.575000000000e-08 6.021752652407e-02 3.600000000000e-08 -2.942091015257e-15 3.625000000000e-08 -1.801087632620e-01 3.650000000000e-08 2.426406871193e-02 3.675000000000e-08 2.336357275839e-01 3.700000000000e-08 3.233524559221e-15 3.725000000000e-08 -5.033942373346e-02 3.750000000000e-08 6.242640687119e-01 3.775000000000e-08 1.105467898425e+00 3.800000000000e-08 4.000000000000e-01 3.825000000000e-08 -7.027339492126e-01 3.850000000000e-08 -8.242640687119e-01 3.875000000000e-08 -1.993211525331e-01 3.900000000000e-08 -7.591149930875e-15 3.925000000000e-08 -2.668178637919e-01 3.950000000000e-08 -2.242640687119e-01 3.975000000000e-08 6.021752652407e-02 4.000000000000e-08 -2.789435349371e-15 4.025000000000e-08 -1.801087632620e-01 4.050000000000e-08 2.426406871194e-02 4.075000000000e-08 2.336357275839e-01 4.100000000000e-08 -2.275957200482e-15 4.125000000000e-08 -5.033942373345e-02 4.150000000000e-08 6.242640687119e-01 4.175000000000e-08 1.105467898425e+00 4.200000000000e-08 4.000000000000e-01 4.225000000000e-08 -7.027339492126e-01 4.250000000000e-08 -8.242640687119e-01 4.275000000000e-08 -1.993211525331e-01 4.300000000000e-08 1.748601263785e-15 4.325000000000e-08 -2.668178637919e-01 4.350000000000e-08 -2.242640687119e-01 4.375000000000e-08 6.021752652407e-02 4.400000000000e-08 -6.911138328292e-15 4.425000000000e-08 -1.801087632620e-01 4.450000000000e-08 2.426406871193e-02 4.475000000000e-08 2.336357275839e-01 4.500000000000e-08 -7.716050021145e-15 4.525000000000e-08 -5.033942373345e-02 4.550000000000e-08 6.242640687119e-01 4.575000000000e-08 1.105467898425e+00 4.600000000000e-08 4.000000000000e-01 4.625000000000e-08 -7.027339492126e-01 4.650000000000e-08 -8.242640687119e-01 4.675000000000e-08 -1.993211525331e-01 4.700000000000e-08 -9.714451465470e-16 4.725000000000e-08 -2.668178637919e-01 4.750000000000e-08 -2.242640687119e-01 4.775000000000e-08 6.021752652407e-02 4.800000000000e-08 -1.955380302121e-14 4.825000000000e-08 -1.801087632620e-01 4.850000000000e-08 2.426406871194e-02 4.875000000000e-08 2.336357275839e-01 4.900000000000e-08 -4.302114220422e-16 4.925000000000e-08 -5.033942373345e-02 4.950000000000e-08 6.242640687119e-01 4.975000000000e-08 1.105467898425e+00 5.000000000000e-08 4.000000000000e-01 5.025000000000e-08 -7.027339492126e-01 5.050000000000e-08 -8.242640687119e-01 5.075000000000e-08 -1.993211525331e-01 5.100000000000e-08 5.551115123126e-16 5.125000000000e-08 -2.668178637919e-01 5.150000000000e-08 -2.242640687119e-01 5.175000000000e-08 6.021752652407e-02 5.200000000000e-08 -1.088018564133e-14 5.225000000000e-08 -1.801087632620e-01 5.250000000000e-08 2.426406871193e-02 5.275000000000e-08 2.336357275839e-01 5.300000000000e-08 -5.925815393937e-15 5.325000000000e-08 -5.033942373345e-02 5.350000000000e-08 6.242640687119e-01 5.375000000000e-08 1.105467898425e+00 5.400000000000e-08 4.000000000000e-01 5.425000000000e-08 -7.027339492126e-01 5.450000000000e-08 -8.242640687119e-01 5.475000000000e-08 -1.993211525331e-01 5.500000000000e-08 -5.065392549852e-15 5.525000000000e-08 -2.668178637919e-01 5.550000000000e-08 -2.242640687119e-01 5.575000000000e-08 6.021752652407e-02 5.600000000000e-08 -1.498801083244e-14 5.625000000000e-08 -1.801087632620e-01 5.650000000000e-08 2.426406871194e-02 5.675000000000e-08 2.336357275839e-01 5.700000000000e-08 -1.457167719821e-15 5.725000000000e-08 -5.033942373345e-02 5.750000000000e-08 6.242640687119e-01 5.775000000000e-08 1.105467898425e+00 5.800000000000e-08 4.000000000000e-01 5.825000000000e-08 -7.027339492126e-01 5.850000000000e-08 -8.242640687119e-01 5.875000000000e-08 -1.993211525331e-01 5.900000000000e-08 -4.968248035198e-15 5.925000000000e-08 -2.668178637919e-01 5.950000000000e-08 -2.242640687119e-01 5.975000000000e-08 6.021752652407e-02 6.000000000000e-08 -2.765843110097e-14 6.025000000000e-08 -1.801087632620e-01 6.050000000000e-08 2.426406871195e-02 6.075000000000e-08 2.336357275839e-01 6.100000000000e-08 2.942091015257e-15 6.125000000000e-08 -5.033942373345e-02 6.150000000000e-08 6.242640687119e-01 6.175000000000e-08 1.105467898425e+00 6.200000000000e-08 4.000000000000e-01 6.225000000000e-08 -7.027339492126e-01 6.250000000000e-08 -8.242640687119e-01 6.275000000000e-08 -1.993211525331e-01 6.300000000000e-08 -1.051936315832e-14 6.325000000000e-08 -2.668178637919e-01 6.350000000000e-08 -2.242640687119e-01 6.375000000000e-08 6.021752652407e-02 6.400000000000e-08 -1.897093593328e-14 6.425000000000e-08 -1.801087632620e-01 6.450000000000e-08 2.426406871195e-02 6.475000000000e-08 2.336357275839e-01 6.500000000000e-08 3.330669073875e-16 6.525000000000e-08 -5.033942373345e-02 6.550000000000e-08 6.242640687119e-01 6.575000000000e-08 1.105467898425e+00 6.600000000000e-08 4.000000000000e-01 6.625000000000e-08 -7.027339492126e-01 6.650000000000e-08 -8.242640687119e-01 6.675000000000e-08 -1.993211525331e-01 6.700000000000e-08 -6.161737786670e-15 6.725000000000e-08 -2.668178637919e-01 6.750000000000e-08 -2.242640687119e-01 6.775000000000e-08 6.021752652407e-02 6.800000000000e-08 -1.028344076559e-14 6.825000000000e-08 -1.801087632620e-01 6.850000000000e-08 2.426406871194e-02 6.875000000000e-08 2.336357275839e-01 6.900000000000e-08 -7.993605777301e-15 6.925000000000e-08 -5.033942373346e-02 6.950000000000e-08 6.242640687119e-01 6.975000000000e-08 1.105467898425e+00 7.000000000000e-08 4.000000000000e-01 7.025000000000e-08 -7.027339492126e-01 7.050000000000e-08 -8.242640687119e-01 7.075000000000e-08 -1.993211525331e-01 7.100000000000e-08 -1.817990202824e-15 7.125000000000e-08 -2.668178637919e-01 7.150000000000e-08 -2.242640687119e-01 7.175000000000e-08 6.021752652407e-02 7.200000000000e-08 -5.884182030513e-15 7.225000000000e-08 -1.801087632620e-01 7.250000000000e-08 2.426406871194e-02 7.275000000000e-08 2.336357275839e-01 7.300000000000e-08 -3.524958103185e-15 7.325000000000e-08 -5.033942373344e-02 7.350000000000e-08 6.242640687119e-01 7.375000000000e-08 1.105467898425e+00 7.400000000000e-08 4.000000000000e-01 7.425000000000e-08 -7.027339492126e-01 7.450000000000e-08 -8.242640687119e-01 7.475000000000e-08 -1.993211525331e-01 7.500000000000e-08 -7.369105325949e-15 7.525000000000e-08 -2.668178637919e-01 7.550000000000e-08 -2.242640687119e-01 7.575000000000e-08 6.021752652407e-02 7.600000000000e-08 -1.426636586643e-14 7.625000000000e-08 -1.801087632620e-01 7.650000000000e-08 2.426406871193e-02 7.675000000000e-08 2.336357275839e-01 7.700000000000e-08 6.647460359943e-15 7.725000000000e-08 -5.033942373345e-02 7.750000000000e-08 6.242640687119e-01 7.775000000000e-08 1.105467898425e+00 7.800000000000e-08 4.000000000000e-01 7.825000000000e-08 -7.027339492126e-01 7.850000000000e-08 -8.242640687119e-01 7.875000000000e-08 -1.993211525331e-01 7.900000000000e-08 -1.297573160031e-14 7.925000000000e-08 -2.668178637919e-01 7.950000000000e-08 -2.242640687119e-01 7.975000000000e-08 6.021752652407e-02 8.000000000000e-08 -5.578870698741e-15 ]
VWL030 (wl030 0) vsource type=pwl wave=[ 0.000000000000e+00 0.000000000000e+00 2.500000000000e-10 1.397824734759e-01 5.000000000000e-10 3.414213562373e-01 7.500000000000e-10 1.331821362081e-01 1.000000000000e-09 -9.714451465470e-17 1.250000000000e-09 3.993211525331e-01 1.500000000000e-09 5.414213562373e-01 1.750000000000e-09 -3.027339492126e-01 2.000000000000e-09 -1.200000000000e+00 2.250000000000e-09 -9.054678984252e-01 2.500000000000e-09 5.857864376269e-02 2.750000000000e-09 3.496605762665e-01 3.000000000000e-09 2.636779683485e-16 3.250000000000e-09 -3.363572758386e-02 3.500000000000e-09 2.585786437627e-01 3.750000000000e-09 2.198912367380e-01 4.000000000000e-09 -3.885780586188e-16 4.250000000000e-09 1.397824734759e-01 4.500000000000e-09 3.414213562373e-01 4.750000000000e-09 1.331821362081e-01 5.000000000000e-09 -6.522560269673e-16 5.250000000000e-09 3.993211525331e-01 5.500000000000e-09 5.414213562373e-01 5.750000000000e-09 -3.027339492126e-01 6.000000000000e-09 -1.200000000000e+00 6.250000000000e-09 -9.054678984252e-01 6.500000000000e-09 5.857864376269e-02 6.750000000000e-09 3.496605762665e-01 7.000000000000e-09 -2.775557561563e-17 7.250000000000e-09 -3.363572758386e-02 7.500000000000e-09 2.585786437627e-01 7.750000000000e-09 2.198912367380e-01 8.000000000000e-09 -8.326672684689e-16 8.250000000000e-09 1.397824734759e-01 8.500000000000e-09 3.414213562373e-01 8.750000000000e-09 1.331821362081e-01 9.000000000000e-09 4.579669976579e-16 9.250000000000e-09 3.993211525331e-01 9.500000000000e-09 5.414213562373e-01 9.750000000000e-09 -3.027339492126e-01 1.000000000000e-08 -1.200000000000e+00 1.025000000000e-08 -9.054678984252e-01 1.050000000000e-08 5.857864376269e-02 1.075000000000e-08 3.496605762665e-01 1.100000000000e-08 1.804112415016e-16 1.125000000000e-08 -3.363572758386e-02 1.150000000000e-08 2.585786437627e-01 1.175000000000e-08 2.198912367380e-01 1.200000000000e-08 -1.609823385706e-15 1.225000000000e-08 1.397824734759e-01 1.250000000000e-08 3.414213562373e-01 1.275000000000e-08 1.331821362081e-01 1.300000000000e-08 -1.706967900361e-15 1.325000000000e-08 3.993211525331e-01 1.350000000000e-08 5.414213562373e-01 1.375000000000e-08 -3.027339492126e-01 1.400000000000e-08 -1.200000000000e+00 1.425000000000e-08 -9.054678984252e-01 1.450000000000e-08 5.857864376269e-02 1.475000000000e-08 3.496605762665e-01 1.500000000000e-08 7.216449660064e-16 1.525000000000e-08 -3.363572758386e-02 1.550000000000e-08 2.585786437627e-01 1.575000000000e-08 2.198912367380e-01 1.600000000000e-08 -1.554312234475e-15 1.625000000000e-08 1.397824734759e-01 1.650000000000e-08 3.414213562373e-01 1.675000000000e-08 1.331821362081e-01 1.700000000000e-08 -1.804112415016e-15 1.725000000000e-08 3.993211525331e-01 1.750000000000e-08 5.414213562373e-01 1.775000000000e-08 -3.027339492126e-01 1.800000000000e-08 -1.200000000000e+00 1.825000000000e-08 -9.054678984252e-01 1.850000000000e-08 5.857864376269e-02 1.875000000000e-08 3.496605762665e-01 1.900000000000e-08 2.720046410332e-15 1.925000000000e-08 -3.363572758386e-02 1.950000000000e-08 2.585786437627e-01 1.975000000000e-08 2.198912367380e-01 2.000000000000e-08 -4.440892098501e-16 2.025000000000e-08 1.397824734759e-01 2.050000000000e-08 3.414213562373e-01 2.075000000000e-08 1.331821362081e-01 2.100000000000e-08 1.804112415016e-16 2.125000000000e-08 3.993211525331e-01 2.150000000000e-08 5.414213562373e-01 2.175000000000e-08 -3.027339492126e-01 2.200000000000e-08 -1.200000000000e+00 2.225000000000e-08 -9.054678984252e-01 2.250000000000e-08 5.857864376270e-02 2.275000000000e-08 3.496605762665e-01 2.300000000000e-08 1.137978600241e-15 2.325000000000e-08 -3.363572758386e-02 2.350000000000e-08 2.585786437627e-01 2.375000000000e-08 2.198912367380e-01 2.400000000000e-08 -3.275157922644e-15 2.425000000000e-08 1.397824734759e-01 2.450000000000e-08 3.414213562373e-01 2.475000000000e-08 1.331821362081e-01 2.500000000000e-08 -2.040034807749e-15 2.525000000000e-08 3.993211525331e-01 2.550000000000e-08 5.414213562373e-01 2.575000000000e-08 -3.027339492126e-01 2.600000000000e-08 -1.200000000000e+00 2.625000000000e-08 -9.054678984252e-01 2.650000000000e-08 5.857864376270e-02 2.675000000000e-08 3.496605762665e-01 2.700000000000e-08 2.775557561563e-15 2.725000000000e-08 -3.363572758386e-02 2.750000000000e-08 2.585786437627e-01 2.775000000000e-08 2.198912367380e-01 2.800000000000e-08 -2.442490654175e-15 2.825000000000e-08 1.397824734759e-01 2.850000000000e-08 3.414213562373e-01 2.875000000000e-08 1.331821362081e-01 2.900000000000e-08 -4.260480856999e-15 2.925000000000e-08 3.993211525331e-01 2.950000000000e-08 5.414213562373e-01 2.975000000000e-08 -3.027339492126e-01 3.000000000000e-08 -1.200000000000e+00 3.025000000000e-08 -9.054678984252e-01 3.050000000000e-08 5.857864376269e-02 3.075000000000e-08 3.496605762665e-01 3.100000000000e-08 5.065392549852e-15 3.125000000000e-08 -3.363572758385e-02 3.150000000000e-08 2.585786437627e-01 3.175000000000e-08 2.198912367380e-01 3.200000000000e-08 -3.219646771413e-15 3.225000000000e-08 1.397824734759e-01 3.250000000000e-08 3.414213562373e-01 3.275000000000e-08 1.331821362081e-01 3.300000000000e-08 -1.471045507628e-15 3.325000000000e-08 3.993211525331e-01 3.350000000000e-08 5.414213562373e-01 3.375000000000e-08 -3.027339492126e-01 3.400000000000e-08 -1.200000000000e+00 3.425000000000e-08 -9.054678984252e-01 3.450000000000e-08 5.857864376270e-02 3.475000000000e-08 3.496605762665e-01 3.500000000000e-08 -4.440892098501e-16 3.525000000000e-08 -3.363572758385e-02 3.550000000000e-08 2.585786437627e-01 3.575000000000e-08 2.198912367380e-01 3.600000000000e-08 -9.992007221626e-16 3.625000000000e-08 1.397824734759e-01 3.650000000000e-08 3.414213562373e-01 3.675000000000e-08 1.331821362081e-01 3.700000000000e-08 -8.701372955500e-15 3.725000000000e-08 3.993211525331e-01 3.750000000000e-08 5.414213562373e-01 3.775000000000e-08 -3.027339492126e-01 3.800000000000e-08 -1.200000000000e+00 3.825000000000e-08 -9.054678984252e-01 3.850000000000e-08 5.857864376268e-02 3.875000000000e-08 3.496605762666e-01 3.900000000000e-08 2.622901895677e-15 3.925000000000e-08 -3.363572758385e-02 3.950000000000e-08 2.585786437627e-01 3.975000000000e-08 2.198912367380e-01 4.000000000000e-08 -8.881784197001e-16 4.025000000000e-08 1.397824734759e-01 4.050000000000e-08 3.414213562373e-01 4.075000000000e-08 1.331821362081e-01 4.100000000000e-08 -5.981326545168e-15 4.125000000000e-08 3.993211525331e-01 4.150000000000e-08 5.414213562373e-01 4.175000000000e-08 -3.027339492126e-01 4.200000000000e-08 -1.200000000000e+00 4.225000000000e-08 -9.054678984252e-01 4.250000000000e-08 5.857864376269e-02 4.275000000000e-08 3.496605762666e-01 4.300000000000e-08 3.538835890993e-15 4.325000000000e-08 -3.363572758386e-02 4.350000000000e-08 2.585786437627e-01 4.375000000000e-08 2.198912367380e-01 4.400000000000e-08 -2.331468351713e-15 4.425000000000e-08 1.397824734759e-01 4.450000000000e-08 3.414213562373e-01 4.475000000000e-08 1.331821362081e-01 4.500000000000e-08 -3.191891195797e-15 4.525000000000e-08 3.993211525331e-01 4.550000000000e-08 5.414213562373e-01 4.575000000000e-08 -3.027339492126e-01 4.600000000000e-08 -1.200000000000e+00 4.625000000000e-08 -9.054678984252e-01 4.650000000000e-08 5.857864376270e-02 4.675000000000e-08 3.496605762665e-01 4.700000000000e-08 -1.970645868710e-15 4.725000000000e-08 -3.363572758386e-02 4.750000000000e-08 2.585786437627e-01 4.775000000000e-08 2.198912367380e-01 4.800000000000e-08 -6.550315845288e-15 4.825000000000e-08 1.397824734759e-01 4.850000000000e-08 3.414213562373e-01 4.875000000000e-08 1.331821362081e-01 4.900000000000e-08 -1.042221864367e-14 4.925000000000e-08 3.993211525331e-01 4.950000000000e-08 5.414213562373e-01 4.975000000000e-08 -3.027339492126e-01 5.000000000000e-08 -1.200000000000e+00 5.025000000000e-08 -9.054678984252e-01 5.050000000000e-08 5.857864376268e-02 5.075000000000e-08 3.496605762666e-01 5.100000000000e-08 8.146261443187e-15 5.125000000000e-08 -3.363572758385e-02 5.150000000000e-08 2.585786437627e-01 5.175000000000e-08 2.198912367380e-01 5.200000000000e-08 -3.608224830032e-15 5.225000000000e-08 1.397824734759e-01 5.250000000000e-08 3.414213562373e-01 5.275000000000e-08 1.331821362081e-01 5.300000000000e-08 -7.688294445529e-15 5.325000000000e-08 3.993211525331e-01 5.350000000000e-08 5.414213562373e-01 5.375000000000e-08 -3.027339492126e-01 5.400000000000e-08 -1.200000000000e+00 5.425000000000e-08 -9.054678984252e-01 5.450000000000e-08 5.857864376270e-02 5.475000000000e-08 3.496605762665e-01 5.500000000000e-08 1.121325254871e-14 5.525000000000e-08 -3.363572758385e-02 5.550000000000e-08 2.585786437627e-01 5.575000000000e-08 2.198912367379e-01 5.600000000000e-08 -5.051514762044e-15 5.625000000000e-08 1.397824734759e-01 5.650000000000e-08 3.414213562373e-01 5.675000000000e-08 1.331821362081e-01 5.700000000000e-08 -6.411537967210e-15 5.725000000000e-08 3.993211525331e-01 5.750000000000e-08 5.414213562373e-01 5.775000000000e-08 -3.027339492126e-01 5.800000000000e-08 -1.200000000000e+00 5.825000000000e-08 -9.054678984252e-01 5.850000000000e-08 5.857864376269e-02 5.875000000000e-08 3.496605762665e-01 5.900000000000e-08 -2.803313137179e-15 5.925000000000e-08 -3.363572758384e-02 5.950000000000e-08 2.585786437627e-01 5.975000000000e-08 2.198912367380e-01 6.000000000000e-08 -9.214851104389e-15 6.025000000000e-08 1.397824734759e-01 6.050000000000e-08 3.414213562373e-01 6.075000000000e-08 1.331821362081e-01 6.100000000000e-08 -5.051514762044e-15 6.125000000000e-08 3.993211525331e-01 6.150000000000e-08 5.414213562373e-01 6.175000000000e-08 -3.027339492126e-01 6.200000000000e-08 -1.200000000000e+00 6.225000000000e-08 -9.054678984252e-01 6.250000000000e-08 5.857864376272e-02 6.275000000000e-08 3.496605762665e-01 6.300000000000e-08 2.775557561563e-16 6.325000000000e-08 -3.363572758385e-02 6.350000000000e-08 2.585786437627e-01 6.375000000000e-08 2.198912367380e-01 6.400000000000e-08 -6.272760089132e-15 6.425000000000e-08 1.397824734759e-01 6.450000000000e-08 3.414213562373e-01 6.475000000000e-08 1.331821362081e-01 6.500000000000e-08 -1.079691891448e-14 6.525000000000e-08 3.993211525331e-01 6.550000000000e-08 5.414213562373e-01 6.575000000000e-08 -3.027339492126e-01 6.600000000000e-08 -1.200000000000e+00 6.625000000000e-08 -9.054678984252e-01 6.650000000000e-08 5.857864376270e-02 6.675000000000e-08 3.496605762666e-01 6.700000000000e-08 1.859623566247e-15 6.725000000000e-08 -3.363572758384e-02 6.750000000000e-08 2.585786437627e-01 6.775000000000e-08 2.198912367380e-01 6.800000000000e-08 -3.441691376338e-15 6.825000000000e-08 1.397824734759e-01 6.850000000000e-08 3.414213562373e-01 6.875000000000e-08 1.331821362081e-01 6.900000000000e-08 4.163336342344e-16 6.925000000000e-08 3.993211525331e-01 6.950000000000e-08 5.414213562373e-01 6.975000000000e-08 -3.027339492126e-01 7.000000000000e-08 -1.200000000000e+00 7.025000000000e-08 -9.054678984251e-01 7.050000000000e-08 5.857864376269e-02 7.075000000000e-08 3.496605762665e-01 7.100000000000e-08 3.511080315377e-15 7.125000000000e-08 -3.363572758384e-02 7.150000000000e-08 2.585786437627e-01 7.175000000000e-08 2.198912367379e-01 7.200000000000e-08 -1.942890293094e-15 7.225000000000e-08 1.397824734759e-01 7.250000000000e-08 3.414213562373e-01 7.275000000000e-08 1.331821362081e-01 7.300000000000e-08 1.762479051592e-15 7.325000000000e-08 3.993211525331e-01 7.350000000000e-08 5.414213562373e-01 7.375000000000e-08 -3.027339492126e-01 7.400000000000e-08 -1.200000000000e+00 7.425000000000e-08 -9.054678984251e-01 7.450000000000e-08 5.857864376268e-02 7.475000000000e-08 3.496605762665e-01 7.500000000000e-08 6.480926906249e-15 7.525000000000e-08 -3.363572758385e-02 7.550000000000e-08 2.585786437627e-01 7.575000000000e-08 2.198912367379e-01 7.600000000000e-08 -4.829470157119e-15 7.625000000000e-08 1.397824734759e-01 7.650000000000e-08 3.414213562373e-01 7.675000000000e-08 1.331821362081e-01 7.700000000000e-08 -1.398881011028e-14 7.725000000000e-08 3.993211525331e-01 7.750000000000e-08 5.414213562373e-01 7.775000000000e-08 -3.027339492126e-01 7.800000000000e-08 -1.200000000000e+00 7.825000000000e-08 -9.054678984252e-01 7.850000000000e-08 5.857864376271e-02 7.875000000000e-08 3.496605762665e-01 7.900000000000e-08 9.561795799584e-15 7.925000000000e-08 -3.363572758385e-02 7.950000000000e-08 2.585786437627e-01 7.975000000000e-08 2.198912367380e-01 8.000000000000e-08 -1.887379141863e-15 ]
VWL031 (wl031 0) vsource type=pwl wave=[ 0.000000000000e+00 0.000000000000e+00 2.500000000000e-10 1.801087632620e-01 5.000000000000e-10 -2.426406871193e-02 7.500000000000e-10 -2.336357275839e-01 1.000000000000e-09 9.714451465470e-17 1.250000000000e-09 5.033942373345e-02 1.500000000000e-09 -6.242640687119e-01 1.750000000000e-09 -1.105467898425e+00 2.000000000000e-09 -4.000000000000e-01 2.250000000000e-09 7.027339492126e-01 2.500000000000e-09 8.242640687119e-01 2.750000000000e-09 1.993211525331e-01 3.000000000000e-09 5.412337245048e-16 3.250000000000e-09 2.668178637919e-01 3.500000000000e-09 2.242640687119e-01 3.750000000000e-09 -6.021752652407e-02 4.000000000000e-09 1.193489751472e-15 4.250000000000e-09 1.801087632620e-01 4.500000000000e-09 -2.426406871193e-02 4.750000000000e-09 -2.336357275839e-01 5.000000000000e-09 -4.024558464266e-16 5.250000000000e-09 5.033942373345e-02 5.500000000000e-09 -6.242640687119e-01 5.750000000000e-09 -1.105467898425e+00 6.000000000000e-09 -4.000000000000e-01 6.250000000000e-09 7.027339492126e-01 6.500000000000e-09 8.242640687119e-01 6.750000000000e-09 1.993211525331e-01 7.000000000000e-09 8.743006318923e-16 7.250000000000e-09 2.668178637919e-01 7.500000000000e-09 2.242640687119e-01 7.750000000000e-09 -6.021752652407e-02 8.000000000000e-09 2.373101715136e-15 8.250000000000e-09 1.801087632620e-01 8.500000000000e-09 -2.426406871193e-02 8.750000000000e-09 -2.336357275839e-01 9.000000000000e-09 1.013078509970e-15 9.250000000000e-09 5.033942373345e-02 9.500000000000e-09 -6.242640687119e-01 9.750000000000e-09 -1.105467898425e+00 1.000000000000e-08 -4.000000000000e-01 1.025000000000e-08 7.027339492126e-01 1.050000000000e-08 8.242640687119e-01 1.075000000000e-08 1.993211525331e-01 1.100000000000e-08 7.632783294298e-16 1.125000000000e-08 2.668178637919e-01 1.150000000000e-08 2.242640687119e-01 1.175000000000e-08 -6.021752652407e-02 1.200000000000e-08 4.898859096159e-15 1.225000000000e-08 1.801087632620e-01 1.250000000000e-08 -2.426406871193e-02 1.275000000000e-08 -2.336357275839e-01 1.300000000000e-08 4.163336342344e-17 1.325000000000e-08 5.033942373345e-02 1.350000000000e-08 -6.242640687119e-01 1.375000000000e-08 -1.105467898425e+00 1.400000000000e-08 -4.000000000000e-01 1.425000000000e-08 7.027339492126e-01 1.450000000000e-08 8.242640687119e-01 1.475000000000e-08 1.993211525331e-01 1.500000000000e-08 3.191891195797e-15 1.525000000000e-08 2.668178637919e-01 1.550000000000e-08 2.242640687119e-01 1.575000000000e-08 -6.021752652407e-02 1.600000000000e-08 4.732325642465e-15 1.625000000000e-08 1.801087632620e-01 1.650000000000e-08 -2.426406871193e-02 1.675000000000e-08 -2.336357275839e-01 1.700000000000e-08 -1.110223024625e-16 1.725000000000e-08 5.033942373345e-02 1.750000000000e-08 -6.242640687119e-01 1.775000000000e-08 -1.105467898425e+00 1.800000000000e-08 -4.000000000000e-01 1.825000000000e-08 7.027339492126e-01 1.850000000000e-08 8.242640687119e-01 1.875000000000e-08 1.993211525331e-01 1.900000000000e-08 1.304512053935e-15 1.925000000000e-08 2.668178637919e-01 1.950000000000e-08 2.242640687119e-01 1.975000000000e-08 -6.021752652407e-02 2.000000000000e-08 1.387778780781e-15 2.025000000000e-08 1.801087632620e-01 2.050000000000e-08 -2.426406871193e-02 2.075000000000e-08 -2.336357275839e-01 2.100000000000e-08 4.024558464266e-16 2.125000000000e-08 5.033942373345e-02 2.150000000000e-08 -6.242640687119e-01 2.175000000000e-08 -1.105467898425e+00 2.200000000000e-08 -4.000000000000e-01 2.225000000000e-08 7.027339492126e-01 2.250000000000e-08 8.242640687119e-01 2.275000000000e-08 1.993211525331e-01 2.300000000000e-08 2.955968803064e-15 2.325000000000e-08 2.668178637919e-01 2.350000000000e-08 2.242640687119e-01 2.375000000000e-08 -6.021752652407e-02 2.400000000000e-08 9.769962616701e-15 2.425000000000e-08 1.801087632620e-01 2.450000000000e-08 -2.426406871193e-02 2.475000000000e-08 -2.336357275839e-01 2.500000000000e-08 -4.718447854657e-16 2.525000000000e-08 5.033942373345e-02 2.550000000000e-08 -6.242640687119e-01 2.575000000000e-08 -1.105467898425e+00 2.600000000000e-08 -4.000000000000e-01 2.625000000000e-08 7.027339492126e-01 2.650000000000e-08 8.242640687119e-01 2.675000000000e-08 1.993211525331e-01 2.700000000000e-08 -1.346145417358e-15 2.725000000000e-08 2.668178637919e-01 2.750000000000e-08 2.242640687119e-01 2.775000000000e-08 -6.021752652407e-02 2.800000000000e-08 7.494005416220e-15 2.825000000000e-08 1.801087632620e-01 2.850000000000e-08 -2.426406871193e-02 2.875000000000e-08 -2.336357275839e-01 2.900000000000e-08 -1.443289932013e-15 2.925000000000e-08 5.033942373345e-02 2.950000000000e-08 -6.242640687119e-01 2.975000000000e-08 -1.105467898425e+00 3.000000000000e-08 -4.000000000000e-01 3.025000000000e-08 7.027339492126e-01 3.050000000000e-08 8.242640687119e-01 3.075000000000e-08 1.993211525331e-01 3.100000000000e-08 -7.632783294298e-16 3.125000000000e-08 2.668178637919e-01 3.150000000000e-08 2.242640687119e-01 3.175000000000e-08 -6.021752652407e-02 3.200000000000e-08 9.478529072737e-15 3.225000000000e-08 1.801087632620e-01 3.250000000000e-08 -2.426406871193e-02 3.275000000000e-08 -2.336357275839e-01 3.300000000000e-08 4.052314039882e-15 3.325000000000e-08 5.033942373345e-02 3.350000000000e-08 -6.242640687119e-01 3.375000000000e-08 -1.105467898425e+00 3.400000000000e-08 -4.000000000000e-01 3.425000000000e-08 7.027339492126e-01 3.450000000000e-08 8.242640687119e-01 3.475000000000e-08 1.993211525331e-01 3.500000000000e-08 2.012279232133e-15 3.525000000000e-08 2.668178637919e-01 3.550000000000e-08 2.242640687119e-01 3.575000000000e-08 -6.021752652407e-02 3.600000000000e-08 2.942091015257e-15 3.625000000000e-08 1.801087632620e-01 3.650000000000e-08 -2.426406871193e-02 3.675000000000e-08 -2.336357275839e-01 3.700000000000e-08 -3.233524559221e-15 3.725000000000e-08 5.033942373346e-02 3.750000000000e-08 -6.242640687119e-01 3.775000000000e-08 -1.105467898425e+00 3.800000000000e-08 -4.000000000000e-01 3.825000000000e-08 7.027339492126e-01 3.850000000000e-08 8.242640687119e-01 3.875000000000e-08 1.993211525331e-01 3.900000000000e-08 7.591149930875e-15 3.925000000000e-08 2.668178637919e-01 3.950000000000e-08 2.242640687119e-01 3.975000000000e-08 -6.021752652407e-02 4.000000000000e-08 2.789435349371e-15 4.025000000000e-08 1.801087632620e-01 4.050000000000e-08 -2.426406871194e-02 4.075000000000e-08 -2.336357275839e-01 4.100000000000e-08 2.275957200482e-15 4.125000000000e-08 5.033942373345e-02 4.150000000000e-08 -6.242640687119e-01 4.175000000000e-08 -1.105467898425e+00 4.200000000000e-08 -4.000000000000e-01 4.225000000000e-08 7.027339492126e-01 4.250000000000e-08 8.242640687119e-01 4.275000000000e-08 1.993211525331e-01 4.300000000000e-08 -1.748601263785e-15 4.325000000000e-08 2.668178637919e-01 4.350000000000e-08 2.242640687119e-01 4.375000000000e-08 -6.021752652407e-02 4.400000000000e-08 6.911138328292e-15 4.425000000000e-08 1.801087632620e-01 4.450000000000e-08 -2.426406871193e-02 4.475000000000e-08 -2.336357275839e-01 4.500000000000e-08 7.716050021145e-15 4.525000000000e-08 5.033942373345e-02 4.550000000000e-08 -6.242640687119e-01 4.575000000000e-08 -1.105467898425e+00 4.600000000000e-08 -4.000000000000e-01 4.625000000000e-08 7.027339492126e-01 4.650000000000e-08 8.242640687119e-01 4.675000000000e-08 1.993211525331e-01 4.700000000000e-08 9.714451465470e-16 4.725000000000e-08 2.668178637919e-01 4.750000000000e-08 2.242640687119e-01 4.775000000000e-08 -6.021752652407e-02 4.800000000000e-08 1.955380302121e-14 4.825000000000e-08 1.801087632620e-01 4.850000000000e-08 -2.426406871194e-02 4.875000000000e-08 -2.336357275839e-01 4.900000000000e-08 4.302114220422e-16 4.925000000000e-08 5.033942373345e-02 4.950000000000e-08 -6.242640687119e-01 4.975000000000e-08 -1.105467898425e+00 5.000000000000e-08 -4.000000000000e-01 5.025000000000e-08 7.027339492126e-01 5.050000000000e-08 8.242640687119e-01 5.075000000000e-08 1.993211525331e-01 5.100000000000e-08 -5.551115123126e-16 5.125000000000e-08 2.668178637919e-01 5.150000000000e-08 2.242640687119e-01 5.175000000000e-08 -6.021752652407e-02 5.200000000000e-08 1.088018564133e-14 5.225000000000e-08 1.801087632620e-01 5.250000000000e-08 -2.426406871193e-02 5.275000000000e-08 -2.336357275839e-01 5.300000000000e-08 5.925815393937e-15 5.325000000000e-08 5.033942373345e-02 5.350000000000e-08 -6.242640687119e-01 5.375000000000e-08 -1.105467898425e+00 5.400000000000e-08 -4.000000000000e-01 5.425000000000e-08 7.027339492126e-01 5.450000000000e-08 8.242640687119e-01 5.475000000000e-08 1.993211525331e-01 5.500000000000e-08 5.065392549852e-15 5.525000000000e-08 2.668178637919e-01 5.550000000000e-08 2.242640687119e-01 5.575000000000e-08 -6.021752652407e-02 5.600000000000e-08 1.498801083244e-14 5.625000000000e-08 1.801087632620e-01 5.650000000000e-08 -2.426406871194e-02 5.675000000000e-08 -2.336357275839e-01 5.700000000000e-08 1.457167719821e-15 5.725000000000e-08 5.033942373345e-02 5.750000000000e-08 -6.242640687119e-01 5.775000000000e-08 -1.105467898425e+00 5.800000000000e-08 -4.000000000000e-01 5.825000000000e-08 7.027339492126e-01 5.850000000000e-08 8.242640687119e-01 5.875000000000e-08 1.993211525331e-01 5.900000000000e-08 4.968248035198e-15 5.925000000000e-08 2.668178637919e-01 5.950000000000e-08 2.242640687119e-01 5.975000000000e-08 -6.021752652407e-02 6.000000000000e-08 2.765843110097e-14 6.025000000000e-08 1.801087632620e-01 6.050000000000e-08 -2.426406871195e-02 6.075000000000e-08 -2.336357275839e-01 6.100000000000e-08 -2.942091015257e-15 6.125000000000e-08 5.033942373345e-02 6.150000000000e-08 -6.242640687119e-01 6.175000000000e-08 -1.105467898425e+00 6.200000000000e-08 -4.000000000000e-01 6.225000000000e-08 7.027339492126e-01 6.250000000000e-08 8.242640687119e-01 6.275000000000e-08 1.993211525331e-01 6.300000000000e-08 1.051936315832e-14 6.325000000000e-08 2.668178637919e-01 6.350000000000e-08 2.242640687119e-01 6.375000000000e-08 -6.021752652407e-02 6.400000000000e-08 1.897093593328e-14 6.425000000000e-08 1.801087632620e-01 6.450000000000e-08 -2.426406871195e-02 6.475000000000e-08 -2.336357275839e-01 6.500000000000e-08 -3.330669073875e-16 6.525000000000e-08 5.033942373345e-02 6.550000000000e-08 -6.242640687119e-01 6.575000000000e-08 -1.105467898425e+00 6.600000000000e-08 -4.000000000000e-01 6.625000000000e-08 7.027339492126e-01 6.650000000000e-08 8.242640687119e-01 6.675000000000e-08 1.993211525331e-01 6.700000000000e-08 6.161737786670e-15 6.725000000000e-08 2.668178637919e-01 6.750000000000e-08 2.242640687119e-01 6.775000000000e-08 -6.021752652407e-02 6.800000000000e-08 1.028344076559e-14 6.825000000000e-08 1.801087632620e-01 6.850000000000e-08 -2.426406871194e-02 6.875000000000e-08 -2.336357275839e-01 6.900000000000e-08 7.993605777301e-15 6.925000000000e-08 5.033942373346e-02 6.950000000000e-08 -6.242640687119e-01 6.975000000000e-08 -1.105467898425e+00 7.000000000000e-08 -4.000000000000e-01 7.025000000000e-08 7.027339492126e-01 7.050000000000e-08 8.242640687119e-01 7.075000000000e-08 1.993211525331e-01 7.100000000000e-08 1.817990202824e-15 7.125000000000e-08 2.668178637919e-01 7.150000000000e-08 2.242640687119e-01 7.175000000000e-08 -6.021752652407e-02 7.200000000000e-08 5.884182030513e-15 7.225000000000e-08 1.801087632620e-01 7.250000000000e-08 -2.426406871194e-02 7.275000000000e-08 -2.336357275839e-01 7.300000000000e-08 3.524958103185e-15 7.325000000000e-08 5.033942373344e-02 7.350000000000e-08 -6.242640687119e-01 7.375000000000e-08 -1.105467898425e+00 7.400000000000e-08 -4.000000000000e-01 7.425000000000e-08 7.027339492126e-01 7.450000000000e-08 8.242640687119e-01 7.475000000000e-08 1.993211525331e-01 7.500000000000e-08 7.369105325949e-15 7.525000000000e-08 2.668178637919e-01 7.550000000000e-08 2.242640687119e-01 7.575000000000e-08 -6.021752652407e-02 7.600000000000e-08 1.426636586643e-14 7.625000000000e-08 1.801087632620e-01 7.650000000000e-08 -2.426406871193e-02 7.675000000000e-08 -2.336357275839e-01 7.700000000000e-08 -6.647460359943e-15 7.725000000000e-08 5.033942373345e-02 7.750000000000e-08 -6.242640687119e-01 7.775000000000e-08 -1.105467898425e+00 7.800000000000e-08 -4.000000000000e-01 7.825000000000e-08 7.027339492126e-01 7.850000000000e-08 8.242640687119e-01 7.875000000000e-08 1.993211525331e-01 7.900000000000e-08 1.297573160031e-14 7.925000000000e-08 2.668178637919e-01 7.950000000000e-08 2.242640687119e-01 7.975000000000e-08 -6.021752652407e-02 8.000000000000e-08 5.578870698741e-15 ]
RBLLOAD000 (bl000 0) resistor r=1
RBLLOAD001 (bl001 0) resistor r=1
RBLLOAD002 (bl002 0) resistor r=1
RBLLOAD003 (bl003 0) resistor r=1
RBLLOAD004 (bl004 0) resistor r=1
RBLLOAD005 (bl005 0) resistor r=1
RBLLOAD006 (bl006 0) resistor r=1
RBLLOAD007 (bl007 0) resistor r=1
RBLLOAD008 (bl008 0) resistor r=1
RBLLOAD009 (bl009 0) resistor r=1
RBLLOAD010 (bl010 0) resistor r=1
RBLLOAD011 (bl011 0) resistor r=1
RBLLOAD012 (bl012 0) resistor r=1
RBLLOAD013 (bl013 0) resistor r=1
RBLLOAD014 (bl014 0) resistor r=1
RBLLOAD015 (bl015 0) resistor r=1
RBLLOAD016 (bl016 0) resistor r=1
RBLLOAD017 (bl017 0) resistor r=1
RBLLOAD018 (bl018 0) resistor r=1
RBLLOAD019 (bl019 0) resistor r=1
RBLLOAD020 (bl020 0) resistor r=1
RBLLOAD021 (bl021 0) resistor r=1
RBLLOAD022 (bl022 0) resistor r=1
RBLLOAD023 (bl023 0) resistor r=1
RBLLOAD024 (bl024 0) resistor r=1
RBLLOAD025 (bl025 0) resistor r=1
RBLLOAD026 (bl026 0) resistor r=1
RBLLOAD027 (bl027 0) resistor r=1
RBLLOAD028 (bl028 0) resistor r=1
RBLLOAD029 (bl029 0) resistor r=1
RBLLOAD030 (bl030 0) resistor r=1
RBLLOAD031 (bl031 0) resistor r=1
MSEL_r000_c000 (n_r000_c000 vdd wl000 wl000) nsel w=45n l=45n
RRAM_r000_c000 (n_r000_c000 bl000) resistor r=1k
MSEL_r000_c001 (n_r000_c001 vdd wl000 wl000) nsel w=45n l=45n
RRAM_r000_c001 (n_r000_c001 bl001) resistor r=1meg
MSEL_r000_c002 (n_r000_c002 vdd wl000 wl000) nsel w=45n l=45n
RRAM_r000_c002 (n_r000_c002 bl002) resistor r=1k
MSEL_r000_c003 (n_r000_c003 vdd wl000 wl000) nsel w=45n l=45n
RRAM_r000_c003 (n_r000_c003 bl003) resistor r=1meg
MSEL_r000_c004 (n_r000_c004 vdd wl000 wl000) nsel w=45n l=45n
RRAM_r000_c004 (n_r000_c004 bl004) resistor r=1k
MSEL_r000_c005 (n_r000_c005 vdd wl000 wl000) nsel w=45n l=45n
RRAM_r000_c005 (n_r000_c005 bl005) resistor r=1k
MSEL_r000_c006 (n_r000_c006 vdd wl000 wl000) nsel w=45n l=45n
RRAM_r000_c006 (n_r000_c006 bl006) resistor r=1k
MSEL_r000_c007 (n_r000_c007 vdd wl000 wl000) nsel w=45n l=45n
RRAM_r000_c007 (n_r000_c007 bl007) resistor r=1k
MSEL_r000_c008 (n_r000_c008 vdd wl000 wl000) nsel w=45n l=45n
RRAM_r000_c008 (n_r000_c008 bl008) resistor r=1k
MSEL_r000_c009 (n_r000_c009 vdd wl000 wl000) nsel w=45n l=45n
RRAM_r000_c009 (n_r000_c009 bl009) resistor r=1meg
MSEL_r000_c010 (n_r000_c010 vdd wl000 wl000) nsel w=45n l=45n
RRAM_r000_c010 (n_r000_c010 bl010) resistor r=1k
MSEL_r000_c011 (n_r000_c011 vdd wl000 wl000) nsel w=45n l=45n
RRAM_r000_c011 (n_r000_c011 bl011) resistor r=1k
MSEL_r000_c012 (n_r000_c012 vdd wl000 wl000) nsel w=45n l=45n
RRAM_r000_c012 (n_r000_c012 bl012) resistor r=1k
MSEL_r000_c013 (n_r000_c013 vdd wl000 wl000) nsel w=45n l=45n
RRAM_r000_c013 (n_r000_c013 bl013) resistor r=1k
MSEL_r000_c014 (n_r000_c014 vdd wl000 wl000) nsel w=45n l=45n
RRAM_r000_c014 (n_r000_c014 bl014) resistor r=1k
MSEL_r000_c015 (n_r000_c015 vdd wl000 wl000) nsel w=45n l=45n
RRAM_r000_c015 (n_r000_c015 bl015) resistor r=1meg
MSEL_r000_c016 (n_r000_c016 vdd wl000 wl000) nsel w=45n l=45n
RRAM_r000_c016 (n_r000_c016 bl016) resistor r=1meg
MSEL_r000_c017 (n_r000_c017 vdd wl000 wl000) nsel w=45n l=45n
RRAM_r000_c017 (n_r000_c017 bl017) resistor r=1k
MSEL_r000_c018 (n_r000_c018 vdd wl000 wl000) nsel w=45n l=45n
RRAM_r000_c018 (n_r000_c018 bl018) resistor r=1k
MSEL_r000_c019 (n_r000_c019 vdd wl000 wl000) nsel w=45n l=45n
RRAM_r000_c019 (n_r000_c019 bl019) resistor r=1meg
MSEL_r000_c020 (n_r000_c020 vdd wl000 wl000) nsel w=45n l=45n
RRAM_r000_c020 (n_r000_c020 bl020) resistor r=1k
MSEL_r000_c021 (n_r000_c021 vdd wl000 wl000) nsel w=45n l=45n
RRAM_r000_c021 (n_r000_c021 bl021) resistor r=1k
MSEL_r000_c022 (n_r000_c022 vdd wl000 wl000) nsel w=45n l=45n
RRAM_r000_c022 (n_r000_c022 bl022) resistor r=1k
MSEL_r000_c023 (n_r000_c023 vdd wl000 wl000) nsel w=45n l=45n
RRAM_r000_c023 (n_r000_c023 bl023) resistor r=1meg
MSEL_r000_c024 (n_r000_c024 vdd wl000 wl000) nsel w=45n l=45n
RRAM_r000_c024 (n_r000_c024 bl024) resistor r=1k
MSEL_r000_c025 (n_r000_c025 vdd wl000 wl000) nsel w=45n l=45n
RRAM_r000_c025 (n_r000_c025 bl025) resistor r=1k
MSEL_r000_c026 (n_r000_c026 vdd wl000 wl000) nsel w=45n l=45n
RRAM_r000_c026 (n_r000_c026 bl026) resistor r=1k
MSEL_r000_c027 (n_r000_c027 vdd wl000 wl000) nsel w=45n l=45n
RRAM_r000_c027 (n_r000_c027 bl027) resistor r=1k
MSEL_r000_c028 (n_r000_c028 vdd wl000 wl000) nsel w=45n l=45n
RRAM_r000_c028 (n_r000_c028 bl028) resistor r=1k
MSEL_r000_c029 (n_r000_c029 vdd wl000 wl000) nsel w=45n l=45n
RRAM_r000_c029 (n_r000_c029 bl029) resistor r=1k
MSEL_r000_c030 (n_r000_c030 vdd wl000 wl000) nsel w=45n l=45n
RRAM_r000_c030 (n_r000_c030 bl030) resistor r=1k
MSEL_r000_c031 (n_r000_c031 vdd wl000 wl000) nsel w=45n l=45n
RRAM_r000_c031 (n_r000_c031 bl031) resistor r=1k
MSEL_r001_c000 (n_r001_c000 vdd wl001 wl001) nsel w=45n l=45n
RRAM_r001_c000 (n_r001_c000 bl000) resistor r=1k
MSEL_r001_c001 (n_r001_c001 vdd wl001 wl001) nsel w=45n l=45n
RRAM_r001_c001 (n_r001_c001 bl001) resistor r=1meg
MSEL_r001_c002 (n_r001_c002 vdd wl001 wl001) nsel w=45n l=45n
RRAM_r001_c002 (n_r001_c002 bl002) resistor r=1meg
MSEL_r001_c003 (n_r001_c003 vdd wl001 wl001) nsel w=45n l=45n
RRAM_r001_c003 (n_r001_c003 bl003) resistor r=1k
MSEL_r001_c004 (n_r001_c004 vdd wl001 wl001) nsel w=45n l=45n
RRAM_r001_c004 (n_r001_c004 bl004) resistor r=1meg
MSEL_r001_c005 (n_r001_c005 vdd wl001 wl001) nsel w=45n l=45n
RRAM_r001_c005 (n_r001_c005 bl005) resistor r=1k
MSEL_r001_c006 (n_r001_c006 vdd wl001 wl001) nsel w=45n l=45n
RRAM_r001_c006 (n_r001_c006 bl006) resistor r=1meg
MSEL_r001_c007 (n_r001_c007 vdd wl001 wl001) nsel w=45n l=45n
RRAM_r001_c007 (n_r001_c007 bl007) resistor r=1meg
MSEL_r001_c008 (n_r001_c008 vdd wl001 wl001) nsel w=45n l=45n
RRAM_r001_c008 (n_r001_c008 bl008) resistor r=1meg
MSEL_r001_c009 (n_r001_c009 vdd wl001 wl001) nsel w=45n l=45n
RRAM_r001_c009 (n_r001_c009 bl009) resistor r=1k
MSEL_r001_c010 (n_r001_c010 vdd wl001 wl001) nsel w=45n l=45n
RRAM_r001_c010 (n_r001_c010 bl010) resistor r=1meg
MSEL_r001_c011 (n_r001_c011 vdd wl001 wl001) nsel w=45n l=45n
RRAM_r001_c011 (n_r001_c011 bl011) resistor r=1meg
MSEL_r001_c012 (n_r001_c012 vdd wl001 wl001) nsel w=45n l=45n
RRAM_r001_c012 (n_r001_c012 bl012) resistor r=1k
MSEL_r001_c013 (n_r001_c013 vdd wl001 wl001) nsel w=45n l=45n
RRAM_r001_c013 (n_r001_c013 bl013) resistor r=1k
MSEL_r001_c014 (n_r001_c014 vdd wl001 wl001) nsel w=45n l=45n
RRAM_r001_c014 (n_r001_c014 bl014) resistor r=1k
MSEL_r001_c015 (n_r001_c015 vdd wl001 wl001) nsel w=45n l=45n
RRAM_r001_c015 (n_r001_c015 bl015) resistor r=1k
MSEL_r001_c016 (n_r001_c016 vdd wl001 wl001) nsel w=45n l=45n
RRAM_r001_c016 (n_r001_c016 bl016) resistor r=1meg
MSEL_r001_c017 (n_r001_c017 vdd wl001 wl001) nsel w=45n l=45n
RRAM_r001_c017 (n_r001_c017 bl017) resistor r=1k
MSEL_r001_c018 (n_r001_c018 vdd wl001 wl001) nsel w=45n l=45n
RRAM_r001_c018 (n_r001_c018 bl018) resistor r=1k
MSEL_r001_c019 (n_r001_c019 vdd wl001 wl001) nsel w=45n l=45n
RRAM_r001_c019 (n_r001_c019 bl019) resistor r=1meg
MSEL_r001_c020 (n_r001_c020 vdd wl001 wl001) nsel w=45n l=45n
RRAM_r001_c020 (n_r001_c020 bl020) resistor r=1meg
MSEL_r001_c021 (n_r001_c021 vdd wl001 wl001) nsel w=45n l=45n
RRAM_r001_c021 (n_r001_c021 bl021) resistor r=1k
MSEL_r001_c022 (n_r001_c022 vdd wl001 wl001) nsel w=45n l=45n
RRAM_r001_c022 (n_r001_c022 bl022) resistor r=1meg
MSEL_r001_c023 (n_r001_c023 vdd wl001 wl001) nsel w=45n l=45n
RRAM_r001_c023 (n_r001_c023 bl023) resistor r=1k
MSEL_r001_c024 (n_r001_c024 vdd wl001 wl001) nsel w=45n l=45n
RRAM_r001_c024 (n_r001_c024 bl024) resistor r=1k
MSEL_r001_c025 (n_r001_c025 vdd wl001 wl001) nsel w=45n l=45n
RRAM_r001_c025 (n_r001_c025 bl025) resistor r=1meg
MSEL_r001_c026 (n_r001_c026 vdd wl001 wl001) nsel w=45n l=45n
RRAM_r001_c026 (n_r001_c026 bl026) resistor r=1meg
MSEL_r001_c027 (n_r001_c027 vdd wl001 wl001) nsel w=45n l=45n
RRAM_r001_c027 (n_r001_c027 bl027) resistor r=1meg
MSEL_r001_c028 (n_r001_c028 vdd wl001 wl001) nsel w=45n l=45n
RRAM_r001_c028 (n_r001_c028 bl028) resistor r=1meg
MSEL_r001_c029 (n_r001_c029 vdd wl001 wl001) nsel w=45n l=45n
RRAM_r001_c029 (n_r001_c029 bl029) resistor r=1meg
MSEL_r001_c030 (n_r001_c030 vdd wl001 wl001) nsel w=45n l=45n
RRAM_r001_c030 (n_r001_c030 bl030) resistor r=1meg
MSEL_r001_c031 (n_r001_c031 vdd wl001 wl001) nsel w=45n l=45n
RRAM_r001_c031 (n_r001_c031 bl031) resistor r=1meg
MSEL_r002_c000 (n_r002_c000 vdd wl002 wl002) nsel w=45n l=45n
RRAM_r002_c000 (n_r002_c000 bl000) resistor r=1meg
MSEL_r002_c001 (n_r002_c001 vdd wl002 wl002) nsel w=45n l=45n
RRAM_r002_c001 (n_r002_c001 bl001) resistor r=1k
MSEL_r002_c002 (n_r002_c002 vdd wl002 wl002) nsel w=45n l=45n
RRAM_r002_c002 (n_r002_c002 bl002) resistor r=1meg
MSEL_r002_c003 (n_r002_c003 vdd wl002 wl002) nsel w=45n l=45n
RRAM_r002_c003 (n_r002_c003 bl003) resistor r=1meg
MSEL_r002_c004 (n_r002_c004 vdd wl002 wl002) nsel w=45n l=45n
RRAM_r002_c004 (n_r002_c004 bl004) resistor r=1k
MSEL_r002_c005 (n_r002_c005 vdd wl002 wl002) nsel w=45n l=45n
RRAM_r002_c005 (n_r002_c005 bl005) resistor r=1k
MSEL_r002_c006 (n_r002_c006 vdd wl002 wl002) nsel w=45n l=45n
RRAM_r002_c006 (n_r002_c006 bl006) resistor r=1k
MSEL_r002_c007 (n_r002_c007 vdd wl002 wl002) nsel w=45n l=45n
RRAM_r002_c007 (n_r002_c007 bl007) resistor r=1meg
MSEL_r002_c008 (n_r002_c008 vdd wl002 wl002) nsel w=45n l=45n
RRAM_r002_c008 (n_r002_c008 bl008) resistor r=1meg
MSEL_r002_c009 (n_r002_c009 vdd wl002 wl002) nsel w=45n l=45n
RRAM_r002_c009 (n_r002_c009 bl009) resistor r=1meg
MSEL_r002_c010 (n_r002_c010 vdd wl002 wl002) nsel w=45n l=45n
RRAM_r002_c010 (n_r002_c010 bl010) resistor r=1meg
MSEL_r002_c011 (n_r002_c011 vdd wl002 wl002) nsel w=45n l=45n
RRAM_r002_c011 (n_r002_c011 bl011) resistor r=1k
MSEL_r002_c012 (n_r002_c012 vdd wl002 wl002) nsel w=45n l=45n
RRAM_r002_c012 (n_r002_c012 bl012) resistor r=1meg
MSEL_r002_c013 (n_r002_c013 vdd wl002 wl002) nsel w=45n l=45n
RRAM_r002_c013 (n_r002_c013 bl013) resistor r=1meg
MSEL_r002_c014 (n_r002_c014 vdd wl002 wl002) nsel w=45n l=45n
RRAM_r002_c014 (n_r002_c014 bl014) resistor r=1meg
MSEL_r002_c015 (n_r002_c015 vdd wl002 wl002) nsel w=45n l=45n
RRAM_r002_c015 (n_r002_c015 bl015) resistor r=1meg
MSEL_r002_c016 (n_r002_c016 vdd wl002 wl002) nsel w=45n l=45n
RRAM_r002_c016 (n_r002_c016 bl016) resistor r=1meg
MSEL_r002_c017 (n_r002_c017 vdd wl002 wl002) nsel w=45n l=45n
RRAM_r002_c017 (n_r002_c017 bl017) resistor r=1meg
MSEL_r002_c018 (n_r002_c018 vdd wl002 wl002) nsel w=45n l=45n
RRAM_r002_c018 (n_r002_c018 bl018) resistor r=1meg
MSEL_r002_c019 (n_r002_c019 vdd wl002 wl002) nsel w=45n l=45n
RRAM_r002_c019 (n_r002_c019 bl019) resistor r=1meg
MSEL_r002_c020 (n_r002_c020 vdd wl002 wl002) nsel w=45n l=45n
RRAM_r002_c020 (n_r002_c020 bl020) resistor r=1meg
MSEL_r002_c021 (n_r002_c021 vdd wl002 wl002) nsel w=45n l=45n
RRAM_r002_c021 (n_r002_c021 bl021) resistor r=1meg
MSEL_r002_c022 (n_r002_c022 vdd wl002 wl002) nsel w=45n l=45n
RRAM_r002_c022 (n_r002_c022 bl022) resistor r=1k
MSEL_r002_c023 (n_r002_c023 vdd wl002 wl002) nsel w=45n l=45n
RRAM_r002_c023 (n_r002_c023 bl023) resistor r=1meg
MSEL_r002_c024 (n_r002_c024 vdd wl002 wl002) nsel w=45n l=45n
RRAM_r002_c024 (n_r002_c024 bl024) resistor r=1meg
MSEL_r002_c025 (n_r002_c025 vdd wl002 wl002) nsel w=45n l=45n
RRAM_r002_c025 (n_r002_c025 bl025) resistor r=1meg
MSEL_r002_c026 (n_r002_c026 vdd wl002 wl002) nsel w=45n l=45n
RRAM_r002_c026 (n_r002_c026 bl026) resistor r=1meg
MSEL_r002_c027 (n_r002_c027 vdd wl002 wl002) nsel w=45n l=45n
RRAM_r002_c027 (n_r002_c027 bl027) resistor r=1meg
MSEL_r002_c028 (n_r002_c028 vdd wl002 wl002) nsel w=45n l=45n
RRAM_r002_c028 (n_r002_c028 bl028) resistor r=1meg
MSEL_r002_c029 (n_r002_c029 vdd wl002 wl002) nsel w=45n l=45n
RRAM_r002_c029 (n_r002_c029 bl029) resistor r=1k
MSEL_r002_c030 (n_r002_c030 vdd wl002 wl002) nsel w=45n l=45n
RRAM_r002_c030 (n_r002_c030 bl030) resistor r=1meg
MSEL_r002_c031 (n_r002_c031 vdd wl002 wl002) nsel w=45n l=45n
RRAM_r002_c031 (n_r002_c031 bl031) resistor r=1k
MSEL_r003_c000 (n_r003_c000 vdd wl003 wl003) nsel w=45n l=45n
RRAM_r003_c000 (n_r003_c000 bl000) resistor r=1k
MSEL_r003_c001 (n_r003_c001 vdd wl003 wl003) nsel w=45n l=45n
RRAM_r003_c001 (n_r003_c001 bl001) resistor r=1meg
MSEL_r003_c002 (n_r003_c002 vdd wl003 wl003) nsel w=45n l=45n
RRAM_r003_c002 (n_r003_c002 bl002) resistor r=1meg
MSEL_r003_c003 (n_r003_c003 vdd wl003 wl003) nsel w=45n l=45n
RRAM_r003_c003 (n_r003_c003 bl003) resistor r=1k
MSEL_r003_c004 (n_r003_c004 vdd wl003 wl003) nsel w=45n l=45n
RRAM_r003_c004 (n_r003_c004 bl004) resistor r=1meg
MSEL_r003_c005 (n_r003_c005 vdd wl003 wl003) nsel w=45n l=45n
RRAM_r003_c005 (n_r003_c005 bl005) resistor r=1k
MSEL_r003_c006 (n_r003_c006 vdd wl003 wl003) nsel w=45n l=45n
RRAM_r003_c006 (n_r003_c006 bl006) resistor r=1meg
MSEL_r003_c007 (n_r003_c007 vdd wl003 wl003) nsel w=45n l=45n
RRAM_r003_c007 (n_r003_c007 bl007) resistor r=1meg
MSEL_r003_c008 (n_r003_c008 vdd wl003 wl003) nsel w=45n l=45n
RRAM_r003_c008 (n_r003_c008 bl008) resistor r=1meg
MSEL_r003_c009 (n_r003_c009 vdd wl003 wl003) nsel w=45n l=45n
RRAM_r003_c009 (n_r003_c009 bl009) resistor r=1k
MSEL_r003_c010 (n_r003_c010 vdd wl003 wl003) nsel w=45n l=45n
RRAM_r003_c010 (n_r003_c010 bl010) resistor r=1k
MSEL_r003_c011 (n_r003_c011 vdd wl003 wl003) nsel w=45n l=45n
RRAM_r003_c011 (n_r003_c011 bl011) resistor r=1k
MSEL_r003_c012 (n_r003_c012 vdd wl003 wl003) nsel w=45n l=45n
RRAM_r003_c012 (n_r003_c012 bl012) resistor r=1k
MSEL_r003_c013 (n_r003_c013 vdd wl003 wl003) nsel w=45n l=45n
RRAM_r003_c013 (n_r003_c013 bl013) resistor r=1k
MSEL_r003_c014 (n_r003_c014 vdd wl003 wl003) nsel w=45n l=45n
RRAM_r003_c014 (n_r003_c014 bl014) resistor r=1meg
MSEL_r003_c015 (n_r003_c015 vdd wl003 wl003) nsel w=45n l=45n
RRAM_r003_c015 (n_r003_c015 bl015) resistor r=1meg
MSEL_r003_c016 (n_r003_c016 vdd wl003 wl003) nsel w=45n l=45n
RRAM_r003_c016 (n_r003_c016 bl016) resistor r=1k
MSEL_r003_c017 (n_r003_c017 vdd wl003 wl003) nsel w=45n l=45n
RRAM_r003_c017 (n_r003_c017 bl017) resistor r=1meg
MSEL_r003_c018 (n_r003_c018 vdd wl003 wl003) nsel w=45n l=45n
RRAM_r003_c018 (n_r003_c018 bl018) resistor r=1meg
MSEL_r003_c019 (n_r003_c019 vdd wl003 wl003) nsel w=45n l=45n
RRAM_r003_c019 (n_r003_c019 bl019) resistor r=1k
MSEL_r003_c020 (n_r003_c020 vdd wl003 wl003) nsel w=45n l=45n
RRAM_r003_c020 (n_r003_c020 bl020) resistor r=1k
MSEL_r003_c021 (n_r003_c021 vdd wl003 wl003) nsel w=45n l=45n
RRAM_r003_c021 (n_r003_c021 bl021) resistor r=1k
MSEL_r003_c022 (n_r003_c022 vdd wl003 wl003) nsel w=45n l=45n
RRAM_r003_c022 (n_r003_c022 bl022) resistor r=1k
MSEL_r003_c023 (n_r003_c023 vdd wl003 wl003) nsel w=45n l=45n
RRAM_r003_c023 (n_r003_c023 bl023) resistor r=1meg
MSEL_r003_c024 (n_r003_c024 vdd wl003 wl003) nsel w=45n l=45n
RRAM_r003_c024 (n_r003_c024 bl024) resistor r=1k
MSEL_r003_c025 (n_r003_c025 vdd wl003 wl003) nsel w=45n l=45n
RRAM_r003_c025 (n_r003_c025 bl025) resistor r=1meg
MSEL_r003_c026 (n_r003_c026 vdd wl003 wl003) nsel w=45n l=45n
RRAM_r003_c026 (n_r003_c026 bl026) resistor r=1meg
MSEL_r003_c027 (n_r003_c027 vdd wl003 wl003) nsel w=45n l=45n
RRAM_r003_c027 (n_r003_c027 bl027) resistor r=1meg
MSEL_r003_c028 (n_r003_c028 vdd wl003 wl003) nsel w=45n l=45n
RRAM_r003_c028 (n_r003_c028 bl028) resistor r=1meg
MSEL_r003_c029 (n_r003_c029 vdd wl003 wl003) nsel w=45n l=45n
RRAM_r003_c029 (n_r003_c029 bl029) resistor r=1meg
MSEL_r003_c030 (n_r003_c030 vdd wl003 wl003) nsel w=45n l=45n
RRAM_r003_c030 (n_r003_c030 bl030) resistor r=1meg
MSEL_r003_c031 (n_r003_c031 vdd wl003 wl003) nsel w=45n l=45n
RRAM_r003_c031 (n_r003_c031 bl031) resistor r=1k
MSEL_r004_c000 (n_r004_c000 vdd wl004 wl004) nsel w=45n l=45n
RRAM_r004_c000 (n_r004_c000 bl000) resistor r=1k
MSEL_r004_c001 (n_r004_c001 vdd wl004 wl004) nsel w=45n l=45n
RRAM_r004_c001 (n_r004_c001 bl001) resistor r=1k
MSEL_r004_c002 (n_r004_c002 vdd wl004 wl004) nsel w=45n l=45n
RRAM_r004_c002 (n_r004_c002 bl002) resistor r=1k
MSEL_r004_c003 (n_r004_c003 vdd wl004 wl004) nsel w=45n l=45n
RRAM_r004_c003 (n_r004_c003 bl003) resistor r=1meg
MSEL_r004_c004 (n_r004_c004 vdd wl004 wl004) nsel w=45n l=45n
RRAM_r004_c004 (n_r004_c004 bl004) resistor r=1meg
MSEL_r004_c005 (n_r004_c005 vdd wl004 wl004) nsel w=45n l=45n
RRAM_r004_c005 (n_r004_c005 bl005) resistor r=1meg
MSEL_r004_c006 (n_r004_c006 vdd wl004 wl004) nsel w=45n l=45n
RRAM_r004_c006 (n_r004_c006 bl006) resistor r=1meg
MSEL_r004_c007 (n_r004_c007 vdd wl004 wl004) nsel w=45n l=45n
RRAM_r004_c007 (n_r004_c007 bl007) resistor r=1k
MSEL_r004_c008 (n_r004_c008 vdd wl004 wl004) nsel w=45n l=45n
RRAM_r004_c008 (n_r004_c008 bl008) resistor r=1k
MSEL_r004_c009 (n_r004_c009 vdd wl004 wl004) nsel w=45n l=45n
RRAM_r004_c009 (n_r004_c009 bl009) resistor r=1meg
MSEL_r004_c010 (n_r004_c010 vdd wl004 wl004) nsel w=45n l=45n
RRAM_r004_c010 (n_r004_c010 bl010) resistor r=1k
MSEL_r004_c011 (n_r004_c011 vdd wl004 wl004) nsel w=45n l=45n
RRAM_r004_c011 (n_r004_c011 bl011) resistor r=1k
MSEL_r004_c012 (n_r004_c012 vdd wl004 wl004) nsel w=45n l=45n
RRAM_r004_c012 (n_r004_c012 bl012) resistor r=1meg
MSEL_r004_c013 (n_r004_c013 vdd wl004 wl004) nsel w=45n l=45n
RRAM_r004_c013 (n_r004_c013 bl013) resistor r=1k
MSEL_r004_c014 (n_r004_c014 vdd wl004 wl004) nsel w=45n l=45n
RRAM_r004_c014 (n_r004_c014 bl014) resistor r=1meg
MSEL_r004_c015 (n_r004_c015 vdd wl004 wl004) nsel w=45n l=45n
RRAM_r004_c015 (n_r004_c015 bl015) resistor r=1meg
MSEL_r004_c016 (n_r004_c016 vdd wl004 wl004) nsel w=45n l=45n
RRAM_r004_c016 (n_r004_c016 bl016) resistor r=1meg
MSEL_r004_c017 (n_r004_c017 vdd wl004 wl004) nsel w=45n l=45n
RRAM_r004_c017 (n_r004_c017 bl017) resistor r=1meg
MSEL_r004_c018 (n_r004_c018 vdd wl004 wl004) nsel w=45n l=45n
RRAM_r004_c018 (n_r004_c018 bl018) resistor r=1k
MSEL_r004_c019 (n_r004_c019 vdd wl004 wl004) nsel w=45n l=45n
RRAM_r004_c019 (n_r004_c019 bl019) resistor r=1k
MSEL_r004_c020 (n_r004_c020 vdd wl004 wl004) nsel w=45n l=45n
RRAM_r004_c020 (n_r004_c020 bl020) resistor r=1meg
MSEL_r004_c021 (n_r004_c021 vdd wl004 wl004) nsel w=45n l=45n
RRAM_r004_c021 (n_r004_c021 bl021) resistor r=1meg
MSEL_r004_c022 (n_r004_c022 vdd wl004 wl004) nsel w=45n l=45n
RRAM_r004_c022 (n_r004_c022 bl022) resistor r=1meg
MSEL_r004_c023 (n_r004_c023 vdd wl004 wl004) nsel w=45n l=45n
RRAM_r004_c023 (n_r004_c023 bl023) resistor r=1meg
MSEL_r004_c024 (n_r004_c024 vdd wl004 wl004) nsel w=45n l=45n
RRAM_r004_c024 (n_r004_c024 bl024) resistor r=1k
MSEL_r004_c025 (n_r004_c025 vdd wl004 wl004) nsel w=45n l=45n
RRAM_r004_c025 (n_r004_c025 bl025) resistor r=1meg
MSEL_r004_c026 (n_r004_c026 vdd wl004 wl004) nsel w=45n l=45n
RRAM_r004_c026 (n_r004_c026 bl026) resistor r=1k
MSEL_r004_c027 (n_r004_c027 vdd wl004 wl004) nsel w=45n l=45n
RRAM_r004_c027 (n_r004_c027 bl027) resistor r=1k
MSEL_r004_c028 (n_r004_c028 vdd wl004 wl004) nsel w=45n l=45n
RRAM_r004_c028 (n_r004_c028 bl028) resistor r=1k
MSEL_r004_c029 (n_r004_c029 vdd wl004 wl004) nsel w=45n l=45n
RRAM_r004_c029 (n_r004_c029 bl029) resistor r=1k
MSEL_r004_c030 (n_r004_c030 vdd wl004 wl004) nsel w=45n l=45n
RRAM_r004_c030 (n_r004_c030 bl030) resistor r=1k
MSEL_r004_c031 (n_r004_c031 vdd wl004 wl004) nsel w=45n l=45n
RRAM_r004_c031 (n_r004_c031 bl031) resistor r=1meg
MSEL_r005_c000 (n_r005_c000 vdd wl005 wl005) nsel w=45n l=45n
RRAM_r005_c000 (n_r005_c000 bl000) resistor r=1k
MSEL_r005_c001 (n_r005_c001 vdd wl005 wl005) nsel w=45n l=45n
RRAM_r005_c001 (n_r005_c001 bl001) resistor r=1k
MSEL_r005_c002 (n_r005_c002 vdd wl005 wl005) nsel w=45n l=45n
RRAM_r005_c002 (n_r005_c002 bl002) resistor r=1meg
MSEL_r005_c003 (n_r005_c003 vdd wl005 wl005) nsel w=45n l=45n
RRAM_r005_c003 (n_r005_c003 bl003) resistor r=1k
MSEL_r005_c004 (n_r005_c004 vdd wl005 wl005) nsel w=45n l=45n
RRAM_r005_c004 (n_r005_c004 bl004) resistor r=1meg
MSEL_r005_c005 (n_r005_c005 vdd wl005 wl005) nsel w=45n l=45n
RRAM_r005_c005 (n_r005_c005 bl005) resistor r=1meg
MSEL_r005_c006 (n_r005_c006 vdd wl005 wl005) nsel w=45n l=45n
RRAM_r005_c006 (n_r005_c006 bl006) resistor r=1k
MSEL_r005_c007 (n_r005_c007 vdd wl005 wl005) nsel w=45n l=45n
RRAM_r005_c007 (n_r005_c007 bl007) resistor r=1meg
MSEL_r005_c008 (n_r005_c008 vdd wl005 wl005) nsel w=45n l=45n
RRAM_r005_c008 (n_r005_c008 bl008) resistor r=1meg
MSEL_r005_c009 (n_r005_c009 vdd wl005 wl005) nsel w=45n l=45n
RRAM_r005_c009 (n_r005_c009 bl009) resistor r=1k
MSEL_r005_c010 (n_r005_c010 vdd wl005 wl005) nsel w=45n l=45n
RRAM_r005_c010 (n_r005_c010 bl010) resistor r=1k
MSEL_r005_c011 (n_r005_c011 vdd wl005 wl005) nsel w=45n l=45n
RRAM_r005_c011 (n_r005_c011 bl011) resistor r=1meg
MSEL_r005_c012 (n_r005_c012 vdd wl005 wl005) nsel w=45n l=45n
RRAM_r005_c012 (n_r005_c012 bl012) resistor r=1k
MSEL_r005_c013 (n_r005_c013 vdd wl005 wl005) nsel w=45n l=45n
RRAM_r005_c013 (n_r005_c013 bl013) resistor r=1meg
MSEL_r005_c014 (n_r005_c014 vdd wl005 wl005) nsel w=45n l=45n
RRAM_r005_c014 (n_r005_c014 bl014) resistor r=1k
MSEL_r005_c015 (n_r005_c015 vdd wl005 wl005) nsel w=45n l=45n
RRAM_r005_c015 (n_r005_c015 bl015) resistor r=1k
MSEL_r005_c016 (n_r005_c016 vdd wl005 wl005) nsel w=45n l=45n
RRAM_r005_c016 (n_r005_c016 bl016) resistor r=1meg
MSEL_r005_c017 (n_r005_c017 vdd wl005 wl005) nsel w=45n l=45n
RRAM_r005_c017 (n_r005_c017 bl017) resistor r=1k
MSEL_r005_c018 (n_r005_c018 vdd wl005 wl005) nsel w=45n l=45n
RRAM_r005_c018 (n_r005_c018 bl018) resistor r=1k
MSEL_r005_c019 (n_r005_c019 vdd wl005 wl005) nsel w=45n l=45n
RRAM_r005_c019 (n_r005_c019 bl019) resistor r=1k
MSEL_r005_c020 (n_r005_c020 vdd wl005 wl005) nsel w=45n l=45n
RRAM_r005_c020 (n_r005_c020 bl020) resistor r=1meg
MSEL_r005_c021 (n_r005_c021 vdd wl005 wl005) nsel w=45n l=45n
RRAM_r005_c021 (n_r005_c021 bl021) resistor r=1meg
MSEL_r005_c022 (n_r005_c022 vdd wl005 wl005) nsel w=45n l=45n
RRAM_r005_c022 (n_r005_c022 bl022) resistor r=1k
MSEL_r005_c023 (n_r005_c023 vdd wl005 wl005) nsel w=45n l=45n
RRAM_r005_c023 (n_r005_c023 bl023) resistor r=1k
MSEL_r005_c024 (n_r005_c024 vdd wl005 wl005) nsel w=45n l=45n
RRAM_r005_c024 (n_r005_c024 bl024) resistor r=1k
MSEL_r005_c025 (n_r005_c025 vdd wl005 wl005) nsel w=45n l=45n
RRAM_r005_c025 (n_r005_c025 bl025) resistor r=1k
MSEL_r005_c026 (n_r005_c026 vdd wl005 wl005) nsel w=45n l=45n
RRAM_r005_c026 (n_r005_c026 bl026) resistor r=1k
MSEL_r005_c027 (n_r005_c027 vdd wl005 wl005) nsel w=45n l=45n
RRAM_r005_c027 (n_r005_c027 bl027) resistor r=1k
MSEL_r005_c028 (n_r005_c028 vdd wl005 wl005) nsel w=45n l=45n
RRAM_r005_c028 (n_r005_c028 bl028) resistor r=1meg
MSEL_r005_c029 (n_r005_c029 vdd wl005 wl005) nsel w=45n l=45n
RRAM_r005_c029 (n_r005_c029 bl029) resistor r=1k
MSEL_r005_c030 (n_r005_c030 vdd wl005 wl005) nsel w=45n l=45n
RRAM_r005_c030 (n_r005_c030 bl030) resistor r=1k
MSEL_r005_c031 (n_r005_c031 vdd wl005 wl005) nsel w=45n l=45n
RRAM_r005_c031 (n_r005_c031 bl031) resistor r=1meg
MSEL_r006_c000 (n_r006_c000 vdd wl006 wl006) nsel w=45n l=45n
RRAM_r006_c000 (n_r006_c000 bl000) resistor r=1k
MSEL_r006_c001 (n_r006_c001 vdd wl006 wl006) nsel w=45n l=45n
RRAM_r006_c001 (n_r006_c001 bl001) resistor r=1meg
MSEL_r006_c002 (n_r006_c002 vdd wl006 wl006) nsel w=45n l=45n
RRAM_r006_c002 (n_r006_c002 bl002) resistor r=1meg
MSEL_r006_c003 (n_r006_c003 vdd wl006 wl006) nsel w=45n l=45n
RRAM_r006_c003 (n_r006_c003 bl003) resistor r=1meg
MSEL_r006_c004 (n_r006_c004 vdd wl006 wl006) nsel w=45n l=45n
RRAM_r006_c004 (n_r006_c004 bl004) resistor r=1meg
MSEL_r006_c005 (n_r006_c005 vdd wl006 wl006) nsel w=45n l=45n
RRAM_r006_c005 (n_r006_c005 bl005) resistor r=1meg
MSEL_r006_c006 (n_r006_c006 vdd wl006 wl006) nsel w=45n l=45n
RRAM_r006_c006 (n_r006_c006 bl006) resistor r=1k
MSEL_r006_c007 (n_r006_c007 vdd wl006 wl006) nsel w=45n l=45n
RRAM_r006_c007 (n_r006_c007 bl007) resistor r=1meg
MSEL_r006_c008 (n_r006_c008 vdd wl006 wl006) nsel w=45n l=45n
RRAM_r006_c008 (n_r006_c008 bl008) resistor r=1meg
MSEL_r006_c009 (n_r006_c009 vdd wl006 wl006) nsel w=45n l=45n
RRAM_r006_c009 (n_r006_c009 bl009) resistor r=1meg
MSEL_r006_c010 (n_r006_c010 vdd wl006 wl006) nsel w=45n l=45n
RRAM_r006_c010 (n_r006_c010 bl010) resistor r=1meg
MSEL_r006_c011 (n_r006_c011 vdd wl006 wl006) nsel w=45n l=45n
RRAM_r006_c011 (n_r006_c011 bl011) resistor r=1k
MSEL_r006_c012 (n_r006_c012 vdd wl006 wl006) nsel w=45n l=45n
RRAM_r006_c012 (n_r006_c012 bl012) resistor r=1meg
MSEL_r006_c013 (n_r006_c013 vdd wl006 wl006) nsel w=45n l=45n
RRAM_r006_c013 (n_r006_c013 bl013) resistor r=1meg
MSEL_r006_c014 (n_r006_c014 vdd wl006 wl006) nsel w=45n l=45n
RRAM_r006_c014 (n_r006_c014 bl014) resistor r=1k
MSEL_r006_c015 (n_r006_c015 vdd wl006 wl006) nsel w=45n l=45n
RRAM_r006_c015 (n_r006_c015 bl015) resistor r=1meg
MSEL_r006_c016 (n_r006_c016 vdd wl006 wl006) nsel w=45n l=45n
RRAM_r006_c016 (n_r006_c016 bl016) resistor r=1meg
MSEL_r006_c017 (n_r006_c017 vdd wl006 wl006) nsel w=45n l=45n
RRAM_r006_c017 (n_r006_c017 bl017) resistor r=1k
MSEL_r006_c018 (n_r006_c018 vdd wl006 wl006) nsel w=45n l=45n
RRAM_r006_c018 (n_r006_c018 bl018) resistor r=1k
MSEL_r006_c019 (n_r006_c019 vdd wl006 wl006) nsel w=45n l=45n
RRAM_r006_c019 (n_r006_c019 bl019) resistor r=1meg
MSEL_r006_c020 (n_r006_c020 vdd wl006 wl006) nsel w=45n l=45n
RRAM_r006_c020 (n_r006_c020 bl020) resistor r=1k
MSEL_r006_c021 (n_r006_c021 vdd wl006 wl006) nsel w=45n l=45n
RRAM_r006_c021 (n_r006_c021 bl021) resistor r=1meg
MSEL_r006_c022 (n_r006_c022 vdd wl006 wl006) nsel w=45n l=45n
RRAM_r006_c022 (n_r006_c022 bl022) resistor r=1meg
MSEL_r006_c023 (n_r006_c023 vdd wl006 wl006) nsel w=45n l=45n
RRAM_r006_c023 (n_r006_c023 bl023) resistor r=1meg
MSEL_r006_c024 (n_r006_c024 vdd wl006 wl006) nsel w=45n l=45n
RRAM_r006_c024 (n_r006_c024 bl024) resistor r=1meg
MSEL_r006_c025 (n_r006_c025 vdd wl006 wl006) nsel w=45n l=45n
RRAM_r006_c025 (n_r006_c025 bl025) resistor r=1meg
MSEL_r006_c026 (n_r006_c026 vdd wl006 wl006) nsel w=45n l=45n
RRAM_r006_c026 (n_r006_c026 bl026) resistor r=1k
MSEL_r006_c027 (n_r006_c027 vdd wl006 wl006) nsel w=45n l=45n
RRAM_r006_c027 (n_r006_c027 bl027) resistor r=1meg
MSEL_r006_c028 (n_r006_c028 vdd wl006 wl006) nsel w=45n l=45n
RRAM_r006_c028 (n_r006_c028 bl028) resistor r=1meg
MSEL_r006_c029 (n_r006_c029 vdd wl006 wl006) nsel w=45n l=45n
RRAM_r006_c029 (n_r006_c029 bl029) resistor r=1k
MSEL_r006_c030 (n_r006_c030 vdd wl006 wl006) nsel w=45n l=45n
RRAM_r006_c030 (n_r006_c030 bl030) resistor r=1k
MSEL_r006_c031 (n_r006_c031 vdd wl006 wl006) nsel w=45n l=45n
RRAM_r006_c031 (n_r006_c031 bl031) resistor r=1k
MSEL_r007_c000 (n_r007_c000 vdd wl007 wl007) nsel w=45n l=45n
RRAM_r007_c000 (n_r007_c000 bl000) resistor r=1meg
MSEL_r007_c001 (n_r007_c001 vdd wl007 wl007) nsel w=45n l=45n
RRAM_r007_c001 (n_r007_c001 bl001) resistor r=1meg
MSEL_r007_c002 (n_r007_c002 vdd wl007 wl007) nsel w=45n l=45n
RRAM_r007_c002 (n_r007_c002 bl002) resistor r=1meg
MSEL_r007_c003 (n_r007_c003 vdd wl007 wl007) nsel w=45n l=45n
RRAM_r007_c003 (n_r007_c003 bl003) resistor r=1meg
MSEL_r007_c004 (n_r007_c004 vdd wl007 wl007) nsel w=45n l=45n
RRAM_r007_c004 (n_r007_c004 bl004) resistor r=1meg
MSEL_r007_c005 (n_r007_c005 vdd wl007 wl007) nsel w=45n l=45n
RRAM_r007_c005 (n_r007_c005 bl005) resistor r=1k
MSEL_r007_c006 (n_r007_c006 vdd wl007 wl007) nsel w=45n l=45n
RRAM_r007_c006 (n_r007_c006 bl006) resistor r=1meg
MSEL_r007_c007 (n_r007_c007 vdd wl007 wl007) nsel w=45n l=45n
RRAM_r007_c007 (n_r007_c007 bl007) resistor r=1meg
MSEL_r007_c008 (n_r007_c008 vdd wl007 wl007) nsel w=45n l=45n
RRAM_r007_c008 (n_r007_c008 bl008) resistor r=1meg
MSEL_r007_c009 (n_r007_c009 vdd wl007 wl007) nsel w=45n l=45n
RRAM_r007_c009 (n_r007_c009 bl009) resistor r=1k
MSEL_r007_c010 (n_r007_c010 vdd wl007 wl007) nsel w=45n l=45n
RRAM_r007_c010 (n_r007_c010 bl010) resistor r=1k
MSEL_r007_c011 (n_r007_c011 vdd wl007 wl007) nsel w=45n l=45n
RRAM_r007_c011 (n_r007_c011 bl011) resistor r=1k
MSEL_r007_c012 (n_r007_c012 vdd wl007 wl007) nsel w=45n l=45n
RRAM_r007_c012 (n_r007_c012 bl012) resistor r=1meg
MSEL_r007_c013 (n_r007_c013 vdd wl007 wl007) nsel w=45n l=45n
RRAM_r007_c013 (n_r007_c013 bl013) resistor r=1k
MSEL_r007_c014 (n_r007_c014 vdd wl007 wl007) nsel w=45n l=45n
RRAM_r007_c014 (n_r007_c014 bl014) resistor r=1meg
MSEL_r007_c015 (n_r007_c015 vdd wl007 wl007) nsel w=45n l=45n
RRAM_r007_c015 (n_r007_c015 bl015) resistor r=1meg
MSEL_r007_c016 (n_r007_c016 vdd wl007 wl007) nsel w=45n l=45n
RRAM_r007_c016 (n_r007_c016 bl016) resistor r=1meg
MSEL_r007_c017 (n_r007_c017 vdd wl007 wl007) nsel w=45n l=45n
RRAM_r007_c017 (n_r007_c017 bl017) resistor r=1k
MSEL_r007_c018 (n_r007_c018 vdd wl007 wl007) nsel w=45n l=45n
RRAM_r007_c018 (n_r007_c018 bl018) resistor r=1meg
MSEL_r007_c019 (n_r007_c019 vdd wl007 wl007) nsel w=45n l=45n
RRAM_r007_c019 (n_r007_c019 bl019) resistor r=1meg
MSEL_r007_c020 (n_r007_c020 vdd wl007 wl007) nsel w=45n l=45n
RRAM_r007_c020 (n_r007_c020 bl020) resistor r=1meg
MSEL_r007_c021 (n_r007_c021 vdd wl007 wl007) nsel w=45n l=45n
RRAM_r007_c021 (n_r007_c021 bl021) resistor r=1k
MSEL_r007_c022 (n_r007_c022 vdd wl007 wl007) nsel w=45n l=45n
RRAM_r007_c022 (n_r007_c022 bl022) resistor r=1meg
MSEL_r007_c023 (n_r007_c023 vdd wl007 wl007) nsel w=45n l=45n
RRAM_r007_c023 (n_r007_c023 bl023) resistor r=1meg
MSEL_r007_c024 (n_r007_c024 vdd wl007 wl007) nsel w=45n l=45n
RRAM_r007_c024 (n_r007_c024 bl024) resistor r=1k
MSEL_r007_c025 (n_r007_c025 vdd wl007 wl007) nsel w=45n l=45n
RRAM_r007_c025 (n_r007_c025 bl025) resistor r=1k
MSEL_r007_c026 (n_r007_c026 vdd wl007 wl007) nsel w=45n l=45n
RRAM_r007_c026 (n_r007_c026 bl026) resistor r=1k
MSEL_r007_c027 (n_r007_c027 vdd wl007 wl007) nsel w=45n l=45n
RRAM_r007_c027 (n_r007_c027 bl027) resistor r=1meg
MSEL_r007_c028 (n_r007_c028 vdd wl007 wl007) nsel w=45n l=45n
RRAM_r007_c028 (n_r007_c028 bl028) resistor r=1k
MSEL_r007_c029 (n_r007_c029 vdd wl007 wl007) nsel w=45n l=45n
RRAM_r007_c029 (n_r007_c029 bl029) resistor r=1meg
MSEL_r007_c030 (n_r007_c030 vdd wl007 wl007) nsel w=45n l=45n
RRAM_r007_c030 (n_r007_c030 bl030) resistor r=1meg
MSEL_r007_c031 (n_r007_c031 vdd wl007 wl007) nsel w=45n l=45n
RRAM_r007_c031 (n_r007_c031 bl031) resistor r=1meg
MSEL_r008_c000 (n_r008_c000 vdd wl008 wl008) nsel w=45n l=45n
RRAM_r008_c000 (n_r008_c000 bl000) resistor r=1meg
MSEL_r008_c001 (n_r008_c001 vdd wl008 wl008) nsel w=45n l=45n
RRAM_r008_c001 (n_r008_c001 bl001) resistor r=1k
MSEL_r008_c002 (n_r008_c002 vdd wl008 wl008) nsel w=45n l=45n
RRAM_r008_c002 (n_r008_c002 bl002) resistor r=1k
MSEL_r008_c003 (n_r008_c003 vdd wl008 wl008) nsel w=45n l=45n
RRAM_r008_c003 (n_r008_c003 bl003) resistor r=1meg
MSEL_r008_c004 (n_r008_c004 vdd wl008 wl008) nsel w=45n l=45n
RRAM_r008_c004 (n_r008_c004 bl004) resistor r=1k
MSEL_r008_c005 (n_r008_c005 vdd wl008 wl008) nsel w=45n l=45n
RRAM_r008_c005 (n_r008_c005 bl005) resistor r=1k
MSEL_r008_c006 (n_r008_c006 vdd wl008 wl008) nsel w=45n l=45n
RRAM_r008_c006 (n_r008_c006 bl006) resistor r=1k
MSEL_r008_c007 (n_r008_c007 vdd wl008 wl008) nsel w=45n l=45n
RRAM_r008_c007 (n_r008_c007 bl007) resistor r=1meg
MSEL_r008_c008 (n_r008_c008 vdd wl008 wl008) nsel w=45n l=45n
RRAM_r008_c008 (n_r008_c008 bl008) resistor r=1meg
MSEL_r008_c009 (n_r008_c009 vdd wl008 wl008) nsel w=45n l=45n
RRAM_r008_c009 (n_r008_c009 bl009) resistor r=1k
MSEL_r008_c010 (n_r008_c010 vdd wl008 wl008) nsel w=45n l=45n
RRAM_r008_c010 (n_r008_c010 bl010) resistor r=1meg
MSEL_r008_c011 (n_r008_c011 vdd wl008 wl008) nsel w=45n l=45n
RRAM_r008_c011 (n_r008_c011 bl011) resistor r=1k
MSEL_r008_c012 (n_r008_c012 vdd wl008 wl008) nsel w=45n l=45n
RRAM_r008_c012 (n_r008_c012 bl012) resistor r=1meg
MSEL_r008_c013 (n_r008_c013 vdd wl008 wl008) nsel w=45n l=45n
RRAM_r008_c013 (n_r008_c013 bl013) resistor r=1k
MSEL_r008_c014 (n_r008_c014 vdd wl008 wl008) nsel w=45n l=45n
RRAM_r008_c014 (n_r008_c014 bl014) resistor r=1k
MSEL_r008_c015 (n_r008_c015 vdd wl008 wl008) nsel w=45n l=45n
RRAM_r008_c015 (n_r008_c015 bl015) resistor r=1k
MSEL_r008_c016 (n_r008_c016 vdd wl008 wl008) nsel w=45n l=45n
RRAM_r008_c016 (n_r008_c016 bl016) resistor r=1k
MSEL_r008_c017 (n_r008_c017 vdd wl008 wl008) nsel w=45n l=45n
RRAM_r008_c017 (n_r008_c017 bl017) resistor r=1k
MSEL_r008_c018 (n_r008_c018 vdd wl008 wl008) nsel w=45n l=45n
RRAM_r008_c018 (n_r008_c018 bl018) resistor r=1k
MSEL_r008_c019 (n_r008_c019 vdd wl008 wl008) nsel w=45n l=45n
RRAM_r008_c019 (n_r008_c019 bl019) resistor r=1k
MSEL_r008_c020 (n_r008_c020 vdd wl008 wl008) nsel w=45n l=45n
RRAM_r008_c020 (n_r008_c020 bl020) resistor r=1meg
MSEL_r008_c021 (n_r008_c021 vdd wl008 wl008) nsel w=45n l=45n
RRAM_r008_c021 (n_r008_c021 bl021) resistor r=1meg
MSEL_r008_c022 (n_r008_c022 vdd wl008 wl008) nsel w=45n l=45n
RRAM_r008_c022 (n_r008_c022 bl022) resistor r=1meg
MSEL_r008_c023 (n_r008_c023 vdd wl008 wl008) nsel w=45n l=45n
RRAM_r008_c023 (n_r008_c023 bl023) resistor r=1meg
MSEL_r008_c024 (n_r008_c024 vdd wl008 wl008) nsel w=45n l=45n
RRAM_r008_c024 (n_r008_c024 bl024) resistor r=1k
MSEL_r008_c025 (n_r008_c025 vdd wl008 wl008) nsel w=45n l=45n
RRAM_r008_c025 (n_r008_c025 bl025) resistor r=1k
MSEL_r008_c026 (n_r008_c026 vdd wl008 wl008) nsel w=45n l=45n
RRAM_r008_c026 (n_r008_c026 bl026) resistor r=1k
MSEL_r008_c027 (n_r008_c027 vdd wl008 wl008) nsel w=45n l=45n
RRAM_r008_c027 (n_r008_c027 bl027) resistor r=1k
MSEL_r008_c028 (n_r008_c028 vdd wl008 wl008) nsel w=45n l=45n
RRAM_r008_c028 (n_r008_c028 bl028) resistor r=1meg
MSEL_r008_c029 (n_r008_c029 vdd wl008 wl008) nsel w=45n l=45n
RRAM_r008_c029 (n_r008_c029 bl029) resistor r=1k
MSEL_r008_c030 (n_r008_c030 vdd wl008 wl008) nsel w=45n l=45n
RRAM_r008_c030 (n_r008_c030 bl030) resistor r=1meg
MSEL_r008_c031 (n_r008_c031 vdd wl008 wl008) nsel w=45n l=45n
RRAM_r008_c031 (n_r008_c031 bl031) resistor r=1meg
MSEL_r009_c000 (n_r009_c000 vdd wl009 wl009) nsel w=45n l=45n
RRAM_r009_c000 (n_r009_c000 bl000) resistor r=1k
MSEL_r009_c001 (n_r009_c001 vdd wl009 wl009) nsel w=45n l=45n
RRAM_r009_c001 (n_r009_c001 bl001) resistor r=1meg
MSEL_r009_c002 (n_r009_c002 vdd wl009 wl009) nsel w=45n l=45n
RRAM_r009_c002 (n_r009_c002 bl002) resistor r=1k
MSEL_r009_c003 (n_r009_c003 vdd wl009 wl009) nsel w=45n l=45n
RRAM_r009_c003 (n_r009_c003 bl003) resistor r=1k
MSEL_r009_c004 (n_r009_c004 vdd wl009 wl009) nsel w=45n l=45n
RRAM_r009_c004 (n_r009_c004 bl004) resistor r=1k
MSEL_r009_c005 (n_r009_c005 vdd wl009 wl009) nsel w=45n l=45n
RRAM_r009_c005 (n_r009_c005 bl005) resistor r=1meg
MSEL_r009_c006 (n_r009_c006 vdd wl009 wl009) nsel w=45n l=45n
RRAM_r009_c006 (n_r009_c006 bl006) resistor r=1meg
MSEL_r009_c007 (n_r009_c007 vdd wl009 wl009) nsel w=45n l=45n
RRAM_r009_c007 (n_r009_c007 bl007) resistor r=1meg
MSEL_r009_c008 (n_r009_c008 vdd wl009 wl009) nsel w=45n l=45n
RRAM_r009_c008 (n_r009_c008 bl008) resistor r=1meg
MSEL_r009_c009 (n_r009_c009 vdd wl009 wl009) nsel w=45n l=45n
RRAM_r009_c009 (n_r009_c009 bl009) resistor r=1k
MSEL_r009_c010 (n_r009_c010 vdd wl009 wl009) nsel w=45n l=45n
RRAM_r009_c010 (n_r009_c010 bl010) resistor r=1k
MSEL_r009_c011 (n_r009_c011 vdd wl009 wl009) nsel w=45n l=45n
RRAM_r009_c011 (n_r009_c011 bl011) resistor r=1meg
MSEL_r009_c012 (n_r009_c012 vdd wl009 wl009) nsel w=45n l=45n
RRAM_r009_c012 (n_r009_c012 bl012) resistor r=1meg
MSEL_r009_c013 (n_r009_c013 vdd wl009 wl009) nsel w=45n l=45n
RRAM_r009_c013 (n_r009_c013 bl013) resistor r=1k
MSEL_r009_c014 (n_r009_c014 vdd wl009 wl009) nsel w=45n l=45n
RRAM_r009_c014 (n_r009_c014 bl014) resistor r=1meg
MSEL_r009_c015 (n_r009_c015 vdd wl009 wl009) nsel w=45n l=45n
RRAM_r009_c015 (n_r009_c015 bl015) resistor r=1k
MSEL_r009_c016 (n_r009_c016 vdd wl009 wl009) nsel w=45n l=45n
RRAM_r009_c016 (n_r009_c016 bl016) resistor r=1meg
MSEL_r009_c017 (n_r009_c017 vdd wl009 wl009) nsel w=45n l=45n
RRAM_r009_c017 (n_r009_c017 bl017) resistor r=1k
MSEL_r009_c018 (n_r009_c018 vdd wl009 wl009) nsel w=45n l=45n
RRAM_r009_c018 (n_r009_c018 bl018) resistor r=1meg
MSEL_r009_c019 (n_r009_c019 vdd wl009 wl009) nsel w=45n l=45n
RRAM_r009_c019 (n_r009_c019 bl019) resistor r=1k
MSEL_r009_c020 (n_r009_c020 vdd wl009 wl009) nsel w=45n l=45n
RRAM_r009_c020 (n_r009_c020 bl020) resistor r=1k
MSEL_r009_c021 (n_r009_c021 vdd wl009 wl009) nsel w=45n l=45n
RRAM_r009_c021 (n_r009_c021 bl021) resistor r=1meg
MSEL_r009_c022 (n_r009_c022 vdd wl009 wl009) nsel w=45n l=45n
RRAM_r009_c022 (n_r009_c022 bl022) resistor r=1k
MSEL_r009_c023 (n_r009_c023 vdd wl009 wl009) nsel w=45n l=45n
RRAM_r009_c023 (n_r009_c023 bl023) resistor r=1meg
MSEL_r009_c024 (n_r009_c024 vdd wl009 wl009) nsel w=45n l=45n
RRAM_r009_c024 (n_r009_c024 bl024) resistor r=1k
MSEL_r009_c025 (n_r009_c025 vdd wl009 wl009) nsel w=45n l=45n
RRAM_r009_c025 (n_r009_c025 bl025) resistor r=1meg
MSEL_r009_c026 (n_r009_c026 vdd wl009 wl009) nsel w=45n l=45n
RRAM_r009_c026 (n_r009_c026 bl026) resistor r=1meg
MSEL_r009_c027 (n_r009_c027 vdd wl009 wl009) nsel w=45n l=45n
RRAM_r009_c027 (n_r009_c027 bl027) resistor r=1k
MSEL_r009_c028 (n_r009_c028 vdd wl009 wl009) nsel w=45n l=45n
RRAM_r009_c028 (n_r009_c028 bl028) resistor r=1meg
MSEL_r009_c029 (n_r009_c029 vdd wl009 wl009) nsel w=45n l=45n
RRAM_r009_c029 (n_r009_c029 bl029) resistor r=1meg
MSEL_r009_c030 (n_r009_c030 vdd wl009 wl009) nsel w=45n l=45n
RRAM_r009_c030 (n_r009_c030 bl030) resistor r=1k
MSEL_r009_c031 (n_r009_c031 vdd wl009 wl009) nsel w=45n l=45n
RRAM_r009_c031 (n_r009_c031 bl031) resistor r=1meg
MSEL_r010_c000 (n_r010_c000 vdd wl010 wl010) nsel w=45n l=45n
RRAM_r010_c000 (n_r010_c000 bl000) resistor r=1k
MSEL_r010_c001 (n_r010_c001 vdd wl010 wl010) nsel w=45n l=45n
RRAM_r010_c001 (n_r010_c001 bl001) resistor r=1k
MSEL_r010_c002 (n_r010_c002 vdd wl010 wl010) nsel w=45n l=45n
RRAM_r010_c002 (n_r010_c002 bl002) resistor r=1k
MSEL_r010_c003 (n_r010_c003 vdd wl010 wl010) nsel w=45n l=45n
RRAM_r010_c003 (n_r010_c003 bl003) resistor r=1k
MSEL_r010_c004 (n_r010_c004 vdd wl010 wl010) nsel w=45n l=45n
RRAM_r010_c004 (n_r010_c004 bl004) resistor r=1k
MSEL_r010_c005 (n_r010_c005 vdd wl010 wl010) nsel w=45n l=45n
RRAM_r010_c005 (n_r010_c005 bl005) resistor r=1meg
MSEL_r010_c006 (n_r010_c006 vdd wl010 wl010) nsel w=45n l=45n
RRAM_r010_c006 (n_r010_c006 bl006) resistor r=1k
MSEL_r010_c007 (n_r010_c007 vdd wl010 wl010) nsel w=45n l=45n
RRAM_r010_c007 (n_r010_c007 bl007) resistor r=1meg
MSEL_r010_c008 (n_r010_c008 vdd wl010 wl010) nsel w=45n l=45n
RRAM_r010_c008 (n_r010_c008 bl008) resistor r=1k
MSEL_r010_c009 (n_r010_c009 vdd wl010 wl010) nsel w=45n l=45n
RRAM_r010_c009 (n_r010_c009 bl009) resistor r=1meg
MSEL_r010_c010 (n_r010_c010 vdd wl010 wl010) nsel w=45n l=45n
RRAM_r010_c010 (n_r010_c010 bl010) resistor r=1k
MSEL_r010_c011 (n_r010_c011 vdd wl010 wl010) nsel w=45n l=45n
RRAM_r010_c011 (n_r010_c011 bl011) resistor r=1meg
MSEL_r010_c012 (n_r010_c012 vdd wl010 wl010) nsel w=45n l=45n
RRAM_r010_c012 (n_r010_c012 bl012) resistor r=1meg
MSEL_r010_c013 (n_r010_c013 vdd wl010 wl010) nsel w=45n l=45n
RRAM_r010_c013 (n_r010_c013 bl013) resistor r=1meg
MSEL_r010_c014 (n_r010_c014 vdd wl010 wl010) nsel w=45n l=45n
RRAM_r010_c014 (n_r010_c014 bl014) resistor r=1k
MSEL_r010_c015 (n_r010_c015 vdd wl010 wl010) nsel w=45n l=45n
RRAM_r010_c015 (n_r010_c015 bl015) resistor r=1meg
MSEL_r010_c016 (n_r010_c016 vdd wl010 wl010) nsel w=45n l=45n
RRAM_r010_c016 (n_r010_c016 bl016) resistor r=1meg
MSEL_r010_c017 (n_r010_c017 vdd wl010 wl010) nsel w=45n l=45n
RRAM_r010_c017 (n_r010_c017 bl017) resistor r=1k
MSEL_r010_c018 (n_r010_c018 vdd wl010 wl010) nsel w=45n l=45n
RRAM_r010_c018 (n_r010_c018 bl018) resistor r=1meg
MSEL_r010_c019 (n_r010_c019 vdd wl010 wl010) nsel w=45n l=45n
RRAM_r010_c019 (n_r010_c019 bl019) resistor r=1meg
MSEL_r010_c020 (n_r010_c020 vdd wl010 wl010) nsel w=45n l=45n
RRAM_r010_c020 (n_r010_c020 bl020) resistor r=1meg
MSEL_r010_c021 (n_r010_c021 vdd wl010 wl010) nsel w=45n l=45n
RRAM_r010_c021 (n_r010_c021 bl021) resistor r=1k
MSEL_r010_c022 (n_r010_c022 vdd wl010 wl010) nsel w=45n l=45n
RRAM_r010_c022 (n_r010_c022 bl022) resistor r=1meg
MSEL_r010_c023 (n_r010_c023 vdd wl010 wl010) nsel w=45n l=45n
RRAM_r010_c023 (n_r010_c023 bl023) resistor r=1k
MSEL_r010_c024 (n_r010_c024 vdd wl010 wl010) nsel w=45n l=45n
RRAM_r010_c024 (n_r010_c024 bl024) resistor r=1meg
MSEL_r010_c025 (n_r010_c025 vdd wl010 wl010) nsel w=45n l=45n
RRAM_r010_c025 (n_r010_c025 bl025) resistor r=1meg
MSEL_r010_c026 (n_r010_c026 vdd wl010 wl010) nsel w=45n l=45n
RRAM_r010_c026 (n_r010_c026 bl026) resistor r=1meg
MSEL_r010_c027 (n_r010_c027 vdd wl010 wl010) nsel w=45n l=45n
RRAM_r010_c027 (n_r010_c027 bl027) resistor r=1k
MSEL_r010_c028 (n_r010_c028 vdd wl010 wl010) nsel w=45n l=45n
RRAM_r010_c028 (n_r010_c028 bl028) resistor r=1k
MSEL_r010_c029 (n_r010_c029 vdd wl010 wl010) nsel w=45n l=45n
RRAM_r010_c029 (n_r010_c029 bl029) resistor r=1meg
MSEL_r010_c030 (n_r010_c030 vdd wl010 wl010) nsel w=45n l=45n
RRAM_r010_c030 (n_r010_c030 bl030) resistor r=1k
MSEL_r010_c031 (n_r010_c031 vdd wl010 wl010) nsel w=45n l=45n
RRAM_r010_c031 (n_r010_c031 bl031) resistor r=1k
MSEL_r011_c000 (n_r011_c000 vdd wl011 wl011) nsel w=45n l=45n
RRAM_r011_c000 (n_r011_c000 bl000) resistor r=1meg
MSEL_r011_c001 (n_r011_c001 vdd wl011 wl011) nsel w=45n l=45n
RRAM_r011_c001 (n_r011_c001 bl001) resistor r=1meg
MSEL_r011_c002 (n_r011_c002 vdd wl011 wl011) nsel w=45n l=45n
RRAM_r011_c002 (n_r011_c002 bl002) resistor r=1k
MSEL_r011_c003 (n_r011_c003 vdd wl011 wl011) nsel w=45n l=45n
RRAM_r011_c003 (n_r011_c003 bl003) resistor r=1k
MSEL_r011_c004 (n_r011_c004 vdd wl011 wl011) nsel w=45n l=45n
RRAM_r011_c004 (n_r011_c004 bl004) resistor r=1k
MSEL_r011_c005 (n_r011_c005 vdd wl011 wl011) nsel w=45n l=45n
RRAM_r011_c005 (n_r011_c005 bl005) resistor r=1k
MSEL_r011_c006 (n_r011_c006 vdd wl011 wl011) nsel w=45n l=45n
RRAM_r011_c006 (n_r011_c006 bl006) resistor r=1meg
MSEL_r011_c007 (n_r011_c007 vdd wl011 wl011) nsel w=45n l=45n
RRAM_r011_c007 (n_r011_c007 bl007) resistor r=1meg
MSEL_r011_c008 (n_r011_c008 vdd wl011 wl011) nsel w=45n l=45n
RRAM_r011_c008 (n_r011_c008 bl008) resistor r=1k
MSEL_r011_c009 (n_r011_c009 vdd wl011 wl011) nsel w=45n l=45n
RRAM_r011_c009 (n_r011_c009 bl009) resistor r=1k
MSEL_r011_c010 (n_r011_c010 vdd wl011 wl011) nsel w=45n l=45n
RRAM_r011_c010 (n_r011_c010 bl010) resistor r=1k
MSEL_r011_c011 (n_r011_c011 vdd wl011 wl011) nsel w=45n l=45n
RRAM_r011_c011 (n_r011_c011 bl011) resistor r=1meg
MSEL_r011_c012 (n_r011_c012 vdd wl011 wl011) nsel w=45n l=45n
RRAM_r011_c012 (n_r011_c012 bl012) resistor r=1meg
MSEL_r011_c013 (n_r011_c013 vdd wl011 wl011) nsel w=45n l=45n
RRAM_r011_c013 (n_r011_c013 bl013) resistor r=1meg
MSEL_r011_c014 (n_r011_c014 vdd wl011 wl011) nsel w=45n l=45n
RRAM_r011_c014 (n_r011_c014 bl014) resistor r=1k
MSEL_r011_c015 (n_r011_c015 vdd wl011 wl011) nsel w=45n l=45n
RRAM_r011_c015 (n_r011_c015 bl015) resistor r=1k
MSEL_r011_c016 (n_r011_c016 vdd wl011 wl011) nsel w=45n l=45n
RRAM_r011_c016 (n_r011_c016 bl016) resistor r=1k
MSEL_r011_c017 (n_r011_c017 vdd wl011 wl011) nsel w=45n l=45n
RRAM_r011_c017 (n_r011_c017 bl017) resistor r=1k
MSEL_r011_c018 (n_r011_c018 vdd wl011 wl011) nsel w=45n l=45n
RRAM_r011_c018 (n_r011_c018 bl018) resistor r=1k
MSEL_r011_c019 (n_r011_c019 vdd wl011 wl011) nsel w=45n l=45n
RRAM_r011_c019 (n_r011_c019 bl019) resistor r=1meg
MSEL_r011_c020 (n_r011_c020 vdd wl011 wl011) nsel w=45n l=45n
RRAM_r011_c020 (n_r011_c020 bl020) resistor r=1meg
MSEL_r011_c021 (n_r011_c021 vdd wl011 wl011) nsel w=45n l=45n
RRAM_r011_c021 (n_r011_c021 bl021) resistor r=1meg
MSEL_r011_c022 (n_r011_c022 vdd wl011 wl011) nsel w=45n l=45n
RRAM_r011_c022 (n_r011_c022 bl022) resistor r=1meg
MSEL_r011_c023 (n_r011_c023 vdd wl011 wl011) nsel w=45n l=45n
RRAM_r011_c023 (n_r011_c023 bl023) resistor r=1meg
MSEL_r011_c024 (n_r011_c024 vdd wl011 wl011) nsel w=45n l=45n
RRAM_r011_c024 (n_r011_c024 bl024) resistor r=1k
MSEL_r011_c025 (n_r011_c025 vdd wl011 wl011) nsel w=45n l=45n
RRAM_r011_c025 (n_r011_c025 bl025) resistor r=1k
MSEL_r011_c026 (n_r011_c026 vdd wl011 wl011) nsel w=45n l=45n
RRAM_r011_c026 (n_r011_c026 bl026) resistor r=1meg
MSEL_r011_c027 (n_r011_c027 vdd wl011 wl011) nsel w=45n l=45n
RRAM_r011_c027 (n_r011_c027 bl027) resistor r=1meg
MSEL_r011_c028 (n_r011_c028 vdd wl011 wl011) nsel w=45n l=45n
RRAM_r011_c028 (n_r011_c028 bl028) resistor r=1k
MSEL_r011_c029 (n_r011_c029 vdd wl011 wl011) nsel w=45n l=45n
RRAM_r011_c029 (n_r011_c029 bl029) resistor r=1k
MSEL_r011_c030 (n_r011_c030 vdd wl011 wl011) nsel w=45n l=45n
RRAM_r011_c030 (n_r011_c030 bl030) resistor r=1k
MSEL_r011_c031 (n_r011_c031 vdd wl011 wl011) nsel w=45n l=45n
RRAM_r011_c031 (n_r011_c031 bl031) resistor r=1meg
MSEL_r012_c000 (n_r012_c000 vdd wl012 wl012) nsel w=45n l=45n
RRAM_r012_c000 (n_r012_c000 bl000) resistor r=1k
MSEL_r012_c001 (n_r012_c001 vdd wl012 wl012) nsel w=45n l=45n
RRAM_r012_c001 (n_r012_c001 bl001) resistor r=1k
MSEL_r012_c002 (n_r012_c002 vdd wl012 wl012) nsel w=45n l=45n
RRAM_r012_c002 (n_r012_c002 bl002) resistor r=1meg
MSEL_r012_c003 (n_r012_c003 vdd wl012 wl012) nsel w=45n l=45n
RRAM_r012_c003 (n_r012_c003 bl003) resistor r=1meg
MSEL_r012_c004 (n_r012_c004 vdd wl012 wl012) nsel w=45n l=45n
RRAM_r012_c004 (n_r012_c004 bl004) resistor r=1k
MSEL_r012_c005 (n_r012_c005 vdd wl012 wl012) nsel w=45n l=45n
RRAM_r012_c005 (n_r012_c005 bl005) resistor r=1k
MSEL_r012_c006 (n_r012_c006 vdd wl012 wl012) nsel w=45n l=45n
RRAM_r012_c006 (n_r012_c006 bl006) resistor r=1k
MSEL_r012_c007 (n_r012_c007 vdd wl012 wl012) nsel w=45n l=45n
RRAM_r012_c007 (n_r012_c007 bl007) resistor r=1k
MSEL_r012_c008 (n_r012_c008 vdd wl012 wl012) nsel w=45n l=45n
RRAM_r012_c008 (n_r012_c008 bl008) resistor r=1meg
MSEL_r012_c009 (n_r012_c009 vdd wl012 wl012) nsel w=45n l=45n
RRAM_r012_c009 (n_r012_c009 bl009) resistor r=1meg
MSEL_r012_c010 (n_r012_c010 vdd wl012 wl012) nsel w=45n l=45n
RRAM_r012_c010 (n_r012_c010 bl010) resistor r=1meg
MSEL_r012_c011 (n_r012_c011 vdd wl012 wl012) nsel w=45n l=45n
RRAM_r012_c011 (n_r012_c011 bl011) resistor r=1meg
MSEL_r012_c012 (n_r012_c012 vdd wl012 wl012) nsel w=45n l=45n
RRAM_r012_c012 (n_r012_c012 bl012) resistor r=1meg
MSEL_r012_c013 (n_r012_c013 vdd wl012 wl012) nsel w=45n l=45n
RRAM_r012_c013 (n_r012_c013 bl013) resistor r=1k
MSEL_r012_c014 (n_r012_c014 vdd wl012 wl012) nsel w=45n l=45n
RRAM_r012_c014 (n_r012_c014 bl014) resistor r=1k
MSEL_r012_c015 (n_r012_c015 vdd wl012 wl012) nsel w=45n l=45n
RRAM_r012_c015 (n_r012_c015 bl015) resistor r=1k
MSEL_r012_c016 (n_r012_c016 vdd wl012 wl012) nsel w=45n l=45n
RRAM_r012_c016 (n_r012_c016 bl016) resistor r=1meg
MSEL_r012_c017 (n_r012_c017 vdd wl012 wl012) nsel w=45n l=45n
RRAM_r012_c017 (n_r012_c017 bl017) resistor r=1k
MSEL_r012_c018 (n_r012_c018 vdd wl012 wl012) nsel w=45n l=45n
RRAM_r012_c018 (n_r012_c018 bl018) resistor r=1k
MSEL_r012_c019 (n_r012_c019 vdd wl012 wl012) nsel w=45n l=45n
RRAM_r012_c019 (n_r012_c019 bl019) resistor r=1k
MSEL_r012_c020 (n_r012_c020 vdd wl012 wl012) nsel w=45n l=45n
RRAM_r012_c020 (n_r012_c020 bl020) resistor r=1meg
MSEL_r012_c021 (n_r012_c021 vdd wl012 wl012) nsel w=45n l=45n
RRAM_r012_c021 (n_r012_c021 bl021) resistor r=1k
MSEL_r012_c022 (n_r012_c022 vdd wl012 wl012) nsel w=45n l=45n
RRAM_r012_c022 (n_r012_c022 bl022) resistor r=1k
MSEL_r012_c023 (n_r012_c023 vdd wl012 wl012) nsel w=45n l=45n
RRAM_r012_c023 (n_r012_c023 bl023) resistor r=1k
MSEL_r012_c024 (n_r012_c024 vdd wl012 wl012) nsel w=45n l=45n
RRAM_r012_c024 (n_r012_c024 bl024) resistor r=1k
MSEL_r012_c025 (n_r012_c025 vdd wl012 wl012) nsel w=45n l=45n
RRAM_r012_c025 (n_r012_c025 bl025) resistor r=1k
MSEL_r012_c026 (n_r012_c026 vdd wl012 wl012) nsel w=45n l=45n
RRAM_r012_c026 (n_r012_c026 bl026) resistor r=1meg
MSEL_r012_c027 (n_r012_c027 vdd wl012 wl012) nsel w=45n l=45n
RRAM_r012_c027 (n_r012_c027 bl027) resistor r=1meg
MSEL_r012_c028 (n_r012_c028 vdd wl012 wl012) nsel w=45n l=45n
RRAM_r012_c028 (n_r012_c028 bl028) resistor r=1k
MSEL_r012_c029 (n_r012_c029 vdd wl012 wl012) nsel w=45n l=45n
RRAM_r012_c029 (n_r012_c029 bl029) resistor r=1meg
MSEL_r012_c030 (n_r012_c030 vdd wl012 wl012) nsel w=45n l=45n
RRAM_r012_c030 (n_r012_c030 bl030) resistor r=1k
MSEL_r012_c031 (n_r012_c031 vdd wl012 wl012) nsel w=45n l=45n
RRAM_r012_c031 (n_r012_c031 bl031) resistor r=1meg
MSEL_r013_c000 (n_r013_c000 vdd wl013 wl013) nsel w=45n l=45n
RRAM_r013_c000 (n_r013_c000 bl000) resistor r=1k
MSEL_r013_c001 (n_r013_c001 vdd wl013 wl013) nsel w=45n l=45n
RRAM_r013_c001 (n_r013_c001 bl001) resistor r=1meg
MSEL_r013_c002 (n_r013_c002 vdd wl013 wl013) nsel w=45n l=45n
RRAM_r013_c002 (n_r013_c002 bl002) resistor r=1meg
MSEL_r013_c003 (n_r013_c003 vdd wl013 wl013) nsel w=45n l=45n
RRAM_r013_c003 (n_r013_c003 bl003) resistor r=1k
MSEL_r013_c004 (n_r013_c004 vdd wl013 wl013) nsel w=45n l=45n
RRAM_r013_c004 (n_r013_c004 bl004) resistor r=1k
MSEL_r013_c005 (n_r013_c005 vdd wl013 wl013) nsel w=45n l=45n
RRAM_r013_c005 (n_r013_c005 bl005) resistor r=1meg
MSEL_r013_c006 (n_r013_c006 vdd wl013 wl013) nsel w=45n l=45n
RRAM_r013_c006 (n_r013_c006 bl006) resistor r=1k
MSEL_r013_c007 (n_r013_c007 vdd wl013 wl013) nsel w=45n l=45n
RRAM_r013_c007 (n_r013_c007 bl007) resistor r=1meg
MSEL_r013_c008 (n_r013_c008 vdd wl013 wl013) nsel w=45n l=45n
RRAM_r013_c008 (n_r013_c008 bl008) resistor r=1k
MSEL_r013_c009 (n_r013_c009 vdd wl013 wl013) nsel w=45n l=45n
RRAM_r013_c009 (n_r013_c009 bl009) resistor r=1meg
MSEL_r013_c010 (n_r013_c010 vdd wl013 wl013) nsel w=45n l=45n
RRAM_r013_c010 (n_r013_c010 bl010) resistor r=1meg
MSEL_r013_c011 (n_r013_c011 vdd wl013 wl013) nsel w=45n l=45n
RRAM_r013_c011 (n_r013_c011 bl011) resistor r=1meg
MSEL_r013_c012 (n_r013_c012 vdd wl013 wl013) nsel w=45n l=45n
RRAM_r013_c012 (n_r013_c012 bl012) resistor r=1k
MSEL_r013_c013 (n_r013_c013 vdd wl013 wl013) nsel w=45n l=45n
RRAM_r013_c013 (n_r013_c013 bl013) resistor r=1meg
MSEL_r013_c014 (n_r013_c014 vdd wl013 wl013) nsel w=45n l=45n
RRAM_r013_c014 (n_r013_c014 bl014) resistor r=1meg
MSEL_r013_c015 (n_r013_c015 vdd wl013 wl013) nsel w=45n l=45n
RRAM_r013_c015 (n_r013_c015 bl015) resistor r=1meg
MSEL_r013_c016 (n_r013_c016 vdd wl013 wl013) nsel w=45n l=45n
RRAM_r013_c016 (n_r013_c016 bl016) resistor r=1meg
MSEL_r013_c017 (n_r013_c017 vdd wl013 wl013) nsel w=45n l=45n
RRAM_r013_c017 (n_r013_c017 bl017) resistor r=1k
MSEL_r013_c018 (n_r013_c018 vdd wl013 wl013) nsel w=45n l=45n
RRAM_r013_c018 (n_r013_c018 bl018) resistor r=1k
MSEL_r013_c019 (n_r013_c019 vdd wl013 wl013) nsel w=45n l=45n
RRAM_r013_c019 (n_r013_c019 bl019) resistor r=1meg
MSEL_r013_c020 (n_r013_c020 vdd wl013 wl013) nsel w=45n l=45n
RRAM_r013_c020 (n_r013_c020 bl020) resistor r=1meg
MSEL_r013_c021 (n_r013_c021 vdd wl013 wl013) nsel w=45n l=45n
RRAM_r013_c021 (n_r013_c021 bl021) resistor r=1k
MSEL_r013_c022 (n_r013_c022 vdd wl013 wl013) nsel w=45n l=45n
RRAM_r013_c022 (n_r013_c022 bl022) resistor r=1k
MSEL_r013_c023 (n_r013_c023 vdd wl013 wl013) nsel w=45n l=45n
RRAM_r013_c023 (n_r013_c023 bl023) resistor r=1k
MSEL_r013_c024 (n_r013_c024 vdd wl013 wl013) nsel w=45n l=45n
RRAM_r013_c024 (n_r013_c024 bl024) resistor r=1meg
MSEL_r013_c025 (n_r013_c025 vdd wl013 wl013) nsel w=45n l=45n
RRAM_r013_c025 (n_r013_c025 bl025) resistor r=1meg
MSEL_r013_c026 (n_r013_c026 vdd wl013 wl013) nsel w=45n l=45n
RRAM_r013_c026 (n_r013_c026 bl026) resistor r=1k
MSEL_r013_c027 (n_r013_c027 vdd wl013 wl013) nsel w=45n l=45n
RRAM_r013_c027 (n_r013_c027 bl027) resistor r=1meg
MSEL_r013_c028 (n_r013_c028 vdd wl013 wl013) nsel w=45n l=45n
RRAM_r013_c028 (n_r013_c028 bl028) resistor r=1k
MSEL_r013_c029 (n_r013_c029 vdd wl013 wl013) nsel w=45n l=45n
RRAM_r013_c029 (n_r013_c029 bl029) resistor r=1k
MSEL_r013_c030 (n_r013_c030 vdd wl013 wl013) nsel w=45n l=45n
RRAM_r013_c030 (n_r013_c030 bl030) resistor r=1meg
MSEL_r013_c031 (n_r013_c031 vdd wl013 wl013) nsel w=45n l=45n
RRAM_r013_c031 (n_r013_c031 bl031) resistor r=1k
MSEL_r014_c000 (n_r014_c000 vdd wl014 wl014) nsel w=45n l=45n
RRAM_r014_c000 (n_r014_c000 bl000) resistor r=1meg
MSEL_r014_c001 (n_r014_c001 vdd wl014 wl014) nsel w=45n l=45n
RRAM_r014_c001 (n_r014_c001 bl001) resistor r=1k
MSEL_r014_c002 (n_r014_c002 vdd wl014 wl014) nsel w=45n l=45n
RRAM_r014_c002 (n_r014_c002 bl002) resistor r=1meg
MSEL_r014_c003 (n_r014_c003 vdd wl014 wl014) nsel w=45n l=45n
RRAM_r014_c003 (n_r014_c003 bl003) resistor r=1meg
MSEL_r014_c004 (n_r014_c004 vdd wl014 wl014) nsel w=45n l=45n
RRAM_r014_c004 (n_r014_c004 bl004) resistor r=1meg
MSEL_r014_c005 (n_r014_c005 vdd wl014 wl014) nsel w=45n l=45n
RRAM_r014_c005 (n_r014_c005 bl005) resistor r=1meg
MSEL_r014_c006 (n_r014_c006 vdd wl014 wl014) nsel w=45n l=45n
RRAM_r014_c006 (n_r014_c006 bl006) resistor r=1k
MSEL_r014_c007 (n_r014_c007 vdd wl014 wl014) nsel w=45n l=45n
RRAM_r014_c007 (n_r014_c007 bl007) resistor r=1meg
MSEL_r014_c008 (n_r014_c008 vdd wl014 wl014) nsel w=45n l=45n
RRAM_r014_c008 (n_r014_c008 bl008) resistor r=1k
MSEL_r014_c009 (n_r014_c009 vdd wl014 wl014) nsel w=45n l=45n
RRAM_r014_c009 (n_r014_c009 bl009) resistor r=1k
MSEL_r014_c010 (n_r014_c010 vdd wl014 wl014) nsel w=45n l=45n
RRAM_r014_c010 (n_r014_c010 bl010) resistor r=1meg
MSEL_r014_c011 (n_r014_c011 vdd wl014 wl014) nsel w=45n l=45n
RRAM_r014_c011 (n_r014_c011 bl011) resistor r=1k
MSEL_r014_c012 (n_r014_c012 vdd wl014 wl014) nsel w=45n l=45n
RRAM_r014_c012 (n_r014_c012 bl012) resistor r=1meg
MSEL_r014_c013 (n_r014_c013 vdd wl014 wl014) nsel w=45n l=45n
RRAM_r014_c013 (n_r014_c013 bl013) resistor r=1k
MSEL_r014_c014 (n_r014_c014 vdd wl014 wl014) nsel w=45n l=45n
RRAM_r014_c014 (n_r014_c014 bl014) resistor r=1k
MSEL_r014_c015 (n_r014_c015 vdd wl014 wl014) nsel w=45n l=45n
RRAM_r014_c015 (n_r014_c015 bl015) resistor r=1k
MSEL_r014_c016 (n_r014_c016 vdd wl014 wl014) nsel w=45n l=45n
RRAM_r014_c016 (n_r014_c016 bl016) resistor r=1k
MSEL_r014_c017 (n_r014_c017 vdd wl014 wl014) nsel w=45n l=45n
RRAM_r014_c017 (n_r014_c017 bl017) resistor r=1k
MSEL_r014_c018 (n_r014_c018 vdd wl014 wl014) nsel w=45n l=45n
RRAM_r014_c018 (n_r014_c018 bl018) resistor r=1k
MSEL_r014_c019 (n_r014_c019 vdd wl014 wl014) nsel w=45n l=45n
RRAM_r014_c019 (n_r014_c019 bl019) resistor r=1meg
MSEL_r014_c020 (n_r014_c020 vdd wl014 wl014) nsel w=45n l=45n
RRAM_r014_c020 (n_r014_c020 bl020) resistor r=1meg
MSEL_r014_c021 (n_r014_c021 vdd wl014 wl014) nsel w=45n l=45n
RRAM_r014_c021 (n_r014_c021 bl021) resistor r=1meg
MSEL_r014_c022 (n_r014_c022 vdd wl014 wl014) nsel w=45n l=45n
RRAM_r014_c022 (n_r014_c022 bl022) resistor r=1k
MSEL_r014_c023 (n_r014_c023 vdd wl014 wl014) nsel w=45n l=45n
RRAM_r014_c023 (n_r014_c023 bl023) resistor r=1meg
MSEL_r014_c024 (n_r014_c024 vdd wl014 wl014) nsel w=45n l=45n
RRAM_r014_c024 (n_r014_c024 bl024) resistor r=1meg
MSEL_r014_c025 (n_r014_c025 vdd wl014 wl014) nsel w=45n l=45n
RRAM_r014_c025 (n_r014_c025 bl025) resistor r=1meg
MSEL_r014_c026 (n_r014_c026 vdd wl014 wl014) nsel w=45n l=45n
RRAM_r014_c026 (n_r014_c026 bl026) resistor r=1meg
MSEL_r014_c027 (n_r014_c027 vdd wl014 wl014) nsel w=45n l=45n
RRAM_r014_c027 (n_r014_c027 bl027) resistor r=1k
MSEL_r014_c028 (n_r014_c028 vdd wl014 wl014) nsel w=45n l=45n
RRAM_r014_c028 (n_r014_c028 bl028) resistor r=1meg
MSEL_r014_c029 (n_r014_c029 vdd wl014 wl014) nsel w=45n l=45n
RRAM_r014_c029 (n_r014_c029 bl029) resistor r=1meg
MSEL_r014_c030 (n_r014_c030 vdd wl014 wl014) nsel w=45n l=45n
RRAM_r014_c030 (n_r014_c030 bl030) resistor r=1k
MSEL_r014_c031 (n_r014_c031 vdd wl014 wl014) nsel w=45n l=45n
RRAM_r014_c031 (n_r014_c031 bl031) resistor r=1meg
MSEL_r015_c000 (n_r015_c000 vdd wl015 wl015) nsel w=45n l=45n
RRAM_r015_c000 (n_r015_c000 bl000) resistor r=1k
MSEL_r015_c001 (n_r015_c001 vdd wl015 wl015) nsel w=45n l=45n
RRAM_r015_c001 (n_r015_c001 bl001) resistor r=1meg
MSEL_r015_c002 (n_r015_c002 vdd wl015 wl015) nsel w=45n l=45n
RRAM_r015_c002 (n_r015_c002 bl002) resistor r=1meg
MSEL_r015_c003 (n_r015_c003 vdd wl015 wl015) nsel w=45n l=45n
RRAM_r015_c003 (n_r015_c003 bl003) resistor r=1meg
MSEL_r015_c004 (n_r015_c004 vdd wl015 wl015) nsel w=45n l=45n
RRAM_r015_c004 (n_r015_c004 bl004) resistor r=1k
MSEL_r015_c005 (n_r015_c005 vdd wl015 wl015) nsel w=45n l=45n
RRAM_r015_c005 (n_r015_c005 bl005) resistor r=1meg
MSEL_r015_c006 (n_r015_c006 vdd wl015 wl015) nsel w=45n l=45n
RRAM_r015_c006 (n_r015_c006 bl006) resistor r=1meg
MSEL_r015_c007 (n_r015_c007 vdd wl015 wl015) nsel w=45n l=45n
RRAM_r015_c007 (n_r015_c007 bl007) resistor r=1k
MSEL_r015_c008 (n_r015_c008 vdd wl015 wl015) nsel w=45n l=45n
RRAM_r015_c008 (n_r015_c008 bl008) resistor r=1k
MSEL_r015_c009 (n_r015_c009 vdd wl015 wl015) nsel w=45n l=45n
RRAM_r015_c009 (n_r015_c009 bl009) resistor r=1meg
MSEL_r015_c010 (n_r015_c010 vdd wl015 wl015) nsel w=45n l=45n
RRAM_r015_c010 (n_r015_c010 bl010) resistor r=1meg
MSEL_r015_c011 (n_r015_c011 vdd wl015 wl015) nsel w=45n l=45n
RRAM_r015_c011 (n_r015_c011 bl011) resistor r=1meg
MSEL_r015_c012 (n_r015_c012 vdd wl015 wl015) nsel w=45n l=45n
RRAM_r015_c012 (n_r015_c012 bl012) resistor r=1meg
MSEL_r015_c013 (n_r015_c013 vdd wl015 wl015) nsel w=45n l=45n
RRAM_r015_c013 (n_r015_c013 bl013) resistor r=1meg
MSEL_r015_c014 (n_r015_c014 vdd wl015 wl015) nsel w=45n l=45n
RRAM_r015_c014 (n_r015_c014 bl014) resistor r=1k
MSEL_r015_c015 (n_r015_c015 vdd wl015 wl015) nsel w=45n l=45n
RRAM_r015_c015 (n_r015_c015 bl015) resistor r=1meg
MSEL_r015_c016 (n_r015_c016 vdd wl015 wl015) nsel w=45n l=45n
RRAM_r015_c016 (n_r015_c016 bl016) resistor r=1k
MSEL_r015_c017 (n_r015_c017 vdd wl015 wl015) nsel w=45n l=45n
RRAM_r015_c017 (n_r015_c017 bl017) resistor r=1k
MSEL_r015_c018 (n_r015_c018 vdd wl015 wl015) nsel w=45n l=45n
RRAM_r015_c018 (n_r015_c018 bl018) resistor r=1meg
MSEL_r015_c019 (n_r015_c019 vdd wl015 wl015) nsel w=45n l=45n
RRAM_r015_c019 (n_r015_c019 bl019) resistor r=1meg
MSEL_r015_c020 (n_r015_c020 vdd wl015 wl015) nsel w=45n l=45n
RRAM_r015_c020 (n_r015_c020 bl020) resistor r=1meg
MSEL_r015_c021 (n_r015_c021 vdd wl015 wl015) nsel w=45n l=45n
RRAM_r015_c021 (n_r015_c021 bl021) resistor r=1k
MSEL_r015_c022 (n_r015_c022 vdd wl015 wl015) nsel w=45n l=45n
RRAM_r015_c022 (n_r015_c022 bl022) resistor r=1k
MSEL_r015_c023 (n_r015_c023 vdd wl015 wl015) nsel w=45n l=45n
RRAM_r015_c023 (n_r015_c023 bl023) resistor r=1k
MSEL_r015_c024 (n_r015_c024 vdd wl015 wl015) nsel w=45n l=45n
RRAM_r015_c024 (n_r015_c024 bl024) resistor r=1meg
MSEL_r015_c025 (n_r015_c025 vdd wl015 wl015) nsel w=45n l=45n
RRAM_r015_c025 (n_r015_c025 bl025) resistor r=1meg
MSEL_r015_c026 (n_r015_c026 vdd wl015 wl015) nsel w=45n l=45n
RRAM_r015_c026 (n_r015_c026 bl026) resistor r=1k
MSEL_r015_c027 (n_r015_c027 vdd wl015 wl015) nsel w=45n l=45n
RRAM_r015_c027 (n_r015_c027 bl027) resistor r=1k
MSEL_r015_c028 (n_r015_c028 vdd wl015 wl015) nsel w=45n l=45n
RRAM_r015_c028 (n_r015_c028 bl028) resistor r=1meg
MSEL_r015_c029 (n_r015_c029 vdd wl015 wl015) nsel w=45n l=45n
RRAM_r015_c029 (n_r015_c029 bl029) resistor r=1meg
MSEL_r015_c030 (n_r015_c030 vdd wl015 wl015) nsel w=45n l=45n
RRAM_r015_c030 (n_r015_c030 bl030) resistor r=1meg
MSEL_r015_c031 (n_r015_c031 vdd wl015 wl015) nsel w=45n l=45n
RRAM_r015_c031 (n_r015_c031 bl031) resistor r=1k
MSEL_r016_c000 (n_r016_c000 vdd wl016 wl016) nsel w=45n l=45n
RRAM_r016_c000 (n_r016_c000 bl000) resistor r=1k
MSEL_r016_c001 (n_r016_c001 vdd wl016 wl016) nsel w=45n l=45n
RRAM_r016_c001 (n_r016_c001 bl001) resistor r=1meg
MSEL_r016_c002 (n_r016_c002 vdd wl016 wl016) nsel w=45n l=45n
RRAM_r016_c002 (n_r016_c002 bl002) resistor r=1meg
MSEL_r016_c003 (n_r016_c003 vdd wl016 wl016) nsel w=45n l=45n
RRAM_r016_c003 (n_r016_c003 bl003) resistor r=1k
MSEL_r016_c004 (n_r016_c004 vdd wl016 wl016) nsel w=45n l=45n
RRAM_r016_c004 (n_r016_c004 bl004) resistor r=1meg
MSEL_r016_c005 (n_r016_c005 vdd wl016 wl016) nsel w=45n l=45n
RRAM_r016_c005 (n_r016_c005 bl005) resistor r=1meg
MSEL_r016_c006 (n_r016_c006 vdd wl016 wl016) nsel w=45n l=45n
RRAM_r016_c006 (n_r016_c006 bl006) resistor r=1k
MSEL_r016_c007 (n_r016_c007 vdd wl016 wl016) nsel w=45n l=45n
RRAM_r016_c007 (n_r016_c007 bl007) resistor r=1k
MSEL_r016_c008 (n_r016_c008 vdd wl016 wl016) nsel w=45n l=45n
RRAM_r016_c008 (n_r016_c008 bl008) resistor r=1meg
MSEL_r016_c009 (n_r016_c009 vdd wl016 wl016) nsel w=45n l=45n
RRAM_r016_c009 (n_r016_c009 bl009) resistor r=1meg
MSEL_r016_c010 (n_r016_c010 vdd wl016 wl016) nsel w=45n l=45n
RRAM_r016_c010 (n_r016_c010 bl010) resistor r=1meg
MSEL_r016_c011 (n_r016_c011 vdd wl016 wl016) nsel w=45n l=45n
RRAM_r016_c011 (n_r016_c011 bl011) resistor r=1k
MSEL_r016_c012 (n_r016_c012 vdd wl016 wl016) nsel w=45n l=45n
RRAM_r016_c012 (n_r016_c012 bl012) resistor r=1k
MSEL_r016_c013 (n_r016_c013 vdd wl016 wl016) nsel w=45n l=45n
RRAM_r016_c013 (n_r016_c013 bl013) resistor r=1meg
MSEL_r016_c014 (n_r016_c014 vdd wl016 wl016) nsel w=45n l=45n
RRAM_r016_c014 (n_r016_c014 bl014) resistor r=1meg
MSEL_r016_c015 (n_r016_c015 vdd wl016 wl016) nsel w=45n l=45n
RRAM_r016_c015 (n_r016_c015 bl015) resistor r=1k
MSEL_r016_c016 (n_r016_c016 vdd wl016 wl016) nsel w=45n l=45n
RRAM_r016_c016 (n_r016_c016 bl016) resistor r=1k
MSEL_r016_c017 (n_r016_c017 vdd wl016 wl016) nsel w=45n l=45n
RRAM_r016_c017 (n_r016_c017 bl017) resistor r=1meg
MSEL_r016_c018 (n_r016_c018 vdd wl016 wl016) nsel w=45n l=45n
RRAM_r016_c018 (n_r016_c018 bl018) resistor r=1meg
MSEL_r016_c019 (n_r016_c019 vdd wl016 wl016) nsel w=45n l=45n
RRAM_r016_c019 (n_r016_c019 bl019) resistor r=1meg
MSEL_r016_c020 (n_r016_c020 vdd wl016 wl016) nsel w=45n l=45n
RRAM_r016_c020 (n_r016_c020 bl020) resistor r=1k
MSEL_r016_c021 (n_r016_c021 vdd wl016 wl016) nsel w=45n l=45n
RRAM_r016_c021 (n_r016_c021 bl021) resistor r=1k
MSEL_r016_c022 (n_r016_c022 vdd wl016 wl016) nsel w=45n l=45n
RRAM_r016_c022 (n_r016_c022 bl022) resistor r=1meg
MSEL_r016_c023 (n_r016_c023 vdd wl016 wl016) nsel w=45n l=45n
RRAM_r016_c023 (n_r016_c023 bl023) resistor r=1meg
MSEL_r016_c024 (n_r016_c024 vdd wl016 wl016) nsel w=45n l=45n
RRAM_r016_c024 (n_r016_c024 bl024) resistor r=1meg
MSEL_r016_c025 (n_r016_c025 vdd wl016 wl016) nsel w=45n l=45n
RRAM_r016_c025 (n_r016_c025 bl025) resistor r=1meg
MSEL_r016_c026 (n_r016_c026 vdd wl016 wl016) nsel w=45n l=45n
RRAM_r016_c026 (n_r016_c026 bl026) resistor r=1k
MSEL_r016_c027 (n_r016_c027 vdd wl016 wl016) nsel w=45n l=45n
RRAM_r016_c027 (n_r016_c027 bl027) resistor r=1k
MSEL_r016_c028 (n_r016_c028 vdd wl016 wl016) nsel w=45n l=45n
RRAM_r016_c028 (n_r016_c028 bl028) resistor r=1k
MSEL_r016_c029 (n_r016_c029 vdd wl016 wl016) nsel w=45n l=45n
RRAM_r016_c029 (n_r016_c029 bl029) resistor r=1meg
MSEL_r016_c030 (n_r016_c030 vdd wl016 wl016) nsel w=45n l=45n
RRAM_r016_c030 (n_r016_c030 bl030) resistor r=1k
MSEL_r016_c031 (n_r016_c031 vdd wl016 wl016) nsel w=45n l=45n
RRAM_r016_c031 (n_r016_c031 bl031) resistor r=1meg
MSEL_r017_c000 (n_r017_c000 vdd wl017 wl017) nsel w=45n l=45n
RRAM_r017_c000 (n_r017_c000 bl000) resistor r=1k
MSEL_r017_c001 (n_r017_c001 vdd wl017 wl017) nsel w=45n l=45n
RRAM_r017_c001 (n_r017_c001 bl001) resistor r=1meg
MSEL_r017_c002 (n_r017_c002 vdd wl017 wl017) nsel w=45n l=45n
RRAM_r017_c002 (n_r017_c002 bl002) resistor r=1meg
MSEL_r017_c003 (n_r017_c003 vdd wl017 wl017) nsel w=45n l=45n
RRAM_r017_c003 (n_r017_c003 bl003) resistor r=1k
MSEL_r017_c004 (n_r017_c004 vdd wl017 wl017) nsel w=45n l=45n
RRAM_r017_c004 (n_r017_c004 bl004) resistor r=1k
MSEL_r017_c005 (n_r017_c005 vdd wl017 wl017) nsel w=45n l=45n
RRAM_r017_c005 (n_r017_c005 bl005) resistor r=1meg
MSEL_r017_c006 (n_r017_c006 vdd wl017 wl017) nsel w=45n l=45n
RRAM_r017_c006 (n_r017_c006 bl006) resistor r=1k
MSEL_r017_c007 (n_r017_c007 vdd wl017 wl017) nsel w=45n l=45n
RRAM_r017_c007 (n_r017_c007 bl007) resistor r=1meg
MSEL_r017_c008 (n_r017_c008 vdd wl017 wl017) nsel w=45n l=45n
RRAM_r017_c008 (n_r017_c008 bl008) resistor r=1meg
MSEL_r017_c009 (n_r017_c009 vdd wl017 wl017) nsel w=45n l=45n
RRAM_r017_c009 (n_r017_c009 bl009) resistor r=1k
MSEL_r017_c010 (n_r017_c010 vdd wl017 wl017) nsel w=45n l=45n
RRAM_r017_c010 (n_r017_c010 bl010) resistor r=1k
MSEL_r017_c011 (n_r017_c011 vdd wl017 wl017) nsel w=45n l=45n
RRAM_r017_c011 (n_r017_c011 bl011) resistor r=1meg
MSEL_r017_c012 (n_r017_c012 vdd wl017 wl017) nsel w=45n l=45n
RRAM_r017_c012 (n_r017_c012 bl012) resistor r=1k
MSEL_r017_c013 (n_r017_c013 vdd wl017 wl017) nsel w=45n l=45n
RRAM_r017_c013 (n_r017_c013 bl013) resistor r=1meg
MSEL_r017_c014 (n_r017_c014 vdd wl017 wl017) nsel w=45n l=45n
RRAM_r017_c014 (n_r017_c014 bl014) resistor r=1k
MSEL_r017_c015 (n_r017_c015 vdd wl017 wl017) nsel w=45n l=45n
RRAM_r017_c015 (n_r017_c015 bl015) resistor r=1k
MSEL_r017_c016 (n_r017_c016 vdd wl017 wl017) nsel w=45n l=45n
RRAM_r017_c016 (n_r017_c016 bl016) resistor r=1meg
MSEL_r017_c017 (n_r017_c017 vdd wl017 wl017) nsel w=45n l=45n
RRAM_r017_c017 (n_r017_c017 bl017) resistor r=1meg
MSEL_r017_c018 (n_r017_c018 vdd wl017 wl017) nsel w=45n l=45n
RRAM_r017_c018 (n_r017_c018 bl018) resistor r=1meg
MSEL_r017_c019 (n_r017_c019 vdd wl017 wl017) nsel w=45n l=45n
RRAM_r017_c019 (n_r017_c019 bl019) resistor r=1k
MSEL_r017_c020 (n_r017_c020 vdd wl017 wl017) nsel w=45n l=45n
RRAM_r017_c020 (n_r017_c020 bl020) resistor r=1k
MSEL_r017_c021 (n_r017_c021 vdd wl017 wl017) nsel w=45n l=45n
RRAM_r017_c021 (n_r017_c021 bl021) resistor r=1k
MSEL_r017_c022 (n_r017_c022 vdd wl017 wl017) nsel w=45n l=45n
RRAM_r017_c022 (n_r017_c022 bl022) resistor r=1k
MSEL_r017_c023 (n_r017_c023 vdd wl017 wl017) nsel w=45n l=45n
RRAM_r017_c023 (n_r017_c023 bl023) resistor r=1meg
MSEL_r017_c024 (n_r017_c024 vdd wl017 wl017) nsel w=45n l=45n
RRAM_r017_c024 (n_r017_c024 bl024) resistor r=1k
MSEL_r017_c025 (n_r017_c025 vdd wl017 wl017) nsel w=45n l=45n
RRAM_r017_c025 (n_r017_c025 bl025) resistor r=1k
MSEL_r017_c026 (n_r017_c026 vdd wl017 wl017) nsel w=45n l=45n
RRAM_r017_c026 (n_r017_c026 bl026) resistor r=1meg
MSEL_r017_c027 (n_r017_c027 vdd wl017 wl017) nsel w=45n l=45n
RRAM_r017_c027 (n_r017_c027 bl027) resistor r=1meg
MSEL_r017_c028 (n_r017_c028 vdd wl017 wl017) nsel w=45n l=45n
RRAM_r017_c028 (n_r017_c028 bl028) resistor r=1k
MSEL_r017_c029 (n_r017_c029 vdd wl017 wl017) nsel w=45n l=45n
RRAM_r017_c029 (n_r017_c029 bl029) resistor r=1meg
MSEL_r017_c030 (n_r017_c030 vdd wl017 wl017) nsel w=45n l=45n
RRAM_r017_c030 (n_r017_c030 bl030) resistor r=1meg
MSEL_r017_c031 (n_r017_c031 vdd wl017 wl017) nsel w=45n l=45n
RRAM_r017_c031 (n_r017_c031 bl031) resistor r=1meg
MSEL_r018_c000 (n_r018_c000 vdd wl018 wl018) nsel w=45n l=45n
RRAM_r018_c000 (n_r018_c000 bl000) resistor r=1meg
MSEL_r018_c001 (n_r018_c001 vdd wl018 wl018) nsel w=45n l=45n
RRAM_r018_c001 (n_r018_c001 bl001) resistor r=1meg
MSEL_r018_c002 (n_r018_c002 vdd wl018 wl018) nsel w=45n l=45n
RRAM_r018_c002 (n_r018_c002 bl002) resistor r=1meg
MSEL_r018_c003 (n_r018_c003 vdd wl018 wl018) nsel w=45n l=45n
RRAM_r018_c003 (n_r018_c003 bl003) resistor r=1k
MSEL_r018_c004 (n_r018_c004 vdd wl018 wl018) nsel w=45n l=45n
RRAM_r018_c004 (n_r018_c004 bl004) resistor r=1k
MSEL_r018_c005 (n_r018_c005 vdd wl018 wl018) nsel w=45n l=45n
RRAM_r018_c005 (n_r018_c005 bl005) resistor r=1k
MSEL_r018_c006 (n_r018_c006 vdd wl018 wl018) nsel w=45n l=45n
RRAM_r018_c006 (n_r018_c006 bl006) resistor r=1meg
MSEL_r018_c007 (n_r018_c007 vdd wl018 wl018) nsel w=45n l=45n
RRAM_r018_c007 (n_r018_c007 bl007) resistor r=1meg
MSEL_r018_c008 (n_r018_c008 vdd wl018 wl018) nsel w=45n l=45n
RRAM_r018_c008 (n_r018_c008 bl008) resistor r=1k
MSEL_r018_c009 (n_r018_c009 vdd wl018 wl018) nsel w=45n l=45n
RRAM_r018_c009 (n_r018_c009 bl009) resistor r=1k
MSEL_r018_c010 (n_r018_c010 vdd wl018 wl018) nsel w=45n l=45n
RRAM_r018_c010 (n_r018_c010 bl010) resistor r=1meg
MSEL_r018_c011 (n_r018_c011 vdd wl018 wl018) nsel w=45n l=45n
RRAM_r018_c011 (n_r018_c011 bl011) resistor r=1meg
MSEL_r018_c012 (n_r018_c012 vdd wl018 wl018) nsel w=45n l=45n
RRAM_r018_c012 (n_r018_c012 bl012) resistor r=1k
MSEL_r018_c013 (n_r018_c013 vdd wl018 wl018) nsel w=45n l=45n
RRAM_r018_c013 (n_r018_c013 bl013) resistor r=1k
MSEL_r018_c014 (n_r018_c014 vdd wl018 wl018) nsel w=45n l=45n
RRAM_r018_c014 (n_r018_c014 bl014) resistor r=1k
MSEL_r018_c015 (n_r018_c015 vdd wl018 wl018) nsel w=45n l=45n
RRAM_r018_c015 (n_r018_c015 bl015) resistor r=1meg
MSEL_r018_c016 (n_r018_c016 vdd wl018 wl018) nsel w=45n l=45n
RRAM_r018_c016 (n_r018_c016 bl016) resistor r=1k
MSEL_r018_c017 (n_r018_c017 vdd wl018 wl018) nsel w=45n l=45n
RRAM_r018_c017 (n_r018_c017 bl017) resistor r=1k
MSEL_r018_c018 (n_r018_c018 vdd wl018 wl018) nsel w=45n l=45n
RRAM_r018_c018 (n_r018_c018 bl018) resistor r=1meg
MSEL_r018_c019 (n_r018_c019 vdd wl018 wl018) nsel w=45n l=45n
RRAM_r018_c019 (n_r018_c019 bl019) resistor r=1k
MSEL_r018_c020 (n_r018_c020 vdd wl018 wl018) nsel w=45n l=45n
RRAM_r018_c020 (n_r018_c020 bl020) resistor r=1k
MSEL_r018_c021 (n_r018_c021 vdd wl018 wl018) nsel w=45n l=45n
RRAM_r018_c021 (n_r018_c021 bl021) resistor r=1k
MSEL_r018_c022 (n_r018_c022 vdd wl018 wl018) nsel w=45n l=45n
RRAM_r018_c022 (n_r018_c022 bl022) resistor r=1k
MSEL_r018_c023 (n_r018_c023 vdd wl018 wl018) nsel w=45n l=45n
RRAM_r018_c023 (n_r018_c023 bl023) resistor r=1meg
MSEL_r018_c024 (n_r018_c024 vdd wl018 wl018) nsel w=45n l=45n
RRAM_r018_c024 (n_r018_c024 bl024) resistor r=1k
MSEL_r018_c025 (n_r018_c025 vdd wl018 wl018) nsel w=45n l=45n
RRAM_r018_c025 (n_r018_c025 bl025) resistor r=1meg
MSEL_r018_c026 (n_r018_c026 vdd wl018 wl018) nsel w=45n l=45n
RRAM_r018_c026 (n_r018_c026 bl026) resistor r=1meg
MSEL_r018_c027 (n_r018_c027 vdd wl018 wl018) nsel w=45n l=45n
RRAM_r018_c027 (n_r018_c027 bl027) resistor r=1meg
MSEL_r018_c028 (n_r018_c028 vdd wl018 wl018) nsel w=45n l=45n
RRAM_r018_c028 (n_r018_c028 bl028) resistor r=1meg
MSEL_r018_c029 (n_r018_c029 vdd wl018 wl018) nsel w=45n l=45n
RRAM_r018_c029 (n_r018_c029 bl029) resistor r=1k
MSEL_r018_c030 (n_r018_c030 vdd wl018 wl018) nsel w=45n l=45n
RRAM_r018_c030 (n_r018_c030 bl030) resistor r=1meg
MSEL_r018_c031 (n_r018_c031 vdd wl018 wl018) nsel w=45n l=45n
RRAM_r018_c031 (n_r018_c031 bl031) resistor r=1meg
MSEL_r019_c000 (n_r019_c000 vdd wl019 wl019) nsel w=45n l=45n
RRAM_r019_c000 (n_r019_c000 bl000) resistor r=1meg
MSEL_r019_c001 (n_r019_c001 vdd wl019 wl019) nsel w=45n l=45n
RRAM_r019_c001 (n_r019_c001 bl001) resistor r=1meg
MSEL_r019_c002 (n_r019_c002 vdd wl019 wl019) nsel w=45n l=45n
RRAM_r019_c002 (n_r019_c002 bl002) resistor r=1k
MSEL_r019_c003 (n_r019_c003 vdd wl019 wl019) nsel w=45n l=45n
RRAM_r019_c003 (n_r019_c003 bl003) resistor r=1k
MSEL_r019_c004 (n_r019_c004 vdd wl019 wl019) nsel w=45n l=45n
RRAM_r019_c004 (n_r019_c004 bl004) resistor r=1meg
MSEL_r019_c005 (n_r019_c005 vdd wl019 wl019) nsel w=45n l=45n
RRAM_r019_c005 (n_r019_c005 bl005) resistor r=1meg
MSEL_r019_c006 (n_r019_c006 vdd wl019 wl019) nsel w=45n l=45n
RRAM_r019_c006 (n_r019_c006 bl006) resistor r=1k
MSEL_r019_c007 (n_r019_c007 vdd wl019 wl019) nsel w=45n l=45n
RRAM_r019_c007 (n_r019_c007 bl007) resistor r=1meg
MSEL_r019_c008 (n_r019_c008 vdd wl019 wl019) nsel w=45n l=45n
RRAM_r019_c008 (n_r019_c008 bl008) resistor r=1meg
MSEL_r019_c009 (n_r019_c009 vdd wl019 wl019) nsel w=45n l=45n
RRAM_r019_c009 (n_r019_c009 bl009) resistor r=1k
MSEL_r019_c010 (n_r019_c010 vdd wl019 wl019) nsel w=45n l=45n
RRAM_r019_c010 (n_r019_c010 bl010) resistor r=1k
MSEL_r019_c011 (n_r019_c011 vdd wl019 wl019) nsel w=45n l=45n
RRAM_r019_c011 (n_r019_c011 bl011) resistor r=1meg
MSEL_r019_c012 (n_r019_c012 vdd wl019 wl019) nsel w=45n l=45n
RRAM_r019_c012 (n_r019_c012 bl012) resistor r=1meg
MSEL_r019_c013 (n_r019_c013 vdd wl019 wl019) nsel w=45n l=45n
RRAM_r019_c013 (n_r019_c013 bl013) resistor r=1k
MSEL_r019_c014 (n_r019_c014 vdd wl019 wl019) nsel w=45n l=45n
RRAM_r019_c014 (n_r019_c014 bl014) resistor r=1meg
MSEL_r019_c015 (n_r019_c015 vdd wl019 wl019) nsel w=45n l=45n
RRAM_r019_c015 (n_r019_c015 bl015) resistor r=1meg
MSEL_r019_c016 (n_r019_c016 vdd wl019 wl019) nsel w=45n l=45n
RRAM_r019_c016 (n_r019_c016 bl016) resistor r=1meg
MSEL_r019_c017 (n_r019_c017 vdd wl019 wl019) nsel w=45n l=45n
RRAM_r019_c017 (n_r019_c017 bl017) resistor r=1k
MSEL_r019_c018 (n_r019_c018 vdd wl019 wl019) nsel w=45n l=45n
RRAM_r019_c018 (n_r019_c018 bl018) resistor r=1meg
MSEL_r019_c019 (n_r019_c019 vdd wl019 wl019) nsel w=45n l=45n
RRAM_r019_c019 (n_r019_c019 bl019) resistor r=1k
MSEL_r019_c020 (n_r019_c020 vdd wl019 wl019) nsel w=45n l=45n
RRAM_r019_c020 (n_r019_c020 bl020) resistor r=1k
MSEL_r019_c021 (n_r019_c021 vdd wl019 wl019) nsel w=45n l=45n
RRAM_r019_c021 (n_r019_c021 bl021) resistor r=1k
MSEL_r019_c022 (n_r019_c022 vdd wl019 wl019) nsel w=45n l=45n
RRAM_r019_c022 (n_r019_c022 bl022) resistor r=1meg
MSEL_r019_c023 (n_r019_c023 vdd wl019 wl019) nsel w=45n l=45n
RRAM_r019_c023 (n_r019_c023 bl023) resistor r=1k
MSEL_r019_c024 (n_r019_c024 vdd wl019 wl019) nsel w=45n l=45n
RRAM_r019_c024 (n_r019_c024 bl024) resistor r=1k
MSEL_r019_c025 (n_r019_c025 vdd wl019 wl019) nsel w=45n l=45n
RRAM_r019_c025 (n_r019_c025 bl025) resistor r=1k
MSEL_r019_c026 (n_r019_c026 vdd wl019 wl019) nsel w=45n l=45n
RRAM_r019_c026 (n_r019_c026 bl026) resistor r=1meg
MSEL_r019_c027 (n_r019_c027 vdd wl019 wl019) nsel w=45n l=45n
RRAM_r019_c027 (n_r019_c027 bl027) resistor r=1meg
MSEL_r019_c028 (n_r019_c028 vdd wl019 wl019) nsel w=45n l=45n
RRAM_r019_c028 (n_r019_c028 bl028) resistor r=1k
MSEL_r019_c029 (n_r019_c029 vdd wl019 wl019) nsel w=45n l=45n
RRAM_r019_c029 (n_r019_c029 bl029) resistor r=1meg
MSEL_r019_c030 (n_r019_c030 vdd wl019 wl019) nsel w=45n l=45n
RRAM_r019_c030 (n_r019_c030 bl030) resistor r=1meg
MSEL_r019_c031 (n_r019_c031 vdd wl019 wl019) nsel w=45n l=45n
RRAM_r019_c031 (n_r019_c031 bl031) resistor r=1k
MSEL_r020_c000 (n_r020_c000 vdd wl020 wl020) nsel w=45n l=45n
RRAM_r020_c000 (n_r020_c000 bl000) resistor r=1meg
MSEL_r020_c001 (n_r020_c001 vdd wl020 wl020) nsel w=45n l=45n
RRAM_r020_c001 (n_r020_c001 bl001) resistor r=1meg
MSEL_r020_c002 (n_r020_c002 vdd wl020 wl020) nsel w=45n l=45n
RRAM_r020_c002 (n_r020_c002 bl002) resistor r=1k
MSEL_r020_c003 (n_r020_c003 vdd wl020 wl020) nsel w=45n l=45n
RRAM_r020_c003 (n_r020_c003 bl003) resistor r=1k
MSEL_r020_c004 (n_r020_c004 vdd wl020 wl020) nsel w=45n l=45n
RRAM_r020_c004 (n_r020_c004 bl004) resistor r=1k
MSEL_r020_c005 (n_r020_c005 vdd wl020 wl020) nsel w=45n l=45n
RRAM_r020_c005 (n_r020_c005 bl005) resistor r=1k
MSEL_r020_c006 (n_r020_c006 vdd wl020 wl020) nsel w=45n l=45n
RRAM_r020_c006 (n_r020_c006 bl006) resistor r=1meg
MSEL_r020_c007 (n_r020_c007 vdd wl020 wl020) nsel w=45n l=45n
RRAM_r020_c007 (n_r020_c007 bl007) resistor r=1k
MSEL_r020_c008 (n_r020_c008 vdd wl020 wl020) nsel w=45n l=45n
RRAM_r020_c008 (n_r020_c008 bl008) resistor r=1meg
MSEL_r020_c009 (n_r020_c009 vdd wl020 wl020) nsel w=45n l=45n
RRAM_r020_c009 (n_r020_c009 bl009) resistor r=1meg
MSEL_r020_c010 (n_r020_c010 vdd wl020 wl020) nsel w=45n l=45n
RRAM_r020_c010 (n_r020_c010 bl010) resistor r=1meg
MSEL_r020_c011 (n_r020_c011 vdd wl020 wl020) nsel w=45n l=45n
RRAM_r020_c011 (n_r020_c011 bl011) resistor r=1k
MSEL_r020_c012 (n_r020_c012 vdd wl020 wl020) nsel w=45n l=45n
RRAM_r020_c012 (n_r020_c012 bl012) resistor r=1k
MSEL_r020_c013 (n_r020_c013 vdd wl020 wl020) nsel w=45n l=45n
RRAM_r020_c013 (n_r020_c013 bl013) resistor r=1k
MSEL_r020_c014 (n_r020_c014 vdd wl020 wl020) nsel w=45n l=45n
RRAM_r020_c014 (n_r020_c014 bl014) resistor r=1k
MSEL_r020_c015 (n_r020_c015 vdd wl020 wl020) nsel w=45n l=45n
RRAM_r020_c015 (n_r020_c015 bl015) resistor r=1meg
MSEL_r020_c016 (n_r020_c016 vdd wl020 wl020) nsel w=45n l=45n
RRAM_r020_c016 (n_r020_c016 bl016) resistor r=1k
MSEL_r020_c017 (n_r020_c017 vdd wl020 wl020) nsel w=45n l=45n
RRAM_r020_c017 (n_r020_c017 bl017) resistor r=1meg
MSEL_r020_c018 (n_r020_c018 vdd wl020 wl020) nsel w=45n l=45n
RRAM_r020_c018 (n_r020_c018 bl018) resistor r=1k
MSEL_r020_c019 (n_r020_c019 vdd wl020 wl020) nsel w=45n l=45n
RRAM_r020_c019 (n_r020_c019 bl019) resistor r=1k
MSEL_r020_c020 (n_r020_c020 vdd wl020 wl020) nsel w=45n l=45n
RRAM_r020_c020 (n_r020_c020 bl020) resistor r=1k
MSEL_r020_c021 (n_r020_c021 vdd wl020 wl020) nsel w=45n l=45n
RRAM_r020_c021 (n_r020_c021 bl021) resistor r=1meg
MSEL_r020_c022 (n_r020_c022 vdd wl020 wl020) nsel w=45n l=45n
RRAM_r020_c022 (n_r020_c022 bl022) resistor r=1meg
MSEL_r020_c023 (n_r020_c023 vdd wl020 wl020) nsel w=45n l=45n
RRAM_r020_c023 (n_r020_c023 bl023) resistor r=1meg
MSEL_r020_c024 (n_r020_c024 vdd wl020 wl020) nsel w=45n l=45n
RRAM_r020_c024 (n_r020_c024 bl024) resistor r=1meg
MSEL_r020_c025 (n_r020_c025 vdd wl020 wl020) nsel w=45n l=45n
RRAM_r020_c025 (n_r020_c025 bl025) resistor r=1k
MSEL_r020_c026 (n_r020_c026 vdd wl020 wl020) nsel w=45n l=45n
RRAM_r020_c026 (n_r020_c026 bl026) resistor r=1k
MSEL_r020_c027 (n_r020_c027 vdd wl020 wl020) nsel w=45n l=45n
RRAM_r020_c027 (n_r020_c027 bl027) resistor r=1meg
MSEL_r020_c028 (n_r020_c028 vdd wl020 wl020) nsel w=45n l=45n
RRAM_r020_c028 (n_r020_c028 bl028) resistor r=1k
MSEL_r020_c029 (n_r020_c029 vdd wl020 wl020) nsel w=45n l=45n
RRAM_r020_c029 (n_r020_c029 bl029) resistor r=1meg
MSEL_r020_c030 (n_r020_c030 vdd wl020 wl020) nsel w=45n l=45n
RRAM_r020_c030 (n_r020_c030 bl030) resistor r=1k
MSEL_r020_c031 (n_r020_c031 vdd wl020 wl020) nsel w=45n l=45n
RRAM_r020_c031 (n_r020_c031 bl031) resistor r=1k
MSEL_r021_c000 (n_r021_c000 vdd wl021 wl021) nsel w=45n l=45n
RRAM_r021_c000 (n_r021_c000 bl000) resistor r=1meg
MSEL_r021_c001 (n_r021_c001 vdd wl021 wl021) nsel w=45n l=45n
RRAM_r021_c001 (n_r021_c001 bl001) resistor r=1k
MSEL_r021_c002 (n_r021_c002 vdd wl021 wl021) nsel w=45n l=45n
RRAM_r021_c002 (n_r021_c002 bl002) resistor r=1k
MSEL_r021_c003 (n_r021_c003 vdd wl021 wl021) nsel w=45n l=45n
RRAM_r021_c003 (n_r021_c003 bl003) resistor r=1k
MSEL_r021_c004 (n_r021_c004 vdd wl021 wl021) nsel w=45n l=45n
RRAM_r021_c004 (n_r021_c004 bl004) resistor r=1k
MSEL_r021_c005 (n_r021_c005 vdd wl021 wl021) nsel w=45n l=45n
RRAM_r021_c005 (n_r021_c005 bl005) resistor r=1k
MSEL_r021_c006 (n_r021_c006 vdd wl021 wl021) nsel w=45n l=45n
RRAM_r021_c006 (n_r021_c006 bl006) resistor r=1meg
MSEL_r021_c007 (n_r021_c007 vdd wl021 wl021) nsel w=45n l=45n
RRAM_r021_c007 (n_r021_c007 bl007) resistor r=1meg
MSEL_r021_c008 (n_r021_c008 vdd wl021 wl021) nsel w=45n l=45n
RRAM_r021_c008 (n_r021_c008 bl008) resistor r=1meg
MSEL_r021_c009 (n_r021_c009 vdd wl021 wl021) nsel w=45n l=45n
RRAM_r021_c009 (n_r021_c009 bl009) resistor r=1meg
MSEL_r021_c010 (n_r021_c010 vdd wl021 wl021) nsel w=45n l=45n
RRAM_r021_c010 (n_r021_c010 bl010) resistor r=1k
MSEL_r021_c011 (n_r021_c011 vdd wl021 wl021) nsel w=45n l=45n
RRAM_r021_c011 (n_r021_c011 bl011) resistor r=1k
MSEL_r021_c012 (n_r021_c012 vdd wl021 wl021) nsel w=45n l=45n
RRAM_r021_c012 (n_r021_c012 bl012) resistor r=1k
MSEL_r021_c013 (n_r021_c013 vdd wl021 wl021) nsel w=45n l=45n
RRAM_r021_c013 (n_r021_c013 bl013) resistor r=1k
MSEL_r021_c014 (n_r021_c014 vdd wl021 wl021) nsel w=45n l=45n
RRAM_r021_c014 (n_r021_c014 bl014) resistor r=1meg
MSEL_r021_c015 (n_r021_c015 vdd wl021 wl021) nsel w=45n l=45n
RRAM_r021_c015 (n_r021_c015 bl015) resistor r=1meg
MSEL_r021_c016 (n_r021_c016 vdd wl021 wl021) nsel w=45n l=45n
RRAM_r021_c016 (n_r021_c016 bl016) resistor r=1meg
MSEL_r021_c017 (n_r021_c017 vdd wl021 wl021) nsel w=45n l=45n
RRAM_r021_c017 (n_r021_c017 bl017) resistor r=1meg
MSEL_r021_c018 (n_r021_c018 vdd wl021 wl021) nsel w=45n l=45n
RRAM_r021_c018 (n_r021_c018 bl018) resistor r=1k
MSEL_r021_c019 (n_r021_c019 vdd wl021 wl021) nsel w=45n l=45n
RRAM_r021_c019 (n_r021_c019 bl019) resistor r=1k
MSEL_r021_c020 (n_r021_c020 vdd wl021 wl021) nsel w=45n l=45n
RRAM_r021_c020 (n_r021_c020 bl020) resistor r=1meg
MSEL_r021_c021 (n_r021_c021 vdd wl021 wl021) nsel w=45n l=45n
RRAM_r021_c021 (n_r021_c021 bl021) resistor r=1meg
MSEL_r021_c022 (n_r021_c022 vdd wl021 wl021) nsel w=45n l=45n
RRAM_r021_c022 (n_r021_c022 bl022) resistor r=1k
MSEL_r021_c023 (n_r021_c023 vdd wl021 wl021) nsel w=45n l=45n
RRAM_r021_c023 (n_r021_c023 bl023) resistor r=1meg
MSEL_r021_c024 (n_r021_c024 vdd wl021 wl021) nsel w=45n l=45n
RRAM_r021_c024 (n_r021_c024 bl024) resistor r=1k
MSEL_r021_c025 (n_r021_c025 vdd wl021 wl021) nsel w=45n l=45n
RRAM_r021_c025 (n_r021_c025 bl025) resistor r=1meg
MSEL_r021_c026 (n_r021_c026 vdd wl021 wl021) nsel w=45n l=45n
RRAM_r021_c026 (n_r021_c026 bl026) resistor r=1k
MSEL_r021_c027 (n_r021_c027 vdd wl021 wl021) nsel w=45n l=45n
RRAM_r021_c027 (n_r021_c027 bl027) resistor r=1k
MSEL_r021_c028 (n_r021_c028 vdd wl021 wl021) nsel w=45n l=45n
RRAM_r021_c028 (n_r021_c028 bl028) resistor r=1meg
MSEL_r021_c029 (n_r021_c029 vdd wl021 wl021) nsel w=45n l=45n
RRAM_r021_c029 (n_r021_c029 bl029) resistor r=1k
MSEL_r021_c030 (n_r021_c030 vdd wl021 wl021) nsel w=45n l=45n
RRAM_r021_c030 (n_r021_c030 bl030) resistor r=1meg
MSEL_r021_c031 (n_r021_c031 vdd wl021 wl021) nsel w=45n l=45n
RRAM_r021_c031 (n_r021_c031 bl031) resistor r=1k
MSEL_r022_c000 (n_r022_c000 vdd wl022 wl022) nsel w=45n l=45n
RRAM_r022_c000 (n_r022_c000 bl000) resistor r=1meg
MSEL_r022_c001 (n_r022_c001 vdd wl022 wl022) nsel w=45n l=45n
RRAM_r022_c001 (n_r022_c001 bl001) resistor r=1meg
MSEL_r022_c002 (n_r022_c002 vdd wl022 wl022) nsel w=45n l=45n
RRAM_r022_c002 (n_r022_c002 bl002) resistor r=1meg
MSEL_r022_c003 (n_r022_c003 vdd wl022 wl022) nsel w=45n l=45n
RRAM_r022_c003 (n_r022_c003 bl003) resistor r=1k
MSEL_r022_c004 (n_r022_c004 vdd wl022 wl022) nsel w=45n l=45n
RRAM_r022_c004 (n_r022_c004 bl004) resistor r=1meg
MSEL_r022_c005 (n_r022_c005 vdd wl022 wl022) nsel w=45n l=45n
RRAM_r022_c005 (n_r022_c005 bl005) resistor r=1k
MSEL_r022_c006 (n_r022_c006 vdd wl022 wl022) nsel w=45n l=45n
RRAM_r022_c006 (n_r022_c006 bl006) resistor r=1k
MSEL_r022_c007 (n_r022_c007 vdd wl022 wl022) nsel w=45n l=45n
RRAM_r022_c007 (n_r022_c007 bl007) resistor r=1k
MSEL_r022_c008 (n_r022_c008 vdd wl022 wl022) nsel w=45n l=45n
RRAM_r022_c008 (n_r022_c008 bl008) resistor r=1k
MSEL_r022_c009 (n_r022_c009 vdd wl022 wl022) nsel w=45n l=45n
RRAM_r022_c009 (n_r022_c009 bl009) resistor r=1k
MSEL_r022_c010 (n_r022_c010 vdd wl022 wl022) nsel w=45n l=45n
RRAM_r022_c010 (n_r022_c010 bl010) resistor r=1meg
MSEL_r022_c011 (n_r022_c011 vdd wl022 wl022) nsel w=45n l=45n
RRAM_r022_c011 (n_r022_c011 bl011) resistor r=1k
MSEL_r022_c012 (n_r022_c012 vdd wl022 wl022) nsel w=45n l=45n
RRAM_r022_c012 (n_r022_c012 bl012) resistor r=1meg
MSEL_r022_c013 (n_r022_c013 vdd wl022 wl022) nsel w=45n l=45n
RRAM_r022_c013 (n_r022_c013 bl013) resistor r=1k
MSEL_r022_c014 (n_r022_c014 vdd wl022 wl022) nsel w=45n l=45n
RRAM_r022_c014 (n_r022_c014 bl014) resistor r=1k
MSEL_r022_c015 (n_r022_c015 vdd wl022 wl022) nsel w=45n l=45n
RRAM_r022_c015 (n_r022_c015 bl015) resistor r=1meg
MSEL_r022_c016 (n_r022_c016 vdd wl022 wl022) nsel w=45n l=45n
RRAM_r022_c016 (n_r022_c016 bl016) resistor r=1k
MSEL_r022_c017 (n_r022_c017 vdd wl022 wl022) nsel w=45n l=45n
RRAM_r022_c017 (n_r022_c017 bl017) resistor r=1meg
MSEL_r022_c018 (n_r022_c018 vdd wl022 wl022) nsel w=45n l=45n
RRAM_r022_c018 (n_r022_c018 bl018) resistor r=1meg
MSEL_r022_c019 (n_r022_c019 vdd wl022 wl022) nsel w=45n l=45n
RRAM_r022_c019 (n_r022_c019 bl019) resistor r=1k
MSEL_r022_c020 (n_r022_c020 vdd wl022 wl022) nsel w=45n l=45n
RRAM_r022_c020 (n_r022_c020 bl020) resistor r=1k
MSEL_r022_c021 (n_r022_c021 vdd wl022 wl022) nsel w=45n l=45n
RRAM_r022_c021 (n_r022_c021 bl021) resistor r=1meg
MSEL_r022_c022 (n_r022_c022 vdd wl022 wl022) nsel w=45n l=45n
RRAM_r022_c022 (n_r022_c022 bl022) resistor r=1k
MSEL_r022_c023 (n_r022_c023 vdd wl022 wl022) nsel w=45n l=45n
RRAM_r022_c023 (n_r022_c023 bl023) resistor r=1k
MSEL_r022_c024 (n_r022_c024 vdd wl022 wl022) nsel w=45n l=45n
RRAM_r022_c024 (n_r022_c024 bl024) resistor r=1meg
MSEL_r022_c025 (n_r022_c025 vdd wl022 wl022) nsel w=45n l=45n
RRAM_r022_c025 (n_r022_c025 bl025) resistor r=1k
MSEL_r022_c026 (n_r022_c026 vdd wl022 wl022) nsel w=45n l=45n
RRAM_r022_c026 (n_r022_c026 bl026) resistor r=1meg
MSEL_r022_c027 (n_r022_c027 vdd wl022 wl022) nsel w=45n l=45n
RRAM_r022_c027 (n_r022_c027 bl027) resistor r=1meg
MSEL_r022_c028 (n_r022_c028 vdd wl022 wl022) nsel w=45n l=45n
RRAM_r022_c028 (n_r022_c028 bl028) resistor r=1k
MSEL_r022_c029 (n_r022_c029 vdd wl022 wl022) nsel w=45n l=45n
RRAM_r022_c029 (n_r022_c029 bl029) resistor r=1meg
MSEL_r022_c030 (n_r022_c030 vdd wl022 wl022) nsel w=45n l=45n
RRAM_r022_c030 (n_r022_c030 bl030) resistor r=1k
MSEL_r022_c031 (n_r022_c031 vdd wl022 wl022) nsel w=45n l=45n
RRAM_r022_c031 (n_r022_c031 bl031) resistor r=1k
MSEL_r023_c000 (n_r023_c000 vdd wl023 wl023) nsel w=45n l=45n
RRAM_r023_c000 (n_r023_c000 bl000) resistor r=1k
MSEL_r023_c001 (n_r023_c001 vdd wl023 wl023) nsel w=45n l=45n
RRAM_r023_c001 (n_r023_c001 bl001) resistor r=1meg
MSEL_r023_c002 (n_r023_c002 vdd wl023 wl023) nsel w=45n l=45n
RRAM_r023_c002 (n_r023_c002 bl002) resistor r=1k
MSEL_r023_c003 (n_r023_c003 vdd wl023 wl023) nsel w=45n l=45n
RRAM_r023_c003 (n_r023_c003 bl003) resistor r=1meg
MSEL_r023_c004 (n_r023_c004 vdd wl023 wl023) nsel w=45n l=45n
RRAM_r023_c004 (n_r023_c004 bl004) resistor r=1k
MSEL_r023_c005 (n_r023_c005 vdd wl023 wl023) nsel w=45n l=45n
RRAM_r023_c005 (n_r023_c005 bl005) resistor r=1meg
MSEL_r023_c006 (n_r023_c006 vdd wl023 wl023) nsel w=45n l=45n
RRAM_r023_c006 (n_r023_c006 bl006) resistor r=1k
MSEL_r023_c007 (n_r023_c007 vdd wl023 wl023) nsel w=45n l=45n
RRAM_r023_c007 (n_r023_c007 bl007) resistor r=1meg
MSEL_r023_c008 (n_r023_c008 vdd wl023 wl023) nsel w=45n l=45n
RRAM_r023_c008 (n_r023_c008 bl008) resistor r=1meg
MSEL_r023_c009 (n_r023_c009 vdd wl023 wl023) nsel w=45n l=45n
RRAM_r023_c009 (n_r023_c009 bl009) resistor r=1k
MSEL_r023_c010 (n_r023_c010 vdd wl023 wl023) nsel w=45n l=45n
RRAM_r023_c010 (n_r023_c010 bl010) resistor r=1meg
MSEL_r023_c011 (n_r023_c011 vdd wl023 wl023) nsel w=45n l=45n
RRAM_r023_c011 (n_r023_c011 bl011) resistor r=1meg
MSEL_r023_c012 (n_r023_c012 vdd wl023 wl023) nsel w=45n l=45n
RRAM_r023_c012 (n_r023_c012 bl012) resistor r=1meg
MSEL_r023_c013 (n_r023_c013 vdd wl023 wl023) nsel w=45n l=45n
RRAM_r023_c013 (n_r023_c013 bl013) resistor r=1meg
MSEL_r023_c014 (n_r023_c014 vdd wl023 wl023) nsel w=45n l=45n
RRAM_r023_c014 (n_r023_c014 bl014) resistor r=1meg
MSEL_r023_c015 (n_r023_c015 vdd wl023 wl023) nsel w=45n l=45n
RRAM_r023_c015 (n_r023_c015 bl015) resistor r=1k
MSEL_r023_c016 (n_r023_c016 vdd wl023 wl023) nsel w=45n l=45n
RRAM_r023_c016 (n_r023_c016 bl016) resistor r=1meg
MSEL_r023_c017 (n_r023_c017 vdd wl023 wl023) nsel w=45n l=45n
RRAM_r023_c017 (n_r023_c017 bl017) resistor r=1k
MSEL_r023_c018 (n_r023_c018 vdd wl023 wl023) nsel w=45n l=45n
RRAM_r023_c018 (n_r023_c018 bl018) resistor r=1meg
MSEL_r023_c019 (n_r023_c019 vdd wl023 wl023) nsel w=45n l=45n
RRAM_r023_c019 (n_r023_c019 bl019) resistor r=1k
MSEL_r023_c020 (n_r023_c020 vdd wl023 wl023) nsel w=45n l=45n
RRAM_r023_c020 (n_r023_c020 bl020) resistor r=1meg
MSEL_r023_c021 (n_r023_c021 vdd wl023 wl023) nsel w=45n l=45n
RRAM_r023_c021 (n_r023_c021 bl021) resistor r=1meg
MSEL_r023_c022 (n_r023_c022 vdd wl023 wl023) nsel w=45n l=45n
RRAM_r023_c022 (n_r023_c022 bl022) resistor r=1meg
MSEL_r023_c023 (n_r023_c023 vdd wl023 wl023) nsel w=45n l=45n
RRAM_r023_c023 (n_r023_c023 bl023) resistor r=1k
MSEL_r023_c024 (n_r023_c024 vdd wl023 wl023) nsel w=45n l=45n
RRAM_r023_c024 (n_r023_c024 bl024) resistor r=1k
MSEL_r023_c025 (n_r023_c025 vdd wl023 wl023) nsel w=45n l=45n
RRAM_r023_c025 (n_r023_c025 bl025) resistor r=1meg
MSEL_r023_c026 (n_r023_c026 vdd wl023 wl023) nsel w=45n l=45n
RRAM_r023_c026 (n_r023_c026 bl026) resistor r=1meg
MSEL_r023_c027 (n_r023_c027 vdd wl023 wl023) nsel w=45n l=45n
RRAM_r023_c027 (n_r023_c027 bl027) resistor r=1k
MSEL_r023_c028 (n_r023_c028 vdd wl023 wl023) nsel w=45n l=45n
RRAM_r023_c028 (n_r023_c028 bl028) resistor r=1k
MSEL_r023_c029 (n_r023_c029 vdd wl023 wl023) nsel w=45n l=45n
RRAM_r023_c029 (n_r023_c029 bl029) resistor r=1meg
MSEL_r023_c030 (n_r023_c030 vdd wl023 wl023) nsel w=45n l=45n
RRAM_r023_c030 (n_r023_c030 bl030) resistor r=1k
MSEL_r023_c031 (n_r023_c031 vdd wl023 wl023) nsel w=45n l=45n
RRAM_r023_c031 (n_r023_c031 bl031) resistor r=1meg
MSEL_r024_c000 (n_r024_c000 vdd wl024 wl024) nsel w=45n l=45n
RRAM_r024_c000 (n_r024_c000 bl000) resistor r=1k
MSEL_r024_c001 (n_r024_c001 vdd wl024 wl024) nsel w=45n l=45n
RRAM_r024_c001 (n_r024_c001 bl001) resistor r=1meg
MSEL_r024_c002 (n_r024_c002 vdd wl024 wl024) nsel w=45n l=45n
RRAM_r024_c002 (n_r024_c002 bl002) resistor r=1meg
MSEL_r024_c003 (n_r024_c003 vdd wl024 wl024) nsel w=45n l=45n
RRAM_r024_c003 (n_r024_c003 bl003) resistor r=1k
MSEL_r024_c004 (n_r024_c004 vdd wl024 wl024) nsel w=45n l=45n
RRAM_r024_c004 (n_r024_c004 bl004) resistor r=1meg
MSEL_r024_c005 (n_r024_c005 vdd wl024 wl024) nsel w=45n l=45n
RRAM_r024_c005 (n_r024_c005 bl005) resistor r=1k
MSEL_r024_c006 (n_r024_c006 vdd wl024 wl024) nsel w=45n l=45n
RRAM_r024_c006 (n_r024_c006 bl006) resistor r=1k
MSEL_r024_c007 (n_r024_c007 vdd wl024 wl024) nsel w=45n l=45n
RRAM_r024_c007 (n_r024_c007 bl007) resistor r=1meg
MSEL_r024_c008 (n_r024_c008 vdd wl024 wl024) nsel w=45n l=45n
RRAM_r024_c008 (n_r024_c008 bl008) resistor r=1k
MSEL_r024_c009 (n_r024_c009 vdd wl024 wl024) nsel w=45n l=45n
RRAM_r024_c009 (n_r024_c009 bl009) resistor r=1meg
MSEL_r024_c010 (n_r024_c010 vdd wl024 wl024) nsel w=45n l=45n
RRAM_r024_c010 (n_r024_c010 bl010) resistor r=1k
MSEL_r024_c011 (n_r024_c011 vdd wl024 wl024) nsel w=45n l=45n
RRAM_r024_c011 (n_r024_c011 bl011) resistor r=1k
MSEL_r024_c012 (n_r024_c012 vdd wl024 wl024) nsel w=45n l=45n
RRAM_r024_c012 (n_r024_c012 bl012) resistor r=1k
MSEL_r024_c013 (n_r024_c013 vdd wl024 wl024) nsel w=45n l=45n
RRAM_r024_c013 (n_r024_c013 bl013) resistor r=1k
MSEL_r024_c014 (n_r024_c014 vdd wl024 wl024) nsel w=45n l=45n
RRAM_r024_c014 (n_r024_c014 bl014) resistor r=1k
MSEL_r024_c015 (n_r024_c015 vdd wl024 wl024) nsel w=45n l=45n
RRAM_r024_c015 (n_r024_c015 bl015) resistor r=1k
MSEL_r024_c016 (n_r024_c016 vdd wl024 wl024) nsel w=45n l=45n
RRAM_r024_c016 (n_r024_c016 bl016) resistor r=1meg
MSEL_r024_c017 (n_r024_c017 vdd wl024 wl024) nsel w=45n l=45n
RRAM_r024_c017 (n_r024_c017 bl017) resistor r=1k
MSEL_r024_c018 (n_r024_c018 vdd wl024 wl024) nsel w=45n l=45n
RRAM_r024_c018 (n_r024_c018 bl018) resistor r=1meg
MSEL_r024_c019 (n_r024_c019 vdd wl024 wl024) nsel w=45n l=45n
RRAM_r024_c019 (n_r024_c019 bl019) resistor r=1meg
MSEL_r024_c020 (n_r024_c020 vdd wl024 wl024) nsel w=45n l=45n
RRAM_r024_c020 (n_r024_c020 bl020) resistor r=1meg
MSEL_r024_c021 (n_r024_c021 vdd wl024 wl024) nsel w=45n l=45n
RRAM_r024_c021 (n_r024_c021 bl021) resistor r=1meg
MSEL_r024_c022 (n_r024_c022 vdd wl024 wl024) nsel w=45n l=45n
RRAM_r024_c022 (n_r024_c022 bl022) resistor r=1meg
MSEL_r024_c023 (n_r024_c023 vdd wl024 wl024) nsel w=45n l=45n
RRAM_r024_c023 (n_r024_c023 bl023) resistor r=1meg
MSEL_r024_c024 (n_r024_c024 vdd wl024 wl024) nsel w=45n l=45n
RRAM_r024_c024 (n_r024_c024 bl024) resistor r=1meg
MSEL_r024_c025 (n_r024_c025 vdd wl024 wl024) nsel w=45n l=45n
RRAM_r024_c025 (n_r024_c025 bl025) resistor r=1k
MSEL_r024_c026 (n_r024_c026 vdd wl024 wl024) nsel w=45n l=45n
RRAM_r024_c026 (n_r024_c026 bl026) resistor r=1meg
MSEL_r024_c027 (n_r024_c027 vdd wl024 wl024) nsel w=45n l=45n
RRAM_r024_c027 (n_r024_c027 bl027) resistor r=1meg
MSEL_r024_c028 (n_r024_c028 vdd wl024 wl024) nsel w=45n l=45n
RRAM_r024_c028 (n_r024_c028 bl028) resistor r=1k
MSEL_r024_c029 (n_r024_c029 vdd wl024 wl024) nsel w=45n l=45n
RRAM_r024_c029 (n_r024_c029 bl029) resistor r=1k
MSEL_r024_c030 (n_r024_c030 vdd wl024 wl024) nsel w=45n l=45n
RRAM_r024_c030 (n_r024_c030 bl030) resistor r=1k
MSEL_r024_c031 (n_r024_c031 vdd wl024 wl024) nsel w=45n l=45n
RRAM_r024_c031 (n_r024_c031 bl031) resistor r=1k
MSEL_r025_c000 (n_r025_c000 vdd wl025 wl025) nsel w=45n l=45n
RRAM_r025_c000 (n_r025_c000 bl000) resistor r=1k
MSEL_r025_c001 (n_r025_c001 vdd wl025 wl025) nsel w=45n l=45n
RRAM_r025_c001 (n_r025_c001 bl001) resistor r=1k
MSEL_r025_c002 (n_r025_c002 vdd wl025 wl025) nsel w=45n l=45n
RRAM_r025_c002 (n_r025_c002 bl002) resistor r=1meg
MSEL_r025_c003 (n_r025_c003 vdd wl025 wl025) nsel w=45n l=45n
RRAM_r025_c003 (n_r025_c003 bl003) resistor r=1k
MSEL_r025_c004 (n_r025_c004 vdd wl025 wl025) nsel w=45n l=45n
RRAM_r025_c004 (n_r025_c004 bl004) resistor r=1k
MSEL_r025_c005 (n_r025_c005 vdd wl025 wl025) nsel w=45n l=45n
RRAM_r025_c005 (n_r025_c005 bl005) resistor r=1meg
MSEL_r025_c006 (n_r025_c006 vdd wl025 wl025) nsel w=45n l=45n
RRAM_r025_c006 (n_r025_c006 bl006) resistor r=1k
MSEL_r025_c007 (n_r025_c007 vdd wl025 wl025) nsel w=45n l=45n
RRAM_r025_c007 (n_r025_c007 bl007) resistor r=1k
MSEL_r025_c008 (n_r025_c008 vdd wl025 wl025) nsel w=45n l=45n
RRAM_r025_c008 (n_r025_c008 bl008) resistor r=1k
MSEL_r025_c009 (n_r025_c009 vdd wl025 wl025) nsel w=45n l=45n
RRAM_r025_c009 (n_r025_c009 bl009) resistor r=1k
MSEL_r025_c010 (n_r025_c010 vdd wl025 wl025) nsel w=45n l=45n
RRAM_r025_c010 (n_r025_c010 bl010) resistor r=1k
MSEL_r025_c011 (n_r025_c011 vdd wl025 wl025) nsel w=45n l=45n
RRAM_r025_c011 (n_r025_c011 bl011) resistor r=1k
MSEL_r025_c012 (n_r025_c012 vdd wl025 wl025) nsel w=45n l=45n
RRAM_r025_c012 (n_r025_c012 bl012) resistor r=1k
MSEL_r025_c013 (n_r025_c013 vdd wl025 wl025) nsel w=45n l=45n
RRAM_r025_c013 (n_r025_c013 bl013) resistor r=1k
MSEL_r025_c014 (n_r025_c014 vdd wl025 wl025) nsel w=45n l=45n
RRAM_r025_c014 (n_r025_c014 bl014) resistor r=1meg
MSEL_r025_c015 (n_r025_c015 vdd wl025 wl025) nsel w=45n l=45n
RRAM_r025_c015 (n_r025_c015 bl015) resistor r=1k
MSEL_r025_c016 (n_r025_c016 vdd wl025 wl025) nsel w=45n l=45n
RRAM_r025_c016 (n_r025_c016 bl016) resistor r=1meg
MSEL_r025_c017 (n_r025_c017 vdd wl025 wl025) nsel w=45n l=45n
RRAM_r025_c017 (n_r025_c017 bl017) resistor r=1k
MSEL_r025_c018 (n_r025_c018 vdd wl025 wl025) nsel w=45n l=45n
RRAM_r025_c018 (n_r025_c018 bl018) resistor r=1meg
MSEL_r025_c019 (n_r025_c019 vdd wl025 wl025) nsel w=45n l=45n
RRAM_r025_c019 (n_r025_c019 bl019) resistor r=1k
MSEL_r025_c020 (n_r025_c020 vdd wl025 wl025) nsel w=45n l=45n
RRAM_r025_c020 (n_r025_c020 bl020) resistor r=1meg
MSEL_r025_c021 (n_r025_c021 vdd wl025 wl025) nsel w=45n l=45n
RRAM_r025_c021 (n_r025_c021 bl021) resistor r=1meg
MSEL_r025_c022 (n_r025_c022 vdd wl025 wl025) nsel w=45n l=45n
RRAM_r025_c022 (n_r025_c022 bl022) resistor r=1meg
MSEL_r025_c023 (n_r025_c023 vdd wl025 wl025) nsel w=45n l=45n
RRAM_r025_c023 (n_r025_c023 bl023) resistor r=1k
MSEL_r025_c024 (n_r025_c024 vdd wl025 wl025) nsel w=45n l=45n
RRAM_r025_c024 (n_r025_c024 bl024) resistor r=1meg
MSEL_r025_c025 (n_r025_c025 vdd wl025 wl025) nsel w=45n l=45n
RRAM_r025_c025 (n_r025_c025 bl025) resistor r=1meg
MSEL_r025_c026 (n_r025_c026 vdd wl025 wl025) nsel w=45n l=45n
RRAM_r025_c026 (n_r025_c026 bl026) resistor r=1k
MSEL_r025_c027 (n_r025_c027 vdd wl025 wl025) nsel w=45n l=45n
RRAM_r025_c027 (n_r025_c027 bl027) resistor r=1meg
MSEL_r025_c028 (n_r025_c028 vdd wl025 wl025) nsel w=45n l=45n
RRAM_r025_c028 (n_r025_c028 bl028) resistor r=1k
MSEL_r025_c029 (n_r025_c029 vdd wl025 wl025) nsel w=45n l=45n
RRAM_r025_c029 (n_r025_c029 bl029) resistor r=1k
MSEL_r025_c030 (n_r025_c030 vdd wl025 wl025) nsel w=45n l=45n
RRAM_r025_c030 (n_r025_c030 bl030) resistor r=1meg
MSEL_r025_c031 (n_r025_c031 vdd wl025 wl025) nsel w=45n l=45n
RRAM_r025_c031 (n_r025_c031 bl031) resistor r=1meg
MSEL_r026_c000 (n_r026_c000 vdd wl026 wl026) nsel w=45n l=45n
RRAM_r026_c000 (n_r026_c000 bl000) resistor r=1meg
MSEL_r026_c001 (n_r026_c001 vdd wl026 wl026) nsel w=45n l=45n
RRAM_r026_c001 (n_r026_c001 bl001) resistor r=1meg
MSEL_r026_c002 (n_r026_c002 vdd wl026 wl026) nsel w=45n l=45n
RRAM_r026_c002 (n_r026_c002 bl002) resistor r=1meg
MSEL_r026_c003 (n_r026_c003 vdd wl026 wl026) nsel w=45n l=45n
RRAM_r026_c003 (n_r026_c003 bl003) resistor r=1meg
MSEL_r026_c004 (n_r026_c004 vdd wl026 wl026) nsel w=45n l=45n
RRAM_r026_c004 (n_r026_c004 bl004) resistor r=1k
MSEL_r026_c005 (n_r026_c005 vdd wl026 wl026) nsel w=45n l=45n
RRAM_r026_c005 (n_r026_c005 bl005) resistor r=1meg
MSEL_r026_c006 (n_r026_c006 vdd wl026 wl026) nsel w=45n l=45n
RRAM_r026_c006 (n_r026_c006 bl006) resistor r=1meg
MSEL_r026_c007 (n_r026_c007 vdd wl026 wl026) nsel w=45n l=45n
RRAM_r026_c007 (n_r026_c007 bl007) resistor r=1meg
MSEL_r026_c008 (n_r026_c008 vdd wl026 wl026) nsel w=45n l=45n
RRAM_r026_c008 (n_r026_c008 bl008) resistor r=1k
MSEL_r026_c009 (n_r026_c009 vdd wl026 wl026) nsel w=45n l=45n
RRAM_r026_c009 (n_r026_c009 bl009) resistor r=1k
MSEL_r026_c010 (n_r026_c010 vdd wl026 wl026) nsel w=45n l=45n
RRAM_r026_c010 (n_r026_c010 bl010) resistor r=1meg
MSEL_r026_c011 (n_r026_c011 vdd wl026 wl026) nsel w=45n l=45n
RRAM_r026_c011 (n_r026_c011 bl011) resistor r=1k
MSEL_r026_c012 (n_r026_c012 vdd wl026 wl026) nsel w=45n l=45n
RRAM_r026_c012 (n_r026_c012 bl012) resistor r=1k
MSEL_r026_c013 (n_r026_c013 vdd wl026 wl026) nsel w=45n l=45n
RRAM_r026_c013 (n_r026_c013 bl013) resistor r=1k
MSEL_r026_c014 (n_r026_c014 vdd wl026 wl026) nsel w=45n l=45n
RRAM_r026_c014 (n_r026_c014 bl014) resistor r=1k
MSEL_r026_c015 (n_r026_c015 vdd wl026 wl026) nsel w=45n l=45n
RRAM_r026_c015 (n_r026_c015 bl015) resistor r=1k
MSEL_r026_c016 (n_r026_c016 vdd wl026 wl026) nsel w=45n l=45n
RRAM_r026_c016 (n_r026_c016 bl016) resistor r=1k
MSEL_r026_c017 (n_r026_c017 vdd wl026 wl026) nsel w=45n l=45n
RRAM_r026_c017 (n_r026_c017 bl017) resistor r=1k
MSEL_r026_c018 (n_r026_c018 vdd wl026 wl026) nsel w=45n l=45n
RRAM_r026_c018 (n_r026_c018 bl018) resistor r=1k
MSEL_r026_c019 (n_r026_c019 vdd wl026 wl026) nsel w=45n l=45n
RRAM_r026_c019 (n_r026_c019 bl019) resistor r=1k
MSEL_r026_c020 (n_r026_c020 vdd wl026 wl026) nsel w=45n l=45n
RRAM_r026_c020 (n_r026_c020 bl020) resistor r=1meg
MSEL_r026_c021 (n_r026_c021 vdd wl026 wl026) nsel w=45n l=45n
RRAM_r026_c021 (n_r026_c021 bl021) resistor r=1k
MSEL_r026_c022 (n_r026_c022 vdd wl026 wl026) nsel w=45n l=45n
RRAM_r026_c022 (n_r026_c022 bl022) resistor r=1k
MSEL_r026_c023 (n_r026_c023 vdd wl026 wl026) nsel w=45n l=45n
RRAM_r026_c023 (n_r026_c023 bl023) resistor r=1k
MSEL_r026_c024 (n_r026_c024 vdd wl026 wl026) nsel w=45n l=45n
RRAM_r026_c024 (n_r026_c024 bl024) resistor r=1meg
MSEL_r026_c025 (n_r026_c025 vdd wl026 wl026) nsel w=45n l=45n
RRAM_r026_c025 (n_r026_c025 bl025) resistor r=1k
MSEL_r026_c026 (n_r026_c026 vdd wl026 wl026) nsel w=45n l=45n
RRAM_r026_c026 (n_r026_c026 bl026) resistor r=1meg
MSEL_r026_c027 (n_r026_c027 vdd wl026 wl026) nsel w=45n l=45n
RRAM_r026_c027 (n_r026_c027 bl027) resistor r=1meg
MSEL_r026_c028 (n_r026_c028 vdd wl026 wl026) nsel w=45n l=45n
RRAM_r026_c028 (n_r026_c028 bl028) resistor r=1k
MSEL_r026_c029 (n_r026_c029 vdd wl026 wl026) nsel w=45n l=45n
RRAM_r026_c029 (n_r026_c029 bl029) resistor r=1meg
MSEL_r026_c030 (n_r026_c030 vdd wl026 wl026) nsel w=45n l=45n
RRAM_r026_c030 (n_r026_c030 bl030) resistor r=1k
MSEL_r026_c031 (n_r026_c031 vdd wl026 wl026) nsel w=45n l=45n
RRAM_r026_c031 (n_r026_c031 bl031) resistor r=1meg
MSEL_r027_c000 (n_r027_c000 vdd wl027 wl027) nsel w=45n l=45n
RRAM_r027_c000 (n_r027_c000 bl000) resistor r=1meg
MSEL_r027_c001 (n_r027_c001 vdd wl027 wl027) nsel w=45n l=45n
RRAM_r027_c001 (n_r027_c001 bl001) resistor r=1k
MSEL_r027_c002 (n_r027_c002 vdd wl027 wl027) nsel w=45n l=45n
RRAM_r027_c002 (n_r027_c002 bl002) resistor r=1meg
MSEL_r027_c003 (n_r027_c003 vdd wl027 wl027) nsel w=45n l=45n
RRAM_r027_c003 (n_r027_c003 bl003) resistor r=1meg
MSEL_r027_c004 (n_r027_c004 vdd wl027 wl027) nsel w=45n l=45n
RRAM_r027_c004 (n_r027_c004 bl004) resistor r=1meg
MSEL_r027_c005 (n_r027_c005 vdd wl027 wl027) nsel w=45n l=45n
RRAM_r027_c005 (n_r027_c005 bl005) resistor r=1k
MSEL_r027_c006 (n_r027_c006 vdd wl027 wl027) nsel w=45n l=45n
RRAM_r027_c006 (n_r027_c006 bl006) resistor r=1k
MSEL_r027_c007 (n_r027_c007 vdd wl027 wl027) nsel w=45n l=45n
RRAM_r027_c007 (n_r027_c007 bl007) resistor r=1k
MSEL_r027_c008 (n_r027_c008 vdd wl027 wl027) nsel w=45n l=45n
RRAM_r027_c008 (n_r027_c008 bl008) resistor r=1k
MSEL_r027_c009 (n_r027_c009 vdd wl027 wl027) nsel w=45n l=45n
RRAM_r027_c009 (n_r027_c009 bl009) resistor r=1k
MSEL_r027_c010 (n_r027_c010 vdd wl027 wl027) nsel w=45n l=45n
RRAM_r027_c010 (n_r027_c010 bl010) resistor r=1k
MSEL_r027_c011 (n_r027_c011 vdd wl027 wl027) nsel w=45n l=45n
RRAM_r027_c011 (n_r027_c011 bl011) resistor r=1meg
MSEL_r027_c012 (n_r027_c012 vdd wl027 wl027) nsel w=45n l=45n
RRAM_r027_c012 (n_r027_c012 bl012) resistor r=1k
MSEL_r027_c013 (n_r027_c013 vdd wl027 wl027) nsel w=45n l=45n
RRAM_r027_c013 (n_r027_c013 bl013) resistor r=1meg
MSEL_r027_c014 (n_r027_c014 vdd wl027 wl027) nsel w=45n l=45n
RRAM_r027_c014 (n_r027_c014 bl014) resistor r=1meg
MSEL_r027_c015 (n_r027_c015 vdd wl027 wl027) nsel w=45n l=45n
RRAM_r027_c015 (n_r027_c015 bl015) resistor r=1meg
MSEL_r027_c016 (n_r027_c016 vdd wl027 wl027) nsel w=45n l=45n
RRAM_r027_c016 (n_r027_c016 bl016) resistor r=1k
MSEL_r027_c017 (n_r027_c017 vdd wl027 wl027) nsel w=45n l=45n
RRAM_r027_c017 (n_r027_c017 bl017) resistor r=1k
MSEL_r027_c018 (n_r027_c018 vdd wl027 wl027) nsel w=45n l=45n
RRAM_r027_c018 (n_r027_c018 bl018) resistor r=1meg
MSEL_r027_c019 (n_r027_c019 vdd wl027 wl027) nsel w=45n l=45n
RRAM_r027_c019 (n_r027_c019 bl019) resistor r=1k
MSEL_r027_c020 (n_r027_c020 vdd wl027 wl027) nsel w=45n l=45n
RRAM_r027_c020 (n_r027_c020 bl020) resistor r=1meg
MSEL_r027_c021 (n_r027_c021 vdd wl027 wl027) nsel w=45n l=45n
RRAM_r027_c021 (n_r027_c021 bl021) resistor r=1meg
MSEL_r027_c022 (n_r027_c022 vdd wl027 wl027) nsel w=45n l=45n
RRAM_r027_c022 (n_r027_c022 bl022) resistor r=1k
MSEL_r027_c023 (n_r027_c023 vdd wl027 wl027) nsel w=45n l=45n
RRAM_r027_c023 (n_r027_c023 bl023) resistor r=1k
MSEL_r027_c024 (n_r027_c024 vdd wl027 wl027) nsel w=45n l=45n
RRAM_r027_c024 (n_r027_c024 bl024) resistor r=1k
MSEL_r027_c025 (n_r027_c025 vdd wl027 wl027) nsel w=45n l=45n
RRAM_r027_c025 (n_r027_c025 bl025) resistor r=1k
MSEL_r027_c026 (n_r027_c026 vdd wl027 wl027) nsel w=45n l=45n
RRAM_r027_c026 (n_r027_c026 bl026) resistor r=1meg
MSEL_r027_c027 (n_r027_c027 vdd wl027 wl027) nsel w=45n l=45n
RRAM_r027_c027 (n_r027_c027 bl027) resistor r=1meg
MSEL_r027_c028 (n_r027_c028 vdd wl027 wl027) nsel w=45n l=45n
RRAM_r027_c028 (n_r027_c028 bl028) resistor r=1meg
MSEL_r027_c029 (n_r027_c029 vdd wl027 wl027) nsel w=45n l=45n
RRAM_r027_c029 (n_r027_c029 bl029) resistor r=1k
MSEL_r027_c030 (n_r027_c030 vdd wl027 wl027) nsel w=45n l=45n
RRAM_r027_c030 (n_r027_c030 bl030) resistor r=1meg
MSEL_r027_c031 (n_r027_c031 vdd wl027 wl027) nsel w=45n l=45n
RRAM_r027_c031 (n_r027_c031 bl031) resistor r=1meg
MSEL_r028_c000 (n_r028_c000 vdd wl028 wl028) nsel w=45n l=45n
RRAM_r028_c000 (n_r028_c000 bl000) resistor r=1meg
MSEL_r028_c001 (n_r028_c001 vdd wl028 wl028) nsel w=45n l=45n
RRAM_r028_c001 (n_r028_c001 bl001) resistor r=1k
MSEL_r028_c002 (n_r028_c002 vdd wl028 wl028) nsel w=45n l=45n
RRAM_r028_c002 (n_r028_c002 bl002) resistor r=1meg
MSEL_r028_c003 (n_r028_c003 vdd wl028 wl028) nsel w=45n l=45n
RRAM_r028_c003 (n_r028_c003 bl003) resistor r=1meg
MSEL_r028_c004 (n_r028_c004 vdd wl028 wl028) nsel w=45n l=45n
RRAM_r028_c004 (n_r028_c004 bl004) resistor r=1k
MSEL_r028_c005 (n_r028_c005 vdd wl028 wl028) nsel w=45n l=45n
RRAM_r028_c005 (n_r028_c005 bl005) resistor r=1k
MSEL_r028_c006 (n_r028_c006 vdd wl028 wl028) nsel w=45n l=45n
RRAM_r028_c006 (n_r028_c006 bl006) resistor r=1k
MSEL_r028_c007 (n_r028_c007 vdd wl028 wl028) nsel w=45n l=45n
RRAM_r028_c007 (n_r028_c007 bl007) resistor r=1meg
MSEL_r028_c008 (n_r028_c008 vdd wl028 wl028) nsel w=45n l=45n
RRAM_r028_c008 (n_r028_c008 bl008) resistor r=1meg
MSEL_r028_c009 (n_r028_c009 vdd wl028 wl028) nsel w=45n l=45n
RRAM_r028_c009 (n_r028_c009 bl009) resistor r=1meg
MSEL_r028_c010 (n_r028_c010 vdd wl028 wl028) nsel w=45n l=45n
RRAM_r028_c010 (n_r028_c010 bl010) resistor r=1k
MSEL_r028_c011 (n_r028_c011 vdd wl028 wl028) nsel w=45n l=45n
RRAM_r028_c011 (n_r028_c011 bl011) resistor r=1k
MSEL_r028_c012 (n_r028_c012 vdd wl028 wl028) nsel w=45n l=45n
RRAM_r028_c012 (n_r028_c012 bl012) resistor r=1k
MSEL_r028_c013 (n_r028_c013 vdd wl028 wl028) nsel w=45n l=45n
RRAM_r028_c013 (n_r028_c013 bl013) resistor r=1k
MSEL_r028_c014 (n_r028_c014 vdd wl028 wl028) nsel w=45n l=45n
RRAM_r028_c014 (n_r028_c014 bl014) resistor r=1meg
MSEL_r028_c015 (n_r028_c015 vdd wl028 wl028) nsel w=45n l=45n
RRAM_r028_c015 (n_r028_c015 bl015) resistor r=1meg
MSEL_r028_c016 (n_r028_c016 vdd wl028 wl028) nsel w=45n l=45n
RRAM_r028_c016 (n_r028_c016 bl016) resistor r=1k
MSEL_r028_c017 (n_r028_c017 vdd wl028 wl028) nsel w=45n l=45n
RRAM_r028_c017 (n_r028_c017 bl017) resistor r=1k
MSEL_r028_c018 (n_r028_c018 vdd wl028 wl028) nsel w=45n l=45n
RRAM_r028_c018 (n_r028_c018 bl018) resistor r=1k
MSEL_r028_c019 (n_r028_c019 vdd wl028 wl028) nsel w=45n l=45n
RRAM_r028_c019 (n_r028_c019 bl019) resistor r=1k
MSEL_r028_c020 (n_r028_c020 vdd wl028 wl028) nsel w=45n l=45n
RRAM_r028_c020 (n_r028_c020 bl020) resistor r=1k
MSEL_r028_c021 (n_r028_c021 vdd wl028 wl028) nsel w=45n l=45n
RRAM_r028_c021 (n_r028_c021 bl021) resistor r=1k
MSEL_r028_c022 (n_r028_c022 vdd wl028 wl028) nsel w=45n l=45n
RRAM_r028_c022 (n_r028_c022 bl022) resistor r=1meg
MSEL_r028_c023 (n_r028_c023 vdd wl028 wl028) nsel w=45n l=45n
RRAM_r028_c023 (n_r028_c023 bl023) resistor r=1meg
MSEL_r028_c024 (n_r028_c024 vdd wl028 wl028) nsel w=45n l=45n
RRAM_r028_c024 (n_r028_c024 bl024) resistor r=1meg
MSEL_r028_c025 (n_r028_c025 vdd wl028 wl028) nsel w=45n l=45n
RRAM_r028_c025 (n_r028_c025 bl025) resistor r=1meg
MSEL_r028_c026 (n_r028_c026 vdd wl028 wl028) nsel w=45n l=45n
RRAM_r028_c026 (n_r028_c026 bl026) resistor r=1k
MSEL_r028_c027 (n_r028_c027 vdd wl028 wl028) nsel w=45n l=45n
RRAM_r028_c027 (n_r028_c027 bl027) resistor r=1meg
MSEL_r028_c028 (n_r028_c028 vdd wl028 wl028) nsel w=45n l=45n
RRAM_r028_c028 (n_r028_c028 bl028) resistor r=1meg
MSEL_r028_c029 (n_r028_c029 vdd wl028 wl028) nsel w=45n l=45n
RRAM_r028_c029 (n_r028_c029 bl029) resistor r=1meg
MSEL_r028_c030 (n_r028_c030 vdd wl028 wl028) nsel w=45n l=45n
RRAM_r028_c030 (n_r028_c030 bl030) resistor r=1meg
MSEL_r028_c031 (n_r028_c031 vdd wl028 wl028) nsel w=45n l=45n
RRAM_r028_c031 (n_r028_c031 bl031) resistor r=1k
MSEL_r029_c000 (n_r029_c000 vdd wl029 wl029) nsel w=45n l=45n
RRAM_r029_c000 (n_r029_c000 bl000) resistor r=1meg
MSEL_r029_c001 (n_r029_c001 vdd wl029 wl029) nsel w=45n l=45n
RRAM_r029_c001 (n_r029_c001 bl001) resistor r=1k
MSEL_r029_c002 (n_r029_c002 vdd wl029 wl029) nsel w=45n l=45n
RRAM_r029_c002 (n_r029_c002 bl002) resistor r=1meg
MSEL_r029_c003 (n_r029_c003 vdd wl029 wl029) nsel w=45n l=45n
RRAM_r029_c003 (n_r029_c003 bl003) resistor r=1meg
MSEL_r029_c004 (n_r029_c004 vdd wl029 wl029) nsel w=45n l=45n
RRAM_r029_c004 (n_r029_c004 bl004) resistor r=1meg
MSEL_r029_c005 (n_r029_c005 vdd wl029 wl029) nsel w=45n l=45n
RRAM_r029_c005 (n_r029_c005 bl005) resistor r=1k
MSEL_r029_c006 (n_r029_c006 vdd wl029 wl029) nsel w=45n l=45n
RRAM_r029_c006 (n_r029_c006 bl006) resistor r=1k
MSEL_r029_c007 (n_r029_c007 vdd wl029 wl029) nsel w=45n l=45n
RRAM_r029_c007 (n_r029_c007 bl007) resistor r=1k
MSEL_r029_c008 (n_r029_c008 vdd wl029 wl029) nsel w=45n l=45n
RRAM_r029_c008 (n_r029_c008 bl008) resistor r=1meg
MSEL_r029_c009 (n_r029_c009 vdd wl029 wl029) nsel w=45n l=45n
RRAM_r029_c009 (n_r029_c009 bl009) resistor r=1k
MSEL_r029_c010 (n_r029_c010 vdd wl029 wl029) nsel w=45n l=45n
RRAM_r029_c010 (n_r029_c010 bl010) resistor r=1k
MSEL_r029_c011 (n_r029_c011 vdd wl029 wl029) nsel w=45n l=45n
RRAM_r029_c011 (n_r029_c011 bl011) resistor r=1meg
MSEL_r029_c012 (n_r029_c012 vdd wl029 wl029) nsel w=45n l=45n
RRAM_r029_c012 (n_r029_c012 bl012) resistor r=1meg
MSEL_r029_c013 (n_r029_c013 vdd wl029 wl029) nsel w=45n l=45n
RRAM_r029_c013 (n_r029_c013 bl013) resistor r=1meg
MSEL_r029_c014 (n_r029_c014 vdd wl029 wl029) nsel w=45n l=45n
RRAM_r029_c014 (n_r029_c014 bl014) resistor r=1k
MSEL_r029_c015 (n_r029_c015 vdd wl029 wl029) nsel w=45n l=45n
RRAM_r029_c015 (n_r029_c015 bl015) resistor r=1k
MSEL_r029_c016 (n_r029_c016 vdd wl029 wl029) nsel w=45n l=45n
RRAM_r029_c016 (n_r029_c016 bl016) resistor r=1k
MSEL_r029_c017 (n_r029_c017 vdd wl029 wl029) nsel w=45n l=45n
RRAM_r029_c017 (n_r029_c017 bl017) resistor r=1meg
MSEL_r029_c018 (n_r029_c018 vdd wl029 wl029) nsel w=45n l=45n
RRAM_r029_c018 (n_r029_c018 bl018) resistor r=1k
MSEL_r029_c019 (n_r029_c019 vdd wl029 wl029) nsel w=45n l=45n
RRAM_r029_c019 (n_r029_c019 bl019) resistor r=1k
MSEL_r029_c020 (n_r029_c020 vdd wl029 wl029) nsel w=45n l=45n
RRAM_r029_c020 (n_r029_c020 bl020) resistor r=1meg
MSEL_r029_c021 (n_r029_c021 vdd wl029 wl029) nsel w=45n l=45n
RRAM_r029_c021 (n_r029_c021 bl021) resistor r=1k
MSEL_r029_c022 (n_r029_c022 vdd wl029 wl029) nsel w=45n l=45n
RRAM_r029_c022 (n_r029_c022 bl022) resistor r=1k
MSEL_r029_c023 (n_r029_c023 vdd wl029 wl029) nsel w=45n l=45n
RRAM_r029_c023 (n_r029_c023 bl023) resistor r=1meg
MSEL_r029_c024 (n_r029_c024 vdd wl029 wl029) nsel w=45n l=45n
RRAM_r029_c024 (n_r029_c024 bl024) resistor r=1meg
MSEL_r029_c025 (n_r029_c025 vdd wl029 wl029) nsel w=45n l=45n
RRAM_r029_c025 (n_r029_c025 bl025) resistor r=1k
MSEL_r029_c026 (n_r029_c026 vdd wl029 wl029) nsel w=45n l=45n
RRAM_r029_c026 (n_r029_c026 bl026) resistor r=1meg
MSEL_r029_c027 (n_r029_c027 vdd wl029 wl029) nsel w=45n l=45n
RRAM_r029_c027 (n_r029_c027 bl027) resistor r=1meg
MSEL_r029_c028 (n_r029_c028 vdd wl029 wl029) nsel w=45n l=45n
RRAM_r029_c028 (n_r029_c028 bl028) resistor r=1meg
MSEL_r029_c029 (n_r029_c029 vdd wl029 wl029) nsel w=45n l=45n
RRAM_r029_c029 (n_r029_c029 bl029) resistor r=1k
MSEL_r029_c030 (n_r029_c030 vdd wl029 wl029) nsel w=45n l=45n
RRAM_r029_c030 (n_r029_c030 bl030) resistor r=1meg
MSEL_r029_c031 (n_r029_c031 vdd wl029 wl029) nsel w=45n l=45n
RRAM_r029_c031 (n_r029_c031 bl031) resistor r=1meg
MSEL_r030_c000 (n_r030_c000 vdd wl030 wl030) nsel w=45n l=45n
RRAM_r030_c000 (n_r030_c000 bl000) resistor r=1k
MSEL_r030_c001 (n_r030_c001 vdd wl030 wl030) nsel w=45n l=45n
RRAM_r030_c001 (n_r030_c001 bl001) resistor r=1k
MSEL_r030_c002 (n_r030_c002 vdd wl030 wl030) nsel w=45n l=45n
RRAM_r030_c002 (n_r030_c002 bl002) resistor r=1k
MSEL_r030_c003 (n_r030_c003 vdd wl030 wl030) nsel w=45n l=45n
RRAM_r030_c003 (n_r030_c003 bl003) resistor r=1meg
MSEL_r030_c004 (n_r030_c004 vdd wl030 wl030) nsel w=45n l=45n
RRAM_r030_c004 (n_r030_c004 bl004) resistor r=1meg
MSEL_r030_c005 (n_r030_c005 vdd wl030 wl030) nsel w=45n l=45n
RRAM_r030_c005 (n_r030_c005 bl005) resistor r=1k
MSEL_r030_c006 (n_r030_c006 vdd wl030 wl030) nsel w=45n l=45n
RRAM_r030_c006 (n_r030_c006 bl006) resistor r=1meg
MSEL_r030_c007 (n_r030_c007 vdd wl030 wl030) nsel w=45n l=45n
RRAM_r030_c007 (n_r030_c007 bl007) resistor r=1meg
MSEL_r030_c008 (n_r030_c008 vdd wl030 wl030) nsel w=45n l=45n
RRAM_r030_c008 (n_r030_c008 bl008) resistor r=1k
MSEL_r030_c009 (n_r030_c009 vdd wl030 wl030) nsel w=45n l=45n
RRAM_r030_c009 (n_r030_c009 bl009) resistor r=1k
MSEL_r030_c010 (n_r030_c010 vdd wl030 wl030) nsel w=45n l=45n
RRAM_r030_c010 (n_r030_c010 bl010) resistor r=1meg
MSEL_r030_c011 (n_r030_c011 vdd wl030 wl030) nsel w=45n l=45n
RRAM_r030_c011 (n_r030_c011 bl011) resistor r=1k
MSEL_r030_c012 (n_r030_c012 vdd wl030 wl030) nsel w=45n l=45n
RRAM_r030_c012 (n_r030_c012 bl012) resistor r=1meg
MSEL_r030_c013 (n_r030_c013 vdd wl030 wl030) nsel w=45n l=45n
RRAM_r030_c013 (n_r030_c013 bl013) resistor r=1meg
MSEL_r030_c014 (n_r030_c014 vdd wl030 wl030) nsel w=45n l=45n
RRAM_r030_c014 (n_r030_c014 bl014) resistor r=1k
MSEL_r030_c015 (n_r030_c015 vdd wl030 wl030) nsel w=45n l=45n
RRAM_r030_c015 (n_r030_c015 bl015) resistor r=1k
MSEL_r030_c016 (n_r030_c016 vdd wl030 wl030) nsel w=45n l=45n
RRAM_r030_c016 (n_r030_c016 bl016) resistor r=1k
MSEL_r030_c017 (n_r030_c017 vdd wl030 wl030) nsel w=45n l=45n
RRAM_r030_c017 (n_r030_c017 bl017) resistor r=1k
MSEL_r030_c018 (n_r030_c018 vdd wl030 wl030) nsel w=45n l=45n
RRAM_r030_c018 (n_r030_c018 bl018) resistor r=1meg
MSEL_r030_c019 (n_r030_c019 vdd wl030 wl030) nsel w=45n l=45n
RRAM_r030_c019 (n_r030_c019 bl019) resistor r=1meg
MSEL_r030_c020 (n_r030_c020 vdd wl030 wl030) nsel w=45n l=45n
RRAM_r030_c020 (n_r030_c020 bl020) resistor r=1meg
MSEL_r030_c021 (n_r030_c021 vdd wl030 wl030) nsel w=45n l=45n
RRAM_r030_c021 (n_r030_c021 bl021) resistor r=1meg
MSEL_r030_c022 (n_r030_c022 vdd wl030 wl030) nsel w=45n l=45n
RRAM_r030_c022 (n_r030_c022 bl022) resistor r=1k
MSEL_r030_c023 (n_r030_c023 vdd wl030 wl030) nsel w=45n l=45n
RRAM_r030_c023 (n_r030_c023 bl023) resistor r=1meg
MSEL_r030_c024 (n_r030_c024 vdd wl030 wl030) nsel w=45n l=45n
RRAM_r030_c024 (n_r030_c024 bl024) resistor r=1k
MSEL_r030_c025 (n_r030_c025 vdd wl030 wl030) nsel w=45n l=45n
RRAM_r030_c025 (n_r030_c025 bl025) resistor r=1meg
MSEL_r030_c026 (n_r030_c026 vdd wl030 wl030) nsel w=45n l=45n
RRAM_r030_c026 (n_r030_c026 bl026) resistor r=1meg
MSEL_r030_c027 (n_r030_c027 vdd wl030 wl030) nsel w=45n l=45n
RRAM_r030_c027 (n_r030_c027 bl027) resistor r=1k
MSEL_r030_c028 (n_r030_c028 vdd wl030 wl030) nsel w=45n l=45n
RRAM_r030_c028 (n_r030_c028 bl028) resistor r=1meg
MSEL_r030_c029 (n_r030_c029 vdd wl030 wl030) nsel w=45n l=45n
RRAM_r030_c029 (n_r030_c029 bl029) resistor r=1meg
MSEL_r030_c030 (n_r030_c030 vdd wl030 wl030) nsel w=45n l=45n
RRAM_r030_c030 (n_r030_c030 bl030) resistor r=1k
MSEL_r030_c031 (n_r030_c031 vdd wl030 wl030) nsel w=45n l=45n
RRAM_r030_c031 (n_r030_c031 bl031) resistor r=1meg
MSEL_r031_c000 (n_r031_c000 vdd wl031 wl031) nsel w=45n l=45n
RRAM_r031_c000 (n_r031_c000 bl000) resistor r=1meg
MSEL_r031_c001 (n_r031_c001 vdd wl031 wl031) nsel w=45n l=45n
RRAM_r031_c001 (n_r031_c001 bl001) resistor r=1k
MSEL_r031_c002 (n_r031_c002 vdd wl031 wl031) nsel w=45n l=45n
RRAM_r031_c002 (n_r031_c002 bl002) resistor r=1meg
MSEL_r031_c003 (n_r031_c003 vdd wl031 wl031) nsel w=45n l=45n
RRAM_r031_c003 (n_r031_c003 bl003) resistor r=1meg
MSEL_r031_c004 (n_r031_c004 vdd wl031 wl031) nsel w=45n l=45n
RRAM_r031_c004 (n_r031_c004 bl004) resistor r=1meg
MSEL_r031_c005 (n_r031_c005 vdd wl031 wl031) nsel w=45n l=45n
RRAM_r031_c005 (n_r031_c005 bl005) resistor r=1k
MSEL_r031_c006 (n_r031_c006 vdd wl031 wl031) nsel w=45n l=45n
RRAM_r031_c006 (n_r031_c006 bl006) resistor r=1k
MSEL_r031_c007 (n_r031_c007 vdd wl031 wl031) nsel w=45n l=45n
RRAM_r031_c007 (n_r031_c007 bl007) resistor r=1meg
MSEL_r031_c008 (n_r031_c008 vdd wl031 wl031) nsel w=45n l=45n
RRAM_r031_c008 (n_r031_c008 bl008) resistor r=1k
MSEL_r031_c009 (n_r031_c009 vdd wl031 wl031) nsel w=45n l=45n
RRAM_r031_c009 (n_r031_c009 bl009) resistor r=1meg
MSEL_r031_c010 (n_r031_c010 vdd wl031 wl031) nsel w=45n l=45n
RRAM_r031_c010 (n_r031_c010 bl010) resistor r=1meg
MSEL_r031_c011 (n_r031_c011 vdd wl031 wl031) nsel w=45n l=45n
RRAM_r031_c011 (n_r031_c011 bl011) resistor r=1meg
MSEL_r031_c012 (n_r031_c012 vdd wl031 wl031) nsel w=45n l=45n
RRAM_r031_c012 (n_r031_c012 bl012) resistor r=1k
MSEL_r031_c013 (n_r031_c013 vdd wl031 wl031) nsel w=45n l=45n
RRAM_r031_c013 (n_r031_c013 bl013) resistor r=1meg
MSEL_r031_c014 (n_r031_c014 vdd wl031 wl031) nsel w=45n l=45n
RRAM_r031_c014 (n_r031_c014 bl014) resistor r=1meg
MSEL_r031_c015 (n_r031_c015 vdd wl031 wl031) nsel w=45n l=45n
RRAM_r031_c015 (n_r031_c015 bl015) resistor r=1meg
MSEL_r031_c016 (n_r031_c016 vdd wl031 wl031) nsel w=45n l=45n
RRAM_r031_c016 (n_r031_c016 bl016) resistor r=1k
MSEL_r031_c017 (n_r031_c017 vdd wl031 wl031) nsel w=45n l=45n
RRAM_r031_c017 (n_r031_c017 bl017) resistor r=1meg
MSEL_r031_c018 (n_r031_c018 vdd wl031 wl031) nsel w=45n l=45n
RRAM_r031_c018 (n_r031_c018 bl018) resistor r=1k
MSEL_r031_c019 (n_r031_c019 vdd wl031 wl031) nsel w=45n l=45n
RRAM_r031_c019 (n_r031_c019 bl019) resistor r=1k
MSEL_r031_c020 (n_r031_c020 vdd wl031 wl031) nsel w=45n l=45n
RRAM_r031_c020 (n_r031_c020 bl020) resistor r=1k
MSEL_r031_c021 (n_r031_c021 vdd wl031 wl031) nsel w=45n l=45n
RRAM_r031_c021 (n_r031_c021 bl021) resistor r=1k
MSEL_r031_c022 (n_r031_c022 vdd wl031 wl031) nsel w=45n l=45n
RRAM_r031_c022 (n_r031_c022 bl022) resistor r=1k
MSEL_r031_c023 (n_r031_c023 vdd wl031 wl031) nsel w=45n l=45n
RRAM_r031_c023 (n_r031_c023 bl023) resistor r=1meg
MSEL_r031_c024 (n_r031_c024 vdd wl031 wl031) nsel w=45n l=45n
RRAM_r031_c024 (n_r031_c024 bl024) resistor r=1meg
MSEL_r031_c025 (n_r031_c025 vdd wl031 wl031) nsel w=45n l=45n
RRAM_r031_c025 (n_r031_c025 bl025) resistor r=1k
MSEL_r031_c026 (n_r031_c026 vdd wl031 wl031) nsel w=45n l=45n
RRAM_r031_c026 (n_r031_c026 bl026) resistor r=1meg
MSEL_r031_c027 (n_r031_c027 vdd wl031 wl031) nsel w=45n l=45n
RRAM_r031_c027 (n_r031_c027 bl027) resistor r=1meg
MSEL_r031_c028 (n_r031_c028 vdd wl031 wl031) nsel w=45n l=45n
RRAM_r031_c028 (n_r031_c028 bl028) resistor r=1k
MSEL_r031_c029 (n_r031_c029 vdd wl031 wl031) nsel w=45n l=45n
RRAM_r031_c029 (n_r031_c029 bl029) resistor r=1meg
MSEL_r031_c030 (n_r031_c030 vdd wl031 wl031) nsel w=45n l=45n
RRAM_r031_c030 (n_r031_c030 bl030) resistor r=1k
MSEL_r031_c031 (n_r031_c031 vdd wl031 wl031) nsel w=45n l=45n
RRAM_r031_c031 (n_r031_c031 bl031) resistor r=1meg
save bl000
save bl001
save bl002
save bl003
save bl004
save bl005
save bl006
save bl007
save bl008
save bl009
save bl010
save bl011
save bl012
save bl013
save bl014
save bl015
save bl016
save bl017
save bl018
save bl019
save bl020
save bl021
save bl022
save bl023
save bl024
save bl025
save bl026
save bl027
save bl028
save bl029
save bl030
save bl031
