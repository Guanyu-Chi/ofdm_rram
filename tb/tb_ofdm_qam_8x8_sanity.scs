// Coherent-demodulation testbench for 8x8 OFDM/QAM-RRAM MVM
// Every BL/carrier path uses BPF, phase-window verification demodulator, and RC integration.
simulator lang=spectre
include "../netlist/clean_8x8_crossbar_sanity.scs"

parameters rclosed_mix=1 ropen_mix=1G

VREFI_0 (ref_i_0 0) vsource type=sine freq=250000000 ampl=1 phase=90
VREFQ_0 (ref_q_0 0) vsource type=sine freq=250000000 ampl=1 phase=0
RREFI_0 (ref_i_0 0) resistor r=1G
RREFQ_0 (ref_q_0 0) resistor r=1G
VWIN_0_00 (win_0_00 0) vsource type=pulse val0=-1 val1=1 period=4.000000000000e-09 width=2.500000000000e-10 delay=0.000000000000e+00 rise=1p fall=1p
VWIN_0_01 (win_0_01 0) vsource type=pulse val0=-1 val1=1 period=4.000000000000e-09 width=2.500000000000e-10 delay=2.500000000000e-10 rise=1p fall=1p
VWIN_0_02 (win_0_02 0) vsource type=pulse val0=-1 val1=1 period=4.000000000000e-09 width=2.500000000000e-10 delay=5.000000000000e-10 rise=1p fall=1p
VWIN_0_03 (win_0_03 0) vsource type=pulse val0=-1 val1=1 period=4.000000000000e-09 width=2.500000000000e-10 delay=7.500000000000e-10 rise=1p fall=1p
VWIN_0_04 (win_0_04 0) vsource type=pulse val0=-1 val1=1 period=4.000000000000e-09 width=2.500000000000e-10 delay=1.000000000000e-09 rise=1p fall=1p
VWIN_0_05 (win_0_05 0) vsource type=pulse val0=-1 val1=1 period=4.000000000000e-09 width=2.500000000000e-10 delay=1.250000000000e-09 rise=1p fall=1p
VWIN_0_06 (win_0_06 0) vsource type=pulse val0=-1 val1=1 period=4.000000000000e-09 width=2.500000000000e-10 delay=1.500000000000e-09 rise=1p fall=1p
VWIN_0_07 (win_0_07 0) vsource type=pulse val0=-1 val1=1 period=4.000000000000e-09 width=2.500000000000e-10 delay=1.750000000000e-09 rise=1p fall=1p
VWIN_0_08 (win_0_08 0) vsource type=pulse val0=-1 val1=1 period=4.000000000000e-09 width=2.500000000000e-10 delay=2.000000000000e-09 rise=1p fall=1p
VWIN_0_09 (win_0_09 0) vsource type=pulse val0=-1 val1=1 period=4.000000000000e-09 width=2.500000000000e-10 delay=2.250000000000e-09 rise=1p fall=1p
VWIN_0_10 (win_0_10 0) vsource type=pulse val0=-1 val1=1 period=4.000000000000e-09 width=2.500000000000e-10 delay=2.500000000000e-09 rise=1p fall=1p
VWIN_0_11 (win_0_11 0) vsource type=pulse val0=-1 val1=1 period=4.000000000000e-09 width=2.500000000000e-10 delay=2.750000000000e-09 rise=1p fall=1p
VWIN_0_12 (win_0_12 0) vsource type=pulse val0=-1 val1=1 period=4.000000000000e-09 width=2.500000000000e-10 delay=3.000000000000e-09 rise=1p fall=1p
VWIN_0_13 (win_0_13 0) vsource type=pulse val0=-1 val1=1 period=4.000000000000e-09 width=2.500000000000e-10 delay=3.250000000000e-09 rise=1p fall=1p
VWIN_0_14 (win_0_14 0) vsource type=pulse val0=-1 val1=1 period=4.000000000000e-09 width=2.500000000000e-10 delay=3.500000000000e-09 rise=1p fall=1p
VWIN_0_15 (win_0_15 0) vsource type=pulse val0=-1 val1=1 period=4.000000000000e-09 width=2.500000000000e-10 delay=3.750000000000e-09 rise=1p fall=1p

VREFI_1 (ref_i_1 0) vsource type=sine freq=500000000 ampl=1 phase=90
VREFQ_1 (ref_q_1 0) vsource type=sine freq=500000000 ampl=1 phase=0
RREFI_1 (ref_i_1 0) resistor r=1G
RREFQ_1 (ref_q_1 0) resistor r=1G
VWIN_1_00 (win_1_00 0) vsource type=pulse val0=-1 val1=1 period=2.000000000000e-09 width=1.250000000000e-10 delay=0.000000000000e+00 rise=1p fall=1p
VWIN_1_01 (win_1_01 0) vsource type=pulse val0=-1 val1=1 period=2.000000000000e-09 width=1.250000000000e-10 delay=1.250000000000e-10 rise=1p fall=1p
VWIN_1_02 (win_1_02 0) vsource type=pulse val0=-1 val1=1 period=2.000000000000e-09 width=1.250000000000e-10 delay=2.500000000000e-10 rise=1p fall=1p
VWIN_1_03 (win_1_03 0) vsource type=pulse val0=-1 val1=1 period=2.000000000000e-09 width=1.250000000000e-10 delay=3.750000000000e-10 rise=1p fall=1p
VWIN_1_04 (win_1_04 0) vsource type=pulse val0=-1 val1=1 period=2.000000000000e-09 width=1.250000000000e-10 delay=5.000000000000e-10 rise=1p fall=1p
VWIN_1_05 (win_1_05 0) vsource type=pulse val0=-1 val1=1 period=2.000000000000e-09 width=1.250000000000e-10 delay=6.250000000000e-10 rise=1p fall=1p
VWIN_1_06 (win_1_06 0) vsource type=pulse val0=-1 val1=1 period=2.000000000000e-09 width=1.250000000000e-10 delay=7.500000000000e-10 rise=1p fall=1p
VWIN_1_07 (win_1_07 0) vsource type=pulse val0=-1 val1=1 period=2.000000000000e-09 width=1.250000000000e-10 delay=8.750000000000e-10 rise=1p fall=1p
VWIN_1_08 (win_1_08 0) vsource type=pulse val0=-1 val1=1 period=2.000000000000e-09 width=1.250000000000e-10 delay=1.000000000000e-09 rise=1p fall=1p
VWIN_1_09 (win_1_09 0) vsource type=pulse val0=-1 val1=1 period=2.000000000000e-09 width=1.250000000000e-10 delay=1.125000000000e-09 rise=1p fall=1p
VWIN_1_10 (win_1_10 0) vsource type=pulse val0=-1 val1=1 period=2.000000000000e-09 width=1.250000000000e-10 delay=1.250000000000e-09 rise=1p fall=1p
VWIN_1_11 (win_1_11 0) vsource type=pulse val0=-1 val1=1 period=2.000000000000e-09 width=1.250000000000e-10 delay=1.375000000000e-09 rise=1p fall=1p
VWIN_1_12 (win_1_12 0) vsource type=pulse val0=-1 val1=1 period=2.000000000000e-09 width=1.250000000000e-10 delay=1.500000000000e-09 rise=1p fall=1p
VWIN_1_13 (win_1_13 0) vsource type=pulse val0=-1 val1=1 period=2.000000000000e-09 width=1.250000000000e-10 delay=1.625000000000e-09 rise=1p fall=1p
VWIN_1_14 (win_1_14 0) vsource type=pulse val0=-1 val1=1 period=2.000000000000e-09 width=1.250000000000e-10 delay=1.750000000000e-09 rise=1p fall=1p
VWIN_1_15 (win_1_15 0) vsource type=pulse val0=-1 val1=1 period=2.000000000000e-09 width=1.250000000000e-10 delay=1.875000000000e-09 rise=1p fall=1p

VREFI_2 (ref_i_2 0) vsource type=sine freq=750000000 ampl=1 phase=90
VREFQ_2 (ref_q_2 0) vsource type=sine freq=750000000 ampl=1 phase=0
RREFI_2 (ref_i_2 0) resistor r=1G
RREFQ_2 (ref_q_2 0) resistor r=1G
VWIN_2_00 (win_2_00 0) vsource type=pulse val0=-1 val1=1 period=1.333333333333e-09 width=8.333333333333e-11 delay=0.000000000000e+00 rise=1p fall=1p
VWIN_2_01 (win_2_01 0) vsource type=pulse val0=-1 val1=1 period=1.333333333333e-09 width=8.333333333333e-11 delay=8.333333333333e-11 rise=1p fall=1p
VWIN_2_02 (win_2_02 0) vsource type=pulse val0=-1 val1=1 period=1.333333333333e-09 width=8.333333333333e-11 delay=1.666666666667e-10 rise=1p fall=1p
VWIN_2_03 (win_2_03 0) vsource type=pulse val0=-1 val1=1 period=1.333333333333e-09 width=8.333333333333e-11 delay=2.500000000000e-10 rise=1p fall=1p
VWIN_2_04 (win_2_04 0) vsource type=pulse val0=-1 val1=1 period=1.333333333333e-09 width=8.333333333333e-11 delay=3.333333333333e-10 rise=1p fall=1p
VWIN_2_05 (win_2_05 0) vsource type=pulse val0=-1 val1=1 period=1.333333333333e-09 width=8.333333333333e-11 delay=4.166666666667e-10 rise=1p fall=1p
VWIN_2_06 (win_2_06 0) vsource type=pulse val0=-1 val1=1 period=1.333333333333e-09 width=8.333333333333e-11 delay=5.000000000000e-10 rise=1p fall=1p
VWIN_2_07 (win_2_07 0) vsource type=pulse val0=-1 val1=1 period=1.333333333333e-09 width=8.333333333333e-11 delay=5.833333333333e-10 rise=1p fall=1p
VWIN_2_08 (win_2_08 0) vsource type=pulse val0=-1 val1=1 period=1.333333333333e-09 width=8.333333333333e-11 delay=6.666666666667e-10 rise=1p fall=1p
VWIN_2_09 (win_2_09 0) vsource type=pulse val0=-1 val1=1 period=1.333333333333e-09 width=8.333333333333e-11 delay=7.500000000000e-10 rise=1p fall=1p
VWIN_2_10 (win_2_10 0) vsource type=pulse val0=-1 val1=1 period=1.333333333333e-09 width=8.333333333333e-11 delay=8.333333333333e-10 rise=1p fall=1p
VWIN_2_11 (win_2_11 0) vsource type=pulse val0=-1 val1=1 period=1.333333333333e-09 width=8.333333333333e-11 delay=9.166666666667e-10 rise=1p fall=1p
VWIN_2_12 (win_2_12 0) vsource type=pulse val0=-1 val1=1 period=1.333333333333e-09 width=8.333333333333e-11 delay=1.000000000000e-09 rise=1p fall=1p
VWIN_2_13 (win_2_13 0) vsource type=pulse val0=-1 val1=1 period=1.333333333333e-09 width=8.333333333333e-11 delay=1.083333333333e-09 rise=1p fall=1p
VWIN_2_14 (win_2_14 0) vsource type=pulse val0=-1 val1=1 period=1.333333333333e-09 width=8.333333333333e-11 delay=1.166666666667e-09 rise=1p fall=1p
VWIN_2_15 (win_2_15 0) vsource type=pulse val0=-1 val1=1 period=1.333333333333e-09 width=8.333333333333e-11 delay=1.250000000000e-09 rise=1p fall=1p

VREFI_3 (ref_i_3 0) vsource type=sine freq=1000000000 ampl=1 phase=90
VREFQ_3 (ref_q_3 0) vsource type=sine freq=1000000000 ampl=1 phase=0
RREFI_3 (ref_i_3 0) resistor r=1G
RREFQ_3 (ref_q_3 0) resistor r=1G
VWIN_3_00 (win_3_00 0) vsource type=pulse val0=-1 val1=1 period=1.000000000000e-09 width=6.250000000000e-11 delay=0.000000000000e+00 rise=1p fall=1p
VWIN_3_01 (win_3_01 0) vsource type=pulse val0=-1 val1=1 period=1.000000000000e-09 width=6.250000000000e-11 delay=6.250000000000e-11 rise=1p fall=1p
VWIN_3_02 (win_3_02 0) vsource type=pulse val0=-1 val1=1 period=1.000000000000e-09 width=6.250000000000e-11 delay=1.250000000000e-10 rise=1p fall=1p
VWIN_3_03 (win_3_03 0) vsource type=pulse val0=-1 val1=1 period=1.000000000000e-09 width=6.250000000000e-11 delay=1.875000000000e-10 rise=1p fall=1p
VWIN_3_04 (win_3_04 0) vsource type=pulse val0=-1 val1=1 period=1.000000000000e-09 width=6.250000000000e-11 delay=2.500000000000e-10 rise=1p fall=1p
VWIN_3_05 (win_3_05 0) vsource type=pulse val0=-1 val1=1 period=1.000000000000e-09 width=6.250000000000e-11 delay=3.125000000000e-10 rise=1p fall=1p
VWIN_3_06 (win_3_06 0) vsource type=pulse val0=-1 val1=1 period=1.000000000000e-09 width=6.250000000000e-11 delay=3.750000000000e-10 rise=1p fall=1p
VWIN_3_07 (win_3_07 0) vsource type=pulse val0=-1 val1=1 period=1.000000000000e-09 width=6.250000000000e-11 delay=4.375000000000e-10 rise=1p fall=1p
VWIN_3_08 (win_3_08 0) vsource type=pulse val0=-1 val1=1 period=1.000000000000e-09 width=6.250000000000e-11 delay=5.000000000000e-10 rise=1p fall=1p
VWIN_3_09 (win_3_09 0) vsource type=pulse val0=-1 val1=1 period=1.000000000000e-09 width=6.250000000000e-11 delay=5.625000000000e-10 rise=1p fall=1p
VWIN_3_10 (win_3_10 0) vsource type=pulse val0=-1 val1=1 period=1.000000000000e-09 width=6.250000000000e-11 delay=6.250000000000e-10 rise=1p fall=1p
VWIN_3_11 (win_3_11 0) vsource type=pulse val0=-1 val1=1 period=1.000000000000e-09 width=6.250000000000e-11 delay=6.875000000000e-10 rise=1p fall=1p
VWIN_3_12 (win_3_12 0) vsource type=pulse val0=-1 val1=1 period=1.000000000000e-09 width=6.250000000000e-11 delay=7.500000000000e-10 rise=1p fall=1p
VWIN_3_13 (win_3_13 0) vsource type=pulse val0=-1 val1=1 period=1.000000000000e-09 width=6.250000000000e-11 delay=8.125000000000e-10 rise=1p fall=1p
VWIN_3_14 (win_3_14 0) vsource type=pulse val0=-1 val1=1 period=1.000000000000e-09 width=6.250000000000e-11 delay=8.750000000000e-10 rise=1p fall=1p
VWIN_3_15 (win_3_15 0) vsource type=pulse val0=-1 val1=1 period=1.000000000000e-09 width=6.250000000000e-11 delay=9.375000000000e-10 rise=1p fall=1p

// bl000, carrier_0: 250000000 Hz coherent I/Q phase-window verification-demod path
CBPF_c000_0 (bl000 n_cbpf_c000_0) capacitor c=4.052847345694e-13
LBPF_c000_0 (n_cbpf_c000_0 bpf_c000_0) inductor l=1.000000000000e-06
RBPF_c000_0 (bpf_c000_0 0) resistor r=7.853981633974e+01
EMIXI_c000_0_00 (mix_i_src_c000_0_00 0 bpf_c000_0 0) vcvs gain=9.807852804032e-01
SMIXI_c000_0_00 (mix_i_src_c000_0_00 mix_i_c000_0 win_0_00 0) relay vt1=-1m vt2=1m ropen=ropen_mix rclosed=rclosed_mix
EMIXQ_c000_0_00 (mix_q_src_c000_0_00 0 bpf_c000_0 0) vcvs gain=1.950903220161e-01
SMIXQ_c000_0_00 (mix_q_src_c000_0_00 mix_q_c000_0 win_0_00 0) relay vt1=-1m vt2=1m ropen=ropen_mix rclosed=rclosed_mix
EMIXI_c000_0_01 (mix_i_src_c000_0_01 0 bpf_c000_0 0) vcvs gain=8.314696123025e-01
SMIXI_c000_0_01 (mix_i_src_c000_0_01 mix_i_c000_0 win_0_01 0) relay vt1=-1m vt2=1m ropen=ropen_mix rclosed=rclosed_mix
EMIXQ_c000_0_01 (mix_q_src_c000_0_01 0 bpf_c000_0 0) vcvs gain=5.555702330196e-01
SMIXQ_c000_0_01 (mix_q_src_c000_0_01 mix_q_c000_0 win_0_01 0) relay vt1=-1m vt2=1m ropen=ropen_mix rclosed=rclosed_mix
EMIXI_c000_0_02 (mix_i_src_c000_0_02 0 bpf_c000_0 0) vcvs gain=5.555702330196e-01
SMIXI_c000_0_02 (mix_i_src_c000_0_02 mix_i_c000_0 win_0_02 0) relay vt1=-1m vt2=1m ropen=ropen_mix rclosed=rclosed_mix
EMIXQ_c000_0_02 (mix_q_src_c000_0_02 0 bpf_c000_0 0) vcvs gain=8.314696123025e-01
SMIXQ_c000_0_02 (mix_q_src_c000_0_02 mix_q_c000_0 win_0_02 0) relay vt1=-1m vt2=1m ropen=ropen_mix rclosed=rclosed_mix
EMIXI_c000_0_03 (mix_i_src_c000_0_03 0 bpf_c000_0 0) vcvs gain=1.950903220161e-01
SMIXI_c000_0_03 (mix_i_src_c000_0_03 mix_i_c000_0 win_0_03 0) relay vt1=-1m vt2=1m ropen=ropen_mix rclosed=rclosed_mix
EMIXQ_c000_0_03 (mix_q_src_c000_0_03 0 bpf_c000_0 0) vcvs gain=9.807852804032e-01
SMIXQ_c000_0_03 (mix_q_src_c000_0_03 mix_q_c000_0 win_0_03 0) relay vt1=-1m vt2=1m ropen=ropen_mix rclosed=rclosed_mix
EMIXI_c000_0_04 (mix_i_src_c000_0_04 0 bpf_c000_0 0) vcvs gain=-1.950903220161e-01
SMIXI_c000_0_04 (mix_i_src_c000_0_04 mix_i_c000_0 win_0_04 0) relay vt1=-1m vt2=1m ropen=ropen_mix rclosed=rclosed_mix
EMIXQ_c000_0_04 (mix_q_src_c000_0_04 0 bpf_c000_0 0) vcvs gain=9.807852804032e-01
SMIXQ_c000_0_04 (mix_q_src_c000_0_04 mix_q_c000_0 win_0_04 0) relay vt1=-1m vt2=1m ropen=ropen_mix rclosed=rclosed_mix
EMIXI_c000_0_05 (mix_i_src_c000_0_05 0 bpf_c000_0 0) vcvs gain=-5.555702330196e-01
SMIXI_c000_0_05 (mix_i_src_c000_0_05 mix_i_c000_0 win_0_05 0) relay vt1=-1m vt2=1m ropen=ropen_mix rclosed=rclosed_mix
EMIXQ_c000_0_05 (mix_q_src_c000_0_05 0 bpf_c000_0 0) vcvs gain=8.314696123025e-01
SMIXQ_c000_0_05 (mix_q_src_c000_0_05 mix_q_c000_0 win_0_05 0) relay vt1=-1m vt2=1m ropen=ropen_mix rclosed=rclosed_mix
EMIXI_c000_0_06 (mix_i_src_c000_0_06 0 bpf_c000_0 0) vcvs gain=-8.314696123025e-01
SMIXI_c000_0_06 (mix_i_src_c000_0_06 mix_i_c000_0 win_0_06 0) relay vt1=-1m vt2=1m ropen=ropen_mix rclosed=rclosed_mix
EMIXQ_c000_0_06 (mix_q_src_c000_0_06 0 bpf_c000_0 0) vcvs gain=5.555702330196e-01
SMIXQ_c000_0_06 (mix_q_src_c000_0_06 mix_q_c000_0 win_0_06 0) relay vt1=-1m vt2=1m ropen=ropen_mix rclosed=rclosed_mix
EMIXI_c000_0_07 (mix_i_src_c000_0_07 0 bpf_c000_0 0) vcvs gain=-9.807852804032e-01
SMIXI_c000_0_07 (mix_i_src_c000_0_07 mix_i_c000_0 win_0_07 0) relay vt1=-1m vt2=1m ropen=ropen_mix rclosed=rclosed_mix
EMIXQ_c000_0_07 (mix_q_src_c000_0_07 0 bpf_c000_0 0) vcvs gain=1.950903220161e-01
SMIXQ_c000_0_07 (mix_q_src_c000_0_07 mix_q_c000_0 win_0_07 0) relay vt1=-1m vt2=1m ropen=ropen_mix rclosed=rclosed_mix
EMIXI_c000_0_08 (mix_i_src_c000_0_08 0 bpf_c000_0 0) vcvs gain=-9.807852804032e-01
SMIXI_c000_0_08 (mix_i_src_c000_0_08 mix_i_c000_0 win_0_08 0) relay vt1=-1m vt2=1m ropen=ropen_mix rclosed=rclosed_mix
EMIXQ_c000_0_08 (mix_q_src_c000_0_08 0 bpf_c000_0 0) vcvs gain=-1.950903220161e-01
SMIXQ_c000_0_08 (mix_q_src_c000_0_08 mix_q_c000_0 win_0_08 0) relay vt1=-1m vt2=1m ropen=ropen_mix rclosed=rclosed_mix
EMIXI_c000_0_09 (mix_i_src_c000_0_09 0 bpf_c000_0 0) vcvs gain=-8.314696123025e-01
SMIXI_c000_0_09 (mix_i_src_c000_0_09 mix_i_c000_0 win_0_09 0) relay vt1=-1m vt2=1m ropen=ropen_mix rclosed=rclosed_mix
EMIXQ_c000_0_09 (mix_q_src_c000_0_09 0 bpf_c000_0 0) vcvs gain=-5.555702330196e-01
SMIXQ_c000_0_09 (mix_q_src_c000_0_09 mix_q_c000_0 win_0_09 0) relay vt1=-1m vt2=1m ropen=ropen_mix rclosed=rclosed_mix
EMIXI_c000_0_10 (mix_i_src_c000_0_10 0 bpf_c000_0 0) vcvs gain=-5.555702330196e-01
SMIXI_c000_0_10 (mix_i_src_c000_0_10 mix_i_c000_0 win_0_10 0) relay vt1=-1m vt2=1m ropen=ropen_mix rclosed=rclosed_mix
EMIXQ_c000_0_10 (mix_q_src_c000_0_10 0 bpf_c000_0 0) vcvs gain=-8.314696123025e-01
SMIXQ_c000_0_10 (mix_q_src_c000_0_10 mix_q_c000_0 win_0_10 0) relay vt1=-1m vt2=1m ropen=ropen_mix rclosed=rclosed_mix
EMIXI_c000_0_11 (mix_i_src_c000_0_11 0 bpf_c000_0 0) vcvs gain=-1.950903220161e-01
SMIXI_c000_0_11 (mix_i_src_c000_0_11 mix_i_c000_0 win_0_11 0) relay vt1=-1m vt2=1m ropen=ropen_mix rclosed=rclosed_mix
EMIXQ_c000_0_11 (mix_q_src_c000_0_11 0 bpf_c000_0 0) vcvs gain=-9.807852804032e-01
SMIXQ_c000_0_11 (mix_q_src_c000_0_11 mix_q_c000_0 win_0_11 0) relay vt1=-1m vt2=1m ropen=ropen_mix rclosed=rclosed_mix
EMIXI_c000_0_12 (mix_i_src_c000_0_12 0 bpf_c000_0 0) vcvs gain=1.950903220161e-01
SMIXI_c000_0_12 (mix_i_src_c000_0_12 mix_i_c000_0 win_0_12 0) relay vt1=-1m vt2=1m ropen=ropen_mix rclosed=rclosed_mix
EMIXQ_c000_0_12 (mix_q_src_c000_0_12 0 bpf_c000_0 0) vcvs gain=-9.807852804032e-01
SMIXQ_c000_0_12 (mix_q_src_c000_0_12 mix_q_c000_0 win_0_12 0) relay vt1=-1m vt2=1m ropen=ropen_mix rclosed=rclosed_mix
EMIXI_c000_0_13 (mix_i_src_c000_0_13 0 bpf_c000_0 0) vcvs gain=5.555702330196e-01
SMIXI_c000_0_13 (mix_i_src_c000_0_13 mix_i_c000_0 win_0_13 0) relay vt1=-1m vt2=1m ropen=ropen_mix rclosed=rclosed_mix
EMIXQ_c000_0_13 (mix_q_src_c000_0_13 0 bpf_c000_0 0) vcvs gain=-8.314696123025e-01
SMIXQ_c000_0_13 (mix_q_src_c000_0_13 mix_q_c000_0 win_0_13 0) relay vt1=-1m vt2=1m ropen=ropen_mix rclosed=rclosed_mix
EMIXI_c000_0_14 (mix_i_src_c000_0_14 0 bpf_c000_0 0) vcvs gain=8.314696123025e-01
SMIXI_c000_0_14 (mix_i_src_c000_0_14 mix_i_c000_0 win_0_14 0) relay vt1=-1m vt2=1m ropen=ropen_mix rclosed=rclosed_mix
EMIXQ_c000_0_14 (mix_q_src_c000_0_14 0 bpf_c000_0 0) vcvs gain=-5.555702330196e-01
SMIXQ_c000_0_14 (mix_q_src_c000_0_14 mix_q_c000_0 win_0_14 0) relay vt1=-1m vt2=1m ropen=ropen_mix rclosed=rclosed_mix
EMIXI_c000_0_15 (mix_i_src_c000_0_15 0 bpf_c000_0 0) vcvs gain=9.807852804032e-01
SMIXI_c000_0_15 (mix_i_src_c000_0_15 mix_i_c000_0 win_0_15 0) relay vt1=-1m vt2=1m ropen=ropen_mix rclosed=rclosed_mix
EMIXQ_c000_0_15 (mix_q_src_c000_0_15 0 bpf_c000_0 0) vcvs gain=-1.950903220161e-01
SMIXQ_c000_0_15 (mix_q_src_c000_0_15 mix_q_c000_0 win_0_15 0) relay vt1=-1m vt2=1m ropen=ropen_mix rclosed=rclosed_mix
RMIXI_c000_0 (mix_i_c000_0 0) resistor r=1G
RMIXQ_c000_0 (mix_q_c000_0 0) resistor r=1G
RINTI_c000_0 (mix_i_c000_0 Icar_c000_0) resistor r=1k
CINTI_c000_0 (Icar_c000_0 0) capacitor c=80p
RINTQ_c000_0 (mix_q_c000_0 Qcar_c000_0) resistor r=1k
CINTQ_c000_0 (Qcar_c000_0 0) capacitor c=80p
save bpf_c000_0 Icar_c000_0 Qcar_c000_0

// bl000, carrier_1: 500000000 Hz coherent I/Q phase-window verification-demod path
CBPF_c000_1 (bl000 n_cbpf_c000_1) capacitor c=1.013211836423e-13
LBPF_c000_1 (n_cbpf_c000_1 bpf_c000_1) inductor l=1.000000000000e-06
RBPF_c000_1 (bpf_c000_1 0) resistor r=1.570796326795e+02
EMIXI_c000_1_00 (mix_i_src_c000_1_00 0 bpf_c000_1 0) vcvs gain=9.807852804032e-01
SMIXI_c000_1_00 (mix_i_src_c000_1_00 mix_i_c000_1 win_1_00 0) relay vt1=-1m vt2=1m ropen=ropen_mix rclosed=rclosed_mix
EMIXQ_c000_1_00 (mix_q_src_c000_1_00 0 bpf_c000_1 0) vcvs gain=1.950903220161e-01
SMIXQ_c000_1_00 (mix_q_src_c000_1_00 mix_q_c000_1 win_1_00 0) relay vt1=-1m vt2=1m ropen=ropen_mix rclosed=rclosed_mix
EMIXI_c000_1_01 (mix_i_src_c000_1_01 0 bpf_c000_1 0) vcvs gain=8.314696123025e-01
SMIXI_c000_1_01 (mix_i_src_c000_1_01 mix_i_c000_1 win_1_01 0) relay vt1=-1m vt2=1m ropen=ropen_mix rclosed=rclosed_mix
EMIXQ_c000_1_01 (mix_q_src_c000_1_01 0 bpf_c000_1 0) vcvs gain=5.555702330196e-01
SMIXQ_c000_1_01 (mix_q_src_c000_1_01 mix_q_c000_1 win_1_01 0) relay vt1=-1m vt2=1m ropen=ropen_mix rclosed=rclosed_mix
EMIXI_c000_1_02 (mix_i_src_c000_1_02 0 bpf_c000_1 0) vcvs gain=5.555702330196e-01
SMIXI_c000_1_02 (mix_i_src_c000_1_02 mix_i_c000_1 win_1_02 0) relay vt1=-1m vt2=1m ropen=ropen_mix rclosed=rclosed_mix
EMIXQ_c000_1_02 (mix_q_src_c000_1_02 0 bpf_c000_1 0) vcvs gain=8.314696123025e-01
SMIXQ_c000_1_02 (mix_q_src_c000_1_02 mix_q_c000_1 win_1_02 0) relay vt1=-1m vt2=1m ropen=ropen_mix rclosed=rclosed_mix
EMIXI_c000_1_03 (mix_i_src_c000_1_03 0 bpf_c000_1 0) vcvs gain=1.950903220161e-01
SMIXI_c000_1_03 (mix_i_src_c000_1_03 mix_i_c000_1 win_1_03 0) relay vt1=-1m vt2=1m ropen=ropen_mix rclosed=rclosed_mix
EMIXQ_c000_1_03 (mix_q_src_c000_1_03 0 bpf_c000_1 0) vcvs gain=9.807852804032e-01
SMIXQ_c000_1_03 (mix_q_src_c000_1_03 mix_q_c000_1 win_1_03 0) relay vt1=-1m vt2=1m ropen=ropen_mix rclosed=rclosed_mix
EMIXI_c000_1_04 (mix_i_src_c000_1_04 0 bpf_c000_1 0) vcvs gain=-1.950903220161e-01
SMIXI_c000_1_04 (mix_i_src_c000_1_04 mix_i_c000_1 win_1_04 0) relay vt1=-1m vt2=1m ropen=ropen_mix rclosed=rclosed_mix
EMIXQ_c000_1_04 (mix_q_src_c000_1_04 0 bpf_c000_1 0) vcvs gain=9.807852804032e-01
SMIXQ_c000_1_04 (mix_q_src_c000_1_04 mix_q_c000_1 win_1_04 0) relay vt1=-1m vt2=1m ropen=ropen_mix rclosed=rclosed_mix
EMIXI_c000_1_05 (mix_i_src_c000_1_05 0 bpf_c000_1 0) vcvs gain=-5.555702330196e-01
SMIXI_c000_1_05 (mix_i_src_c000_1_05 mix_i_c000_1 win_1_05 0) relay vt1=-1m vt2=1m ropen=ropen_mix rclosed=rclosed_mix
EMIXQ_c000_1_05 (mix_q_src_c000_1_05 0 bpf_c000_1 0) vcvs gain=8.314696123025e-01
SMIXQ_c000_1_05 (mix_q_src_c000_1_05 mix_q_c000_1 win_1_05 0) relay vt1=-1m vt2=1m ropen=ropen_mix rclosed=rclosed_mix
EMIXI_c000_1_06 (mix_i_src_c000_1_06 0 bpf_c000_1 0) vcvs gain=-8.314696123025e-01
SMIXI_c000_1_06 (mix_i_src_c000_1_06 mix_i_c000_1 win_1_06 0) relay vt1=-1m vt2=1m ropen=ropen_mix rclosed=rclosed_mix
EMIXQ_c000_1_06 (mix_q_src_c000_1_06 0 bpf_c000_1 0) vcvs gain=5.555702330196e-01
SMIXQ_c000_1_06 (mix_q_src_c000_1_06 mix_q_c000_1 win_1_06 0) relay vt1=-1m vt2=1m ropen=ropen_mix rclosed=rclosed_mix
EMIXI_c000_1_07 (mix_i_src_c000_1_07 0 bpf_c000_1 0) vcvs gain=-9.807852804032e-01
SMIXI_c000_1_07 (mix_i_src_c000_1_07 mix_i_c000_1 win_1_07 0) relay vt1=-1m vt2=1m ropen=ropen_mix rclosed=rclosed_mix
EMIXQ_c000_1_07 (mix_q_src_c000_1_07 0 bpf_c000_1 0) vcvs gain=1.950903220161e-01
SMIXQ_c000_1_07 (mix_q_src_c000_1_07 mix_q_c000_1 win_1_07 0) relay vt1=-1m vt2=1m ropen=ropen_mix rclosed=rclosed_mix
EMIXI_c000_1_08 (mix_i_src_c000_1_08 0 bpf_c000_1 0) vcvs gain=-9.807852804032e-01
SMIXI_c000_1_08 (mix_i_src_c000_1_08 mix_i_c000_1 win_1_08 0) relay vt1=-1m vt2=1m ropen=ropen_mix rclosed=rclosed_mix
EMIXQ_c000_1_08 (mix_q_src_c000_1_08 0 bpf_c000_1 0) vcvs gain=-1.950903220161e-01
SMIXQ_c000_1_08 (mix_q_src_c000_1_08 mix_q_c000_1 win_1_08 0) relay vt1=-1m vt2=1m ropen=ropen_mix rclosed=rclosed_mix
EMIXI_c000_1_09 (mix_i_src_c000_1_09 0 bpf_c000_1 0) vcvs gain=-8.314696123025e-01
SMIXI_c000_1_09 (mix_i_src_c000_1_09 mix_i_c000_1 win_1_09 0) relay vt1=-1m vt2=1m ropen=ropen_mix rclosed=rclosed_mix
EMIXQ_c000_1_09 (mix_q_src_c000_1_09 0 bpf_c000_1 0) vcvs gain=-5.555702330196e-01
SMIXQ_c000_1_09 (mix_q_src_c000_1_09 mix_q_c000_1 win_1_09 0) relay vt1=-1m vt2=1m ropen=ropen_mix rclosed=rclosed_mix
EMIXI_c000_1_10 (mix_i_src_c000_1_10 0 bpf_c000_1 0) vcvs gain=-5.555702330196e-01
SMIXI_c000_1_10 (mix_i_src_c000_1_10 mix_i_c000_1 win_1_10 0) relay vt1=-1m vt2=1m ropen=ropen_mix rclosed=rclosed_mix
EMIXQ_c000_1_10 (mix_q_src_c000_1_10 0 bpf_c000_1 0) vcvs gain=-8.314696123025e-01
SMIXQ_c000_1_10 (mix_q_src_c000_1_10 mix_q_c000_1 win_1_10 0) relay vt1=-1m vt2=1m ropen=ropen_mix rclosed=rclosed_mix
EMIXI_c000_1_11 (mix_i_src_c000_1_11 0 bpf_c000_1 0) vcvs gain=-1.950903220161e-01
SMIXI_c000_1_11 (mix_i_src_c000_1_11 mix_i_c000_1 win_1_11 0) relay vt1=-1m vt2=1m ropen=ropen_mix rclosed=rclosed_mix
EMIXQ_c000_1_11 (mix_q_src_c000_1_11 0 bpf_c000_1 0) vcvs gain=-9.807852804032e-01
SMIXQ_c000_1_11 (mix_q_src_c000_1_11 mix_q_c000_1 win_1_11 0) relay vt1=-1m vt2=1m ropen=ropen_mix rclosed=rclosed_mix
EMIXI_c000_1_12 (mix_i_src_c000_1_12 0 bpf_c000_1 0) vcvs gain=1.950903220161e-01
SMIXI_c000_1_12 (mix_i_src_c000_1_12 mix_i_c000_1 win_1_12 0) relay vt1=-1m vt2=1m ropen=ropen_mix rclosed=rclosed_mix
EMIXQ_c000_1_12 (mix_q_src_c000_1_12 0 bpf_c000_1 0) vcvs gain=-9.807852804032e-01
SMIXQ_c000_1_12 (mix_q_src_c000_1_12 mix_q_c000_1 win_1_12 0) relay vt1=-1m vt2=1m ropen=ropen_mix rclosed=rclosed_mix
EMIXI_c000_1_13 (mix_i_src_c000_1_13 0 bpf_c000_1 0) vcvs gain=5.555702330196e-01
SMIXI_c000_1_13 (mix_i_src_c000_1_13 mix_i_c000_1 win_1_13 0) relay vt1=-1m vt2=1m ropen=ropen_mix rclosed=rclosed_mix
EMIXQ_c000_1_13 (mix_q_src_c000_1_13 0 bpf_c000_1 0) vcvs gain=-8.314696123025e-01
SMIXQ_c000_1_13 (mix_q_src_c000_1_13 mix_q_c000_1 win_1_13 0) relay vt1=-1m vt2=1m ropen=ropen_mix rclosed=rclosed_mix
EMIXI_c000_1_14 (mix_i_src_c000_1_14 0 bpf_c000_1 0) vcvs gain=8.314696123025e-01
SMIXI_c000_1_14 (mix_i_src_c000_1_14 mix_i_c000_1 win_1_14 0) relay vt1=-1m vt2=1m ropen=ropen_mix rclosed=rclosed_mix
EMIXQ_c000_1_14 (mix_q_src_c000_1_14 0 bpf_c000_1 0) vcvs gain=-5.555702330196e-01
SMIXQ_c000_1_14 (mix_q_src_c000_1_14 mix_q_c000_1 win_1_14 0) relay vt1=-1m vt2=1m ropen=ropen_mix rclosed=rclosed_mix
EMIXI_c000_1_15 (mix_i_src_c000_1_15 0 bpf_c000_1 0) vcvs gain=9.807852804032e-01
SMIXI_c000_1_15 (mix_i_src_c000_1_15 mix_i_c000_1 win_1_15 0) relay vt1=-1m vt2=1m ropen=ropen_mix rclosed=rclosed_mix
EMIXQ_c000_1_15 (mix_q_src_c000_1_15 0 bpf_c000_1 0) vcvs gain=-1.950903220161e-01
SMIXQ_c000_1_15 (mix_q_src_c000_1_15 mix_q_c000_1 win_1_15 0) relay vt1=-1m vt2=1m ropen=ropen_mix rclosed=rclosed_mix
RMIXI_c000_1 (mix_i_c000_1 0) resistor r=1G
RMIXQ_c000_1 (mix_q_c000_1 0) resistor r=1G
RINTI_c000_1 (mix_i_c000_1 Icar_c000_1) resistor r=1k
CINTI_c000_1 (Icar_c000_1 0) capacitor c=80p
RINTQ_c000_1 (mix_q_c000_1 Qcar_c000_1) resistor r=1k
CINTQ_c000_1 (Qcar_c000_1 0) capacitor c=80p
save bpf_c000_1 Icar_c000_1 Qcar_c000_1

// bl000, carrier_2: 750000000 Hz coherent I/Q phase-window verification-demod path
CBPF_c000_2 (bl000 n_cbpf_c000_2) capacitor c=4.503163717437e-14
LBPF_c000_2 (n_cbpf_c000_2 bpf_c000_2) inductor l=1.000000000000e-06
RBPF_c000_2 (bpf_c000_2 0) resistor r=2.356194490192e+02
EMIXI_c000_2_00 (mix_i_src_c000_2_00 0 bpf_c000_2 0) vcvs gain=9.807852804032e-01
SMIXI_c000_2_00 (mix_i_src_c000_2_00 mix_i_c000_2 win_2_00 0) relay vt1=-1m vt2=1m ropen=ropen_mix rclosed=rclosed_mix
EMIXQ_c000_2_00 (mix_q_src_c000_2_00 0 bpf_c000_2 0) vcvs gain=1.950903220161e-01
SMIXQ_c000_2_00 (mix_q_src_c000_2_00 mix_q_c000_2 win_2_00 0) relay vt1=-1m vt2=1m ropen=ropen_mix rclosed=rclosed_mix
EMIXI_c000_2_01 (mix_i_src_c000_2_01 0 bpf_c000_2 0) vcvs gain=8.314696123025e-01
SMIXI_c000_2_01 (mix_i_src_c000_2_01 mix_i_c000_2 win_2_01 0) relay vt1=-1m vt2=1m ropen=ropen_mix rclosed=rclosed_mix
EMIXQ_c000_2_01 (mix_q_src_c000_2_01 0 bpf_c000_2 0) vcvs gain=5.555702330196e-01
SMIXQ_c000_2_01 (mix_q_src_c000_2_01 mix_q_c000_2 win_2_01 0) relay vt1=-1m vt2=1m ropen=ropen_mix rclosed=rclosed_mix
EMIXI_c000_2_02 (mix_i_src_c000_2_02 0 bpf_c000_2 0) vcvs gain=5.555702330196e-01
SMIXI_c000_2_02 (mix_i_src_c000_2_02 mix_i_c000_2 win_2_02 0) relay vt1=-1m vt2=1m ropen=ropen_mix rclosed=rclosed_mix
EMIXQ_c000_2_02 (mix_q_src_c000_2_02 0 bpf_c000_2 0) vcvs gain=8.314696123025e-01
SMIXQ_c000_2_02 (mix_q_src_c000_2_02 mix_q_c000_2 win_2_02 0) relay vt1=-1m vt2=1m ropen=ropen_mix rclosed=rclosed_mix
EMIXI_c000_2_03 (mix_i_src_c000_2_03 0 bpf_c000_2 0) vcvs gain=1.950903220161e-01
SMIXI_c000_2_03 (mix_i_src_c000_2_03 mix_i_c000_2 win_2_03 0) relay vt1=-1m vt2=1m ropen=ropen_mix rclosed=rclosed_mix
EMIXQ_c000_2_03 (mix_q_src_c000_2_03 0 bpf_c000_2 0) vcvs gain=9.807852804032e-01
SMIXQ_c000_2_03 (mix_q_src_c000_2_03 mix_q_c000_2 win_2_03 0) relay vt1=-1m vt2=1m ropen=ropen_mix rclosed=rclosed_mix
EMIXI_c000_2_04 (mix_i_src_c000_2_04 0 bpf_c000_2 0) vcvs gain=-1.950903220161e-01
SMIXI_c000_2_04 (mix_i_src_c000_2_04 mix_i_c000_2 win_2_04 0) relay vt1=-1m vt2=1m ropen=ropen_mix rclosed=rclosed_mix
EMIXQ_c000_2_04 (mix_q_src_c000_2_04 0 bpf_c000_2 0) vcvs gain=9.807852804032e-01
SMIXQ_c000_2_04 (mix_q_src_c000_2_04 mix_q_c000_2 win_2_04 0) relay vt1=-1m vt2=1m ropen=ropen_mix rclosed=rclosed_mix
EMIXI_c000_2_05 (mix_i_src_c000_2_05 0 bpf_c000_2 0) vcvs gain=-5.555702330196e-01
SMIXI_c000_2_05 (mix_i_src_c000_2_05 mix_i_c000_2 win_2_05 0) relay vt1=-1m vt2=1m ropen=ropen_mix rclosed=rclosed_mix
EMIXQ_c000_2_05 (mix_q_src_c000_2_05 0 bpf_c000_2 0) vcvs gain=8.314696123025e-01
SMIXQ_c000_2_05 (mix_q_src_c000_2_05 mix_q_c000_2 win_2_05 0) relay vt1=-1m vt2=1m ropen=ropen_mix rclosed=rclosed_mix
EMIXI_c000_2_06 (mix_i_src_c000_2_06 0 bpf_c000_2 0) vcvs gain=-8.314696123025e-01
SMIXI_c000_2_06 (mix_i_src_c000_2_06 mix_i_c000_2 win_2_06 0) relay vt1=-1m vt2=1m ropen=ropen_mix rclosed=rclosed_mix
EMIXQ_c000_2_06 (mix_q_src_c000_2_06 0 bpf_c000_2 0) vcvs gain=5.555702330196e-01
SMIXQ_c000_2_06 (mix_q_src_c000_2_06 mix_q_c000_2 win_2_06 0) relay vt1=-1m vt2=1m ropen=ropen_mix rclosed=rclosed_mix
EMIXI_c000_2_07 (mix_i_src_c000_2_07 0 bpf_c000_2 0) vcvs gain=-9.807852804032e-01
SMIXI_c000_2_07 (mix_i_src_c000_2_07 mix_i_c000_2 win_2_07 0) relay vt1=-1m vt2=1m ropen=ropen_mix rclosed=rclosed_mix
EMIXQ_c000_2_07 (mix_q_src_c000_2_07 0 bpf_c000_2 0) vcvs gain=1.950903220161e-01
SMIXQ_c000_2_07 (mix_q_src_c000_2_07 mix_q_c000_2 win_2_07 0) relay vt1=-1m vt2=1m ropen=ropen_mix rclosed=rclosed_mix
EMIXI_c000_2_08 (mix_i_src_c000_2_08 0 bpf_c000_2 0) vcvs gain=-9.807852804032e-01
SMIXI_c000_2_08 (mix_i_src_c000_2_08 mix_i_c000_2 win_2_08 0) relay vt1=-1m vt2=1m ropen=ropen_mix rclosed=rclosed_mix
EMIXQ_c000_2_08 (mix_q_src_c000_2_08 0 bpf_c000_2 0) vcvs gain=-1.950903220161e-01
SMIXQ_c000_2_08 (mix_q_src_c000_2_08 mix_q_c000_2 win_2_08 0) relay vt1=-1m vt2=1m ropen=ropen_mix rclosed=rclosed_mix
EMIXI_c000_2_09 (mix_i_src_c000_2_09 0 bpf_c000_2 0) vcvs gain=-8.314696123025e-01
SMIXI_c000_2_09 (mix_i_src_c000_2_09 mix_i_c000_2 win_2_09 0) relay vt1=-1m vt2=1m ropen=ropen_mix rclosed=rclosed_mix
EMIXQ_c000_2_09 (mix_q_src_c000_2_09 0 bpf_c000_2 0) vcvs gain=-5.555702330196e-01
SMIXQ_c000_2_09 (mix_q_src_c000_2_09 mix_q_c000_2 win_2_09 0) relay vt1=-1m vt2=1m ropen=ropen_mix rclosed=rclosed_mix
EMIXI_c000_2_10 (mix_i_src_c000_2_10 0 bpf_c000_2 0) vcvs gain=-5.555702330196e-01
SMIXI_c000_2_10 (mix_i_src_c000_2_10 mix_i_c000_2 win_2_10 0) relay vt1=-1m vt2=1m ropen=ropen_mix rclosed=rclosed_mix
EMIXQ_c000_2_10 (mix_q_src_c000_2_10 0 bpf_c000_2 0) vcvs gain=-8.314696123025e-01
SMIXQ_c000_2_10 (mix_q_src_c000_2_10 mix_q_c000_2 win_2_10 0) relay vt1=-1m vt2=1m ropen=ropen_mix rclosed=rclosed_mix
EMIXI_c000_2_11 (mix_i_src_c000_2_11 0 bpf_c000_2 0) vcvs gain=-1.950903220161e-01
SMIXI_c000_2_11 (mix_i_src_c000_2_11 mix_i_c000_2 win_2_11 0) relay vt1=-1m vt2=1m ropen=ropen_mix rclosed=rclosed_mix
EMIXQ_c000_2_11 (mix_q_src_c000_2_11 0 bpf_c000_2 0) vcvs gain=-9.807852804032e-01
SMIXQ_c000_2_11 (mix_q_src_c000_2_11 mix_q_c000_2 win_2_11 0) relay vt1=-1m vt2=1m ropen=ropen_mix rclosed=rclosed_mix
EMIXI_c000_2_12 (mix_i_src_c000_2_12 0 bpf_c000_2 0) vcvs gain=1.950903220161e-01
SMIXI_c000_2_12 (mix_i_src_c000_2_12 mix_i_c000_2 win_2_12 0) relay vt1=-1m vt2=1m ropen=ropen_mix rclosed=rclosed_mix
EMIXQ_c000_2_12 (mix_q_src_c000_2_12 0 bpf_c000_2 0) vcvs gain=-9.807852804032e-01
SMIXQ_c000_2_12 (mix_q_src_c000_2_12 mix_q_c000_2 win_2_12 0) relay vt1=-1m vt2=1m ropen=ropen_mix rclosed=rclosed_mix
EMIXI_c000_2_13 (mix_i_src_c000_2_13 0 bpf_c000_2 0) vcvs gain=5.555702330196e-01
SMIXI_c000_2_13 (mix_i_src_c000_2_13 mix_i_c000_2 win_2_13 0) relay vt1=-1m vt2=1m ropen=ropen_mix rclosed=rclosed_mix
EMIXQ_c000_2_13 (mix_q_src_c000_2_13 0 bpf_c000_2 0) vcvs gain=-8.314696123025e-01
SMIXQ_c000_2_13 (mix_q_src_c000_2_13 mix_q_c000_2 win_2_13 0) relay vt1=-1m vt2=1m ropen=ropen_mix rclosed=rclosed_mix
EMIXI_c000_2_14 (mix_i_src_c000_2_14 0 bpf_c000_2 0) vcvs gain=8.314696123025e-01
SMIXI_c000_2_14 (mix_i_src_c000_2_14 mix_i_c000_2 win_2_14 0) relay vt1=-1m vt2=1m ropen=ropen_mix rclosed=rclosed_mix
EMIXQ_c000_2_14 (mix_q_src_c000_2_14 0 bpf_c000_2 0) vcvs gain=-5.555702330196e-01
SMIXQ_c000_2_14 (mix_q_src_c000_2_14 mix_q_c000_2 win_2_14 0) relay vt1=-1m vt2=1m ropen=ropen_mix rclosed=rclosed_mix
EMIXI_c000_2_15 (mix_i_src_c000_2_15 0 bpf_c000_2 0) vcvs gain=9.807852804032e-01
SMIXI_c000_2_15 (mix_i_src_c000_2_15 mix_i_c000_2 win_2_15 0) relay vt1=-1m vt2=1m ropen=ropen_mix rclosed=rclosed_mix
EMIXQ_c000_2_15 (mix_q_src_c000_2_15 0 bpf_c000_2 0) vcvs gain=-1.950903220161e-01
SMIXQ_c000_2_15 (mix_q_src_c000_2_15 mix_q_c000_2 win_2_15 0) relay vt1=-1m vt2=1m ropen=ropen_mix rclosed=rclosed_mix
RMIXI_c000_2 (mix_i_c000_2 0) resistor r=1G
RMIXQ_c000_2 (mix_q_c000_2 0) resistor r=1G
RINTI_c000_2 (mix_i_c000_2 Icar_c000_2) resistor r=1k
CINTI_c000_2 (Icar_c000_2 0) capacitor c=80p
RINTQ_c000_2 (mix_q_c000_2 Qcar_c000_2) resistor r=1k
CINTQ_c000_2 (Qcar_c000_2 0) capacitor c=80p
save bpf_c000_2 Icar_c000_2 Qcar_c000_2

// bl000, carrier_3: 1000000000 Hz coherent I/Q phase-window verification-demod path
CBPF_c000_3 (bl000 n_cbpf_c000_3) capacitor c=2.533029591058e-14
LBPF_c000_3 (n_cbpf_c000_3 bpf_c000_3) inductor l=1.000000000000e-06
RBPF_c000_3 (bpf_c000_3 0) resistor r=3.141592653590e+02
EMIXI_c000_3_00 (mix_i_src_c000_3_00 0 bpf_c000_3 0) vcvs gain=9.807852804032e-01
SMIXI_c000_3_00 (mix_i_src_c000_3_00 mix_i_c000_3 win_3_00 0) relay vt1=-1m vt2=1m ropen=ropen_mix rclosed=rclosed_mix
EMIXQ_c000_3_00 (mix_q_src_c000_3_00 0 bpf_c000_3 0) vcvs gain=1.950903220161e-01
SMIXQ_c000_3_00 (mix_q_src_c000_3_00 mix_q_c000_3 win_3_00 0) relay vt1=-1m vt2=1m ropen=ropen_mix rclosed=rclosed_mix
EMIXI_c000_3_01 (mix_i_src_c000_3_01 0 bpf_c000_3 0) vcvs gain=8.314696123025e-01
SMIXI_c000_3_01 (mix_i_src_c000_3_01 mix_i_c000_3 win_3_01 0) relay vt1=-1m vt2=1m ropen=ropen_mix rclosed=rclosed_mix
EMIXQ_c000_3_01 (mix_q_src_c000_3_01 0 bpf_c000_3 0) vcvs gain=5.555702330196e-01
SMIXQ_c000_3_01 (mix_q_src_c000_3_01 mix_q_c000_3 win_3_01 0) relay vt1=-1m vt2=1m ropen=ropen_mix rclosed=rclosed_mix
EMIXI_c000_3_02 (mix_i_src_c000_3_02 0 bpf_c000_3 0) vcvs gain=5.555702330196e-01
SMIXI_c000_3_02 (mix_i_src_c000_3_02 mix_i_c000_3 win_3_02 0) relay vt1=-1m vt2=1m ropen=ropen_mix rclosed=rclosed_mix
EMIXQ_c000_3_02 (mix_q_src_c000_3_02 0 bpf_c000_3 0) vcvs gain=8.314696123025e-01
SMIXQ_c000_3_02 (mix_q_src_c000_3_02 mix_q_c000_3 win_3_02 0) relay vt1=-1m vt2=1m ropen=ropen_mix rclosed=rclosed_mix
EMIXI_c000_3_03 (mix_i_src_c000_3_03 0 bpf_c000_3 0) vcvs gain=1.950903220161e-01
SMIXI_c000_3_03 (mix_i_src_c000_3_03 mix_i_c000_3 win_3_03 0) relay vt1=-1m vt2=1m ropen=ropen_mix rclosed=rclosed_mix
EMIXQ_c000_3_03 (mix_q_src_c000_3_03 0 bpf_c000_3 0) vcvs gain=9.807852804032e-01
SMIXQ_c000_3_03 (mix_q_src_c000_3_03 mix_q_c000_3 win_3_03 0) relay vt1=-1m vt2=1m ropen=ropen_mix rclosed=rclosed_mix
EMIXI_c000_3_04 (mix_i_src_c000_3_04 0 bpf_c000_3 0) vcvs gain=-1.950903220161e-01
SMIXI_c000_3_04 (mix_i_src_c000_3_04 mix_i_c000_3 win_3_04 0) relay vt1=-1m vt2=1m ropen=ropen_mix rclosed=rclosed_mix
EMIXQ_c000_3_04 (mix_q_src_c000_3_04 0 bpf_c000_3 0) vcvs gain=9.807852804032e-01
SMIXQ_c000_3_04 (mix_q_src_c000_3_04 mix_q_c000_3 win_3_04 0) relay vt1=-1m vt2=1m ropen=ropen_mix rclosed=rclosed_mix
EMIXI_c000_3_05 (mix_i_src_c000_3_05 0 bpf_c000_3 0) vcvs gain=-5.555702330196e-01
SMIXI_c000_3_05 (mix_i_src_c000_3_05 mix_i_c000_3 win_3_05 0) relay vt1=-1m vt2=1m ropen=ropen_mix rclosed=rclosed_mix
EMIXQ_c000_3_05 (mix_q_src_c000_3_05 0 bpf_c000_3 0) vcvs gain=8.314696123025e-01
SMIXQ_c000_3_05 (mix_q_src_c000_3_05 mix_q_c000_3 win_3_05 0) relay vt1=-1m vt2=1m ropen=ropen_mix rclosed=rclosed_mix
EMIXI_c000_3_06 (mix_i_src_c000_3_06 0 bpf_c000_3 0) vcvs gain=-8.314696123025e-01
SMIXI_c000_3_06 (mix_i_src_c000_3_06 mix_i_c000_3 win_3_06 0) relay vt1=-1m vt2=1m ropen=ropen_mix rclosed=rclosed_mix
EMIXQ_c000_3_06 (mix_q_src_c000_3_06 0 bpf_c000_3 0) vcvs gain=5.555702330196e-01
SMIXQ_c000_3_06 (mix_q_src_c000_3_06 mix_q_c000_3 win_3_06 0) relay vt1=-1m vt2=1m ropen=ropen_mix rclosed=rclosed_mix
EMIXI_c000_3_07 (mix_i_src_c000_3_07 0 bpf_c000_3 0) vcvs gain=-9.807852804032e-01
SMIXI_c000_3_07 (mix_i_src_c000_3_07 mix_i_c000_3 win_3_07 0) relay vt1=-1m vt2=1m ropen=ropen_mix rclosed=rclosed_mix
EMIXQ_c000_3_07 (mix_q_src_c000_3_07 0 bpf_c000_3 0) vcvs gain=1.950903220161e-01
SMIXQ_c000_3_07 (mix_q_src_c000_3_07 mix_q_c000_3 win_3_07 0) relay vt1=-1m vt2=1m ropen=ropen_mix rclosed=rclosed_mix
EMIXI_c000_3_08 (mix_i_src_c000_3_08 0 bpf_c000_3 0) vcvs gain=-9.807852804032e-01
SMIXI_c000_3_08 (mix_i_src_c000_3_08 mix_i_c000_3 win_3_08 0) relay vt1=-1m vt2=1m ropen=ropen_mix rclosed=rclosed_mix
EMIXQ_c000_3_08 (mix_q_src_c000_3_08 0 bpf_c000_3 0) vcvs gain=-1.950903220161e-01
SMIXQ_c000_3_08 (mix_q_src_c000_3_08 mix_q_c000_3 win_3_08 0) relay vt1=-1m vt2=1m ropen=ropen_mix rclosed=rclosed_mix
EMIXI_c000_3_09 (mix_i_src_c000_3_09 0 bpf_c000_3 0) vcvs gain=-8.314696123025e-01
SMIXI_c000_3_09 (mix_i_src_c000_3_09 mix_i_c000_3 win_3_09 0) relay vt1=-1m vt2=1m ropen=ropen_mix rclosed=rclosed_mix
EMIXQ_c000_3_09 (mix_q_src_c000_3_09 0 bpf_c000_3 0) vcvs gain=-5.555702330196e-01
SMIXQ_c000_3_09 (mix_q_src_c000_3_09 mix_q_c000_3 win_3_09 0) relay vt1=-1m vt2=1m ropen=ropen_mix rclosed=rclosed_mix
EMIXI_c000_3_10 (mix_i_src_c000_3_10 0 bpf_c000_3 0) vcvs gain=-5.555702330196e-01
SMIXI_c000_3_10 (mix_i_src_c000_3_10 mix_i_c000_3 win_3_10 0) relay vt1=-1m vt2=1m ropen=ropen_mix rclosed=rclosed_mix
EMIXQ_c000_3_10 (mix_q_src_c000_3_10 0 bpf_c000_3 0) vcvs gain=-8.314696123025e-01
SMIXQ_c000_3_10 (mix_q_src_c000_3_10 mix_q_c000_3 win_3_10 0) relay vt1=-1m vt2=1m ropen=ropen_mix rclosed=rclosed_mix
EMIXI_c000_3_11 (mix_i_src_c000_3_11 0 bpf_c000_3 0) vcvs gain=-1.950903220161e-01
SMIXI_c000_3_11 (mix_i_src_c000_3_11 mix_i_c000_3 win_3_11 0) relay vt1=-1m vt2=1m ropen=ropen_mix rclosed=rclosed_mix
EMIXQ_c000_3_11 (mix_q_src_c000_3_11 0 bpf_c000_3 0) vcvs gain=-9.807852804032e-01
SMIXQ_c000_3_11 (mix_q_src_c000_3_11 mix_q_c000_3 win_3_11 0) relay vt1=-1m vt2=1m ropen=ropen_mix rclosed=rclosed_mix
EMIXI_c000_3_12 (mix_i_src_c000_3_12 0 bpf_c000_3 0) vcvs gain=1.950903220161e-01
SMIXI_c000_3_12 (mix_i_src_c000_3_12 mix_i_c000_3 win_3_12 0) relay vt1=-1m vt2=1m ropen=ropen_mix rclosed=rclosed_mix
EMIXQ_c000_3_12 (mix_q_src_c000_3_12 0 bpf_c000_3 0) vcvs gain=-9.807852804032e-01
SMIXQ_c000_3_12 (mix_q_src_c000_3_12 mix_q_c000_3 win_3_12 0) relay vt1=-1m vt2=1m ropen=ropen_mix rclosed=rclosed_mix
EMIXI_c000_3_13 (mix_i_src_c000_3_13 0 bpf_c000_3 0) vcvs gain=5.555702330196e-01
SMIXI_c000_3_13 (mix_i_src_c000_3_13 mix_i_c000_3 win_3_13 0) relay vt1=-1m vt2=1m ropen=ropen_mix rclosed=rclosed_mix
EMIXQ_c000_3_13 (mix_q_src_c000_3_13 0 bpf_c000_3 0) vcvs gain=-8.314696123025e-01
SMIXQ_c000_3_13 (mix_q_src_c000_3_13 mix_q_c000_3 win_3_13 0) relay vt1=-1m vt2=1m ropen=ropen_mix rclosed=rclosed_mix
EMIXI_c000_3_14 (mix_i_src_c000_3_14 0 bpf_c000_3 0) vcvs gain=8.314696123025e-01
SMIXI_c000_3_14 (mix_i_src_c000_3_14 mix_i_c000_3 win_3_14 0) relay vt1=-1m vt2=1m ropen=ropen_mix rclosed=rclosed_mix
EMIXQ_c000_3_14 (mix_q_src_c000_3_14 0 bpf_c000_3 0) vcvs gain=-5.555702330196e-01
SMIXQ_c000_3_14 (mix_q_src_c000_3_14 mix_q_c000_3 win_3_14 0) relay vt1=-1m vt2=1m ropen=ropen_mix rclosed=rclosed_mix
EMIXI_c000_3_15 (mix_i_src_c000_3_15 0 bpf_c000_3 0) vcvs gain=9.807852804032e-01
SMIXI_c000_3_15 (mix_i_src_c000_3_15 mix_i_c000_3 win_3_15 0) relay vt1=-1m vt2=1m ropen=ropen_mix rclosed=rclosed_mix
EMIXQ_c000_3_15 (mix_q_src_c000_3_15 0 bpf_c000_3 0) vcvs gain=-1.950903220161e-01
SMIXQ_c000_3_15 (mix_q_src_c000_3_15 mix_q_c000_3 win_3_15 0) relay vt1=-1m vt2=1m ropen=ropen_mix rclosed=rclosed_mix
RMIXI_c000_3 (mix_i_c000_3 0) resistor r=1G
RMIXQ_c000_3 (mix_q_c000_3 0) resistor r=1G
RINTI_c000_3 (mix_i_c000_3 Icar_c000_3) resistor r=1k
CINTI_c000_3 (Icar_c000_3 0) capacitor c=80p
RINTQ_c000_3 (mix_q_c000_3 Qcar_c000_3) resistor r=1k
CINTQ_c000_3 (Qcar_c000_3 0) capacitor c=80p
save bpf_c000_3 Icar_c000_3 Qcar_c000_3

// bl001, carrier_0: 250000000 Hz coherent I/Q phase-window verification-demod path
CBPF_c001_0 (bl001 n_cbpf_c001_0) capacitor c=4.052847345694e-13
LBPF_c001_0 (n_cbpf_c001_0 bpf_c001_0) inductor l=1.000000000000e-06
RBPF_c001_0 (bpf_c001_0 0) resistor r=7.853981633974e+01
EMIXI_c001_0_00 (mix_i_src_c001_0_00 0 bpf_c001_0 0) vcvs gain=9.807852804032e-01
SMIXI_c001_0_00 (mix_i_src_c001_0_00 mix_i_c001_0 win_0_00 0) relay vt1=-1m vt2=1m ropen=ropen_mix rclosed=rclosed_mix
EMIXQ_c001_0_00 (mix_q_src_c001_0_00 0 bpf_c001_0 0) vcvs gain=1.950903220161e-01
SMIXQ_c001_0_00 (mix_q_src_c001_0_00 mix_q_c001_0 win_0_00 0) relay vt1=-1m vt2=1m ropen=ropen_mix rclosed=rclosed_mix
EMIXI_c001_0_01 (mix_i_src_c001_0_01 0 bpf_c001_0 0) vcvs gain=8.314696123025e-01
SMIXI_c001_0_01 (mix_i_src_c001_0_01 mix_i_c001_0 win_0_01 0) relay vt1=-1m vt2=1m ropen=ropen_mix rclosed=rclosed_mix
EMIXQ_c001_0_01 (mix_q_src_c001_0_01 0 bpf_c001_0 0) vcvs gain=5.555702330196e-01
SMIXQ_c001_0_01 (mix_q_src_c001_0_01 mix_q_c001_0 win_0_01 0) relay vt1=-1m vt2=1m ropen=ropen_mix rclosed=rclosed_mix
EMIXI_c001_0_02 (mix_i_src_c001_0_02 0 bpf_c001_0 0) vcvs gain=5.555702330196e-01
SMIXI_c001_0_02 (mix_i_src_c001_0_02 mix_i_c001_0 win_0_02 0) relay vt1=-1m vt2=1m ropen=ropen_mix rclosed=rclosed_mix
EMIXQ_c001_0_02 (mix_q_src_c001_0_02 0 bpf_c001_0 0) vcvs gain=8.314696123025e-01
SMIXQ_c001_0_02 (mix_q_src_c001_0_02 mix_q_c001_0 win_0_02 0) relay vt1=-1m vt2=1m ropen=ropen_mix rclosed=rclosed_mix
EMIXI_c001_0_03 (mix_i_src_c001_0_03 0 bpf_c001_0 0) vcvs gain=1.950903220161e-01
SMIXI_c001_0_03 (mix_i_src_c001_0_03 mix_i_c001_0 win_0_03 0) relay vt1=-1m vt2=1m ropen=ropen_mix rclosed=rclosed_mix
EMIXQ_c001_0_03 (mix_q_src_c001_0_03 0 bpf_c001_0 0) vcvs gain=9.807852804032e-01
SMIXQ_c001_0_03 (mix_q_src_c001_0_03 mix_q_c001_0 win_0_03 0) relay vt1=-1m vt2=1m ropen=ropen_mix rclosed=rclosed_mix
EMIXI_c001_0_04 (mix_i_src_c001_0_04 0 bpf_c001_0 0) vcvs gain=-1.950903220161e-01
SMIXI_c001_0_04 (mix_i_src_c001_0_04 mix_i_c001_0 win_0_04 0) relay vt1=-1m vt2=1m ropen=ropen_mix rclosed=rclosed_mix
EMIXQ_c001_0_04 (mix_q_src_c001_0_04 0 bpf_c001_0 0) vcvs gain=9.807852804032e-01
SMIXQ_c001_0_04 (mix_q_src_c001_0_04 mix_q_c001_0 win_0_04 0) relay vt1=-1m vt2=1m ropen=ropen_mix rclosed=rclosed_mix
EMIXI_c001_0_05 (mix_i_src_c001_0_05 0 bpf_c001_0 0) vcvs gain=-5.555702330196e-01
SMIXI_c001_0_05 (mix_i_src_c001_0_05 mix_i_c001_0 win_0_05 0) relay vt1=-1m vt2=1m ropen=ropen_mix rclosed=rclosed_mix
EMIXQ_c001_0_05 (mix_q_src_c001_0_05 0 bpf_c001_0 0) vcvs gain=8.314696123025e-01
SMIXQ_c001_0_05 (mix_q_src_c001_0_05 mix_q_c001_0 win_0_05 0) relay vt1=-1m vt2=1m ropen=ropen_mix rclosed=rclosed_mix
EMIXI_c001_0_06 (mix_i_src_c001_0_06 0 bpf_c001_0 0) vcvs gain=-8.314696123025e-01
SMIXI_c001_0_06 (mix_i_src_c001_0_06 mix_i_c001_0 win_0_06 0) relay vt1=-1m vt2=1m ropen=ropen_mix rclosed=rclosed_mix
EMIXQ_c001_0_06 (mix_q_src_c001_0_06 0 bpf_c001_0 0) vcvs gain=5.555702330196e-01
SMIXQ_c001_0_06 (mix_q_src_c001_0_06 mix_q_c001_0 win_0_06 0) relay vt1=-1m vt2=1m ropen=ropen_mix rclosed=rclosed_mix
EMIXI_c001_0_07 (mix_i_src_c001_0_07 0 bpf_c001_0 0) vcvs gain=-9.807852804032e-01
SMIXI_c001_0_07 (mix_i_src_c001_0_07 mix_i_c001_0 win_0_07 0) relay vt1=-1m vt2=1m ropen=ropen_mix rclosed=rclosed_mix
EMIXQ_c001_0_07 (mix_q_src_c001_0_07 0 bpf_c001_0 0) vcvs gain=1.950903220161e-01
SMIXQ_c001_0_07 (mix_q_src_c001_0_07 mix_q_c001_0 win_0_07 0) relay vt1=-1m vt2=1m ropen=ropen_mix rclosed=rclosed_mix
EMIXI_c001_0_08 (mix_i_src_c001_0_08 0 bpf_c001_0 0) vcvs gain=-9.807852804032e-01
SMIXI_c001_0_08 (mix_i_src_c001_0_08 mix_i_c001_0 win_0_08 0) relay vt1=-1m vt2=1m ropen=ropen_mix rclosed=rclosed_mix
EMIXQ_c001_0_08 (mix_q_src_c001_0_08 0 bpf_c001_0 0) vcvs gain=-1.950903220161e-01
SMIXQ_c001_0_08 (mix_q_src_c001_0_08 mix_q_c001_0 win_0_08 0) relay vt1=-1m vt2=1m ropen=ropen_mix rclosed=rclosed_mix
EMIXI_c001_0_09 (mix_i_src_c001_0_09 0 bpf_c001_0 0) vcvs gain=-8.314696123025e-01
SMIXI_c001_0_09 (mix_i_src_c001_0_09 mix_i_c001_0 win_0_09 0) relay vt1=-1m vt2=1m ropen=ropen_mix rclosed=rclosed_mix
EMIXQ_c001_0_09 (mix_q_src_c001_0_09 0 bpf_c001_0 0) vcvs gain=-5.555702330196e-01
SMIXQ_c001_0_09 (mix_q_src_c001_0_09 mix_q_c001_0 win_0_09 0) relay vt1=-1m vt2=1m ropen=ropen_mix rclosed=rclosed_mix
EMIXI_c001_0_10 (mix_i_src_c001_0_10 0 bpf_c001_0 0) vcvs gain=-5.555702330196e-01
SMIXI_c001_0_10 (mix_i_src_c001_0_10 mix_i_c001_0 win_0_10 0) relay vt1=-1m vt2=1m ropen=ropen_mix rclosed=rclosed_mix
EMIXQ_c001_0_10 (mix_q_src_c001_0_10 0 bpf_c001_0 0) vcvs gain=-8.314696123025e-01
SMIXQ_c001_0_10 (mix_q_src_c001_0_10 mix_q_c001_0 win_0_10 0) relay vt1=-1m vt2=1m ropen=ropen_mix rclosed=rclosed_mix
EMIXI_c001_0_11 (mix_i_src_c001_0_11 0 bpf_c001_0 0) vcvs gain=-1.950903220161e-01
SMIXI_c001_0_11 (mix_i_src_c001_0_11 mix_i_c001_0 win_0_11 0) relay vt1=-1m vt2=1m ropen=ropen_mix rclosed=rclosed_mix
EMIXQ_c001_0_11 (mix_q_src_c001_0_11 0 bpf_c001_0 0) vcvs gain=-9.807852804032e-01
SMIXQ_c001_0_11 (mix_q_src_c001_0_11 mix_q_c001_0 win_0_11 0) relay vt1=-1m vt2=1m ropen=ropen_mix rclosed=rclosed_mix
EMIXI_c001_0_12 (mix_i_src_c001_0_12 0 bpf_c001_0 0) vcvs gain=1.950903220161e-01
SMIXI_c001_0_12 (mix_i_src_c001_0_12 mix_i_c001_0 win_0_12 0) relay vt1=-1m vt2=1m ropen=ropen_mix rclosed=rclosed_mix
EMIXQ_c001_0_12 (mix_q_src_c001_0_12 0 bpf_c001_0 0) vcvs gain=-9.807852804032e-01
SMIXQ_c001_0_12 (mix_q_src_c001_0_12 mix_q_c001_0 win_0_12 0) relay vt1=-1m vt2=1m ropen=ropen_mix rclosed=rclosed_mix
EMIXI_c001_0_13 (mix_i_src_c001_0_13 0 bpf_c001_0 0) vcvs gain=5.555702330196e-01
SMIXI_c001_0_13 (mix_i_src_c001_0_13 mix_i_c001_0 win_0_13 0) relay vt1=-1m vt2=1m ropen=ropen_mix rclosed=rclosed_mix
EMIXQ_c001_0_13 (mix_q_src_c001_0_13 0 bpf_c001_0 0) vcvs gain=-8.314696123025e-01
SMIXQ_c001_0_13 (mix_q_src_c001_0_13 mix_q_c001_0 win_0_13 0) relay vt1=-1m vt2=1m ropen=ropen_mix rclosed=rclosed_mix
EMIXI_c001_0_14 (mix_i_src_c001_0_14 0 bpf_c001_0 0) vcvs gain=8.314696123025e-01
SMIXI_c001_0_14 (mix_i_src_c001_0_14 mix_i_c001_0 win_0_14 0) relay vt1=-1m vt2=1m ropen=ropen_mix rclosed=rclosed_mix
EMIXQ_c001_0_14 (mix_q_src_c001_0_14 0 bpf_c001_0 0) vcvs gain=-5.555702330196e-01
SMIXQ_c001_0_14 (mix_q_src_c001_0_14 mix_q_c001_0 win_0_14 0) relay vt1=-1m vt2=1m ropen=ropen_mix rclosed=rclosed_mix
EMIXI_c001_0_15 (mix_i_src_c001_0_15 0 bpf_c001_0 0) vcvs gain=9.807852804032e-01
SMIXI_c001_0_15 (mix_i_src_c001_0_15 mix_i_c001_0 win_0_15 0) relay vt1=-1m vt2=1m ropen=ropen_mix rclosed=rclosed_mix
EMIXQ_c001_0_15 (mix_q_src_c001_0_15 0 bpf_c001_0 0) vcvs gain=-1.950903220161e-01
SMIXQ_c001_0_15 (mix_q_src_c001_0_15 mix_q_c001_0 win_0_15 0) relay vt1=-1m vt2=1m ropen=ropen_mix rclosed=rclosed_mix
RMIXI_c001_0 (mix_i_c001_0 0) resistor r=1G
RMIXQ_c001_0 (mix_q_c001_0 0) resistor r=1G
RINTI_c001_0 (mix_i_c001_0 Icar_c001_0) resistor r=1k
CINTI_c001_0 (Icar_c001_0 0) capacitor c=80p
RINTQ_c001_0 (mix_q_c001_0 Qcar_c001_0) resistor r=1k
CINTQ_c001_0 (Qcar_c001_0 0) capacitor c=80p
save bpf_c001_0 Icar_c001_0 Qcar_c001_0

// bl001, carrier_1: 500000000 Hz coherent I/Q phase-window verification-demod path
CBPF_c001_1 (bl001 n_cbpf_c001_1) capacitor c=1.013211836423e-13
LBPF_c001_1 (n_cbpf_c001_1 bpf_c001_1) inductor l=1.000000000000e-06
RBPF_c001_1 (bpf_c001_1 0) resistor r=1.570796326795e+02
EMIXI_c001_1_00 (mix_i_src_c001_1_00 0 bpf_c001_1 0) vcvs gain=9.807852804032e-01
SMIXI_c001_1_00 (mix_i_src_c001_1_00 mix_i_c001_1 win_1_00 0) relay vt1=-1m vt2=1m ropen=ropen_mix rclosed=rclosed_mix
EMIXQ_c001_1_00 (mix_q_src_c001_1_00 0 bpf_c001_1 0) vcvs gain=1.950903220161e-01
SMIXQ_c001_1_00 (mix_q_src_c001_1_00 mix_q_c001_1 win_1_00 0) relay vt1=-1m vt2=1m ropen=ropen_mix rclosed=rclosed_mix
EMIXI_c001_1_01 (mix_i_src_c001_1_01 0 bpf_c001_1 0) vcvs gain=8.314696123025e-01
SMIXI_c001_1_01 (mix_i_src_c001_1_01 mix_i_c001_1 win_1_01 0) relay vt1=-1m vt2=1m ropen=ropen_mix rclosed=rclosed_mix
EMIXQ_c001_1_01 (mix_q_src_c001_1_01 0 bpf_c001_1 0) vcvs gain=5.555702330196e-01
SMIXQ_c001_1_01 (mix_q_src_c001_1_01 mix_q_c001_1 win_1_01 0) relay vt1=-1m vt2=1m ropen=ropen_mix rclosed=rclosed_mix
EMIXI_c001_1_02 (mix_i_src_c001_1_02 0 bpf_c001_1 0) vcvs gain=5.555702330196e-01
SMIXI_c001_1_02 (mix_i_src_c001_1_02 mix_i_c001_1 win_1_02 0) relay vt1=-1m vt2=1m ropen=ropen_mix rclosed=rclosed_mix
EMIXQ_c001_1_02 (mix_q_src_c001_1_02 0 bpf_c001_1 0) vcvs gain=8.314696123025e-01
SMIXQ_c001_1_02 (mix_q_src_c001_1_02 mix_q_c001_1 win_1_02 0) relay vt1=-1m vt2=1m ropen=ropen_mix rclosed=rclosed_mix
EMIXI_c001_1_03 (mix_i_src_c001_1_03 0 bpf_c001_1 0) vcvs gain=1.950903220161e-01
SMIXI_c001_1_03 (mix_i_src_c001_1_03 mix_i_c001_1 win_1_03 0) relay vt1=-1m vt2=1m ropen=ropen_mix rclosed=rclosed_mix
EMIXQ_c001_1_03 (mix_q_src_c001_1_03 0 bpf_c001_1 0) vcvs gain=9.807852804032e-01
SMIXQ_c001_1_03 (mix_q_src_c001_1_03 mix_q_c001_1 win_1_03 0) relay vt1=-1m vt2=1m ropen=ropen_mix rclosed=rclosed_mix
EMIXI_c001_1_04 (mix_i_src_c001_1_04 0 bpf_c001_1 0) vcvs gain=-1.950903220161e-01
SMIXI_c001_1_04 (mix_i_src_c001_1_04 mix_i_c001_1 win_1_04 0) relay vt1=-1m vt2=1m ropen=ropen_mix rclosed=rclosed_mix
EMIXQ_c001_1_04 (mix_q_src_c001_1_04 0 bpf_c001_1 0) vcvs gain=9.807852804032e-01
SMIXQ_c001_1_04 (mix_q_src_c001_1_04 mix_q_c001_1 win_1_04 0) relay vt1=-1m vt2=1m ropen=ropen_mix rclosed=rclosed_mix
EMIXI_c001_1_05 (mix_i_src_c001_1_05 0 bpf_c001_1 0) vcvs gain=-5.555702330196e-01
SMIXI_c001_1_05 (mix_i_src_c001_1_05 mix_i_c001_1 win_1_05 0) relay vt1=-1m vt2=1m ropen=ropen_mix rclosed=rclosed_mix
EMIXQ_c001_1_05 (mix_q_src_c001_1_05 0 bpf_c001_1 0) vcvs gain=8.314696123025e-01
SMIXQ_c001_1_05 (mix_q_src_c001_1_05 mix_q_c001_1 win_1_05 0) relay vt1=-1m vt2=1m ropen=ropen_mix rclosed=rclosed_mix
EMIXI_c001_1_06 (mix_i_src_c001_1_06 0 bpf_c001_1 0) vcvs gain=-8.314696123025e-01
SMIXI_c001_1_06 (mix_i_src_c001_1_06 mix_i_c001_1 win_1_06 0) relay vt1=-1m vt2=1m ropen=ropen_mix rclosed=rclosed_mix
EMIXQ_c001_1_06 (mix_q_src_c001_1_06 0 bpf_c001_1 0) vcvs gain=5.555702330196e-01
SMIXQ_c001_1_06 (mix_q_src_c001_1_06 mix_q_c001_1 win_1_06 0) relay vt1=-1m vt2=1m ropen=ropen_mix rclosed=rclosed_mix
EMIXI_c001_1_07 (mix_i_src_c001_1_07 0 bpf_c001_1 0) vcvs gain=-9.807852804032e-01
SMIXI_c001_1_07 (mix_i_src_c001_1_07 mix_i_c001_1 win_1_07 0) relay vt1=-1m vt2=1m ropen=ropen_mix rclosed=rclosed_mix
EMIXQ_c001_1_07 (mix_q_src_c001_1_07 0 bpf_c001_1 0) vcvs gain=1.950903220161e-01
SMIXQ_c001_1_07 (mix_q_src_c001_1_07 mix_q_c001_1 win_1_07 0) relay vt1=-1m vt2=1m ropen=ropen_mix rclosed=rclosed_mix
EMIXI_c001_1_08 (mix_i_src_c001_1_08 0 bpf_c001_1 0) vcvs gain=-9.807852804032e-01
SMIXI_c001_1_08 (mix_i_src_c001_1_08 mix_i_c001_1 win_1_08 0) relay vt1=-1m vt2=1m ropen=ropen_mix rclosed=rclosed_mix
EMIXQ_c001_1_08 (mix_q_src_c001_1_08 0 bpf_c001_1 0) vcvs gain=-1.950903220161e-01
SMIXQ_c001_1_08 (mix_q_src_c001_1_08 mix_q_c001_1 win_1_08 0) relay vt1=-1m vt2=1m ropen=ropen_mix rclosed=rclosed_mix
EMIXI_c001_1_09 (mix_i_src_c001_1_09 0 bpf_c001_1 0) vcvs gain=-8.314696123025e-01
SMIXI_c001_1_09 (mix_i_src_c001_1_09 mix_i_c001_1 win_1_09 0) relay vt1=-1m vt2=1m ropen=ropen_mix rclosed=rclosed_mix
EMIXQ_c001_1_09 (mix_q_src_c001_1_09 0 bpf_c001_1 0) vcvs gain=-5.555702330196e-01
SMIXQ_c001_1_09 (mix_q_src_c001_1_09 mix_q_c001_1 win_1_09 0) relay vt1=-1m vt2=1m ropen=ropen_mix rclosed=rclosed_mix
EMIXI_c001_1_10 (mix_i_src_c001_1_10 0 bpf_c001_1 0) vcvs gain=-5.555702330196e-01
SMIXI_c001_1_10 (mix_i_src_c001_1_10 mix_i_c001_1 win_1_10 0) relay vt1=-1m vt2=1m ropen=ropen_mix rclosed=rclosed_mix
EMIXQ_c001_1_10 (mix_q_src_c001_1_10 0 bpf_c001_1 0) vcvs gain=-8.314696123025e-01
SMIXQ_c001_1_10 (mix_q_src_c001_1_10 mix_q_c001_1 win_1_10 0) relay vt1=-1m vt2=1m ropen=ropen_mix rclosed=rclosed_mix
EMIXI_c001_1_11 (mix_i_src_c001_1_11 0 bpf_c001_1 0) vcvs gain=-1.950903220161e-01
SMIXI_c001_1_11 (mix_i_src_c001_1_11 mix_i_c001_1 win_1_11 0) relay vt1=-1m vt2=1m ropen=ropen_mix rclosed=rclosed_mix
EMIXQ_c001_1_11 (mix_q_src_c001_1_11 0 bpf_c001_1 0) vcvs gain=-9.807852804032e-01
SMIXQ_c001_1_11 (mix_q_src_c001_1_11 mix_q_c001_1 win_1_11 0) relay vt1=-1m vt2=1m ropen=ropen_mix rclosed=rclosed_mix
EMIXI_c001_1_12 (mix_i_src_c001_1_12 0 bpf_c001_1 0) vcvs gain=1.950903220161e-01
SMIXI_c001_1_12 (mix_i_src_c001_1_12 mix_i_c001_1 win_1_12 0) relay vt1=-1m vt2=1m ropen=ropen_mix rclosed=rclosed_mix
EMIXQ_c001_1_12 (mix_q_src_c001_1_12 0 bpf_c001_1 0) vcvs gain=-9.807852804032e-01
SMIXQ_c001_1_12 (mix_q_src_c001_1_12 mix_q_c001_1 win_1_12 0) relay vt1=-1m vt2=1m ropen=ropen_mix rclosed=rclosed_mix
EMIXI_c001_1_13 (mix_i_src_c001_1_13 0 bpf_c001_1 0) vcvs gain=5.555702330196e-01
SMIXI_c001_1_13 (mix_i_src_c001_1_13 mix_i_c001_1 win_1_13 0) relay vt1=-1m vt2=1m ropen=ropen_mix rclosed=rclosed_mix
EMIXQ_c001_1_13 (mix_q_src_c001_1_13 0 bpf_c001_1 0) vcvs gain=-8.314696123025e-01
SMIXQ_c001_1_13 (mix_q_src_c001_1_13 mix_q_c001_1 win_1_13 0) relay vt1=-1m vt2=1m ropen=ropen_mix rclosed=rclosed_mix
EMIXI_c001_1_14 (mix_i_src_c001_1_14 0 bpf_c001_1 0) vcvs gain=8.314696123025e-01
SMIXI_c001_1_14 (mix_i_src_c001_1_14 mix_i_c001_1 win_1_14 0) relay vt1=-1m vt2=1m ropen=ropen_mix rclosed=rclosed_mix
EMIXQ_c001_1_14 (mix_q_src_c001_1_14 0 bpf_c001_1 0) vcvs gain=-5.555702330196e-01
SMIXQ_c001_1_14 (mix_q_src_c001_1_14 mix_q_c001_1 win_1_14 0) relay vt1=-1m vt2=1m ropen=ropen_mix rclosed=rclosed_mix
EMIXI_c001_1_15 (mix_i_src_c001_1_15 0 bpf_c001_1 0) vcvs gain=9.807852804032e-01
SMIXI_c001_1_15 (mix_i_src_c001_1_15 mix_i_c001_1 win_1_15 0) relay vt1=-1m vt2=1m ropen=ropen_mix rclosed=rclosed_mix
EMIXQ_c001_1_15 (mix_q_src_c001_1_15 0 bpf_c001_1 0) vcvs gain=-1.950903220161e-01
SMIXQ_c001_1_15 (mix_q_src_c001_1_15 mix_q_c001_1 win_1_15 0) relay vt1=-1m vt2=1m ropen=ropen_mix rclosed=rclosed_mix
RMIXI_c001_1 (mix_i_c001_1 0) resistor r=1G
RMIXQ_c001_1 (mix_q_c001_1 0) resistor r=1G
RINTI_c001_1 (mix_i_c001_1 Icar_c001_1) resistor r=1k
CINTI_c001_1 (Icar_c001_1 0) capacitor c=80p
RINTQ_c001_1 (mix_q_c001_1 Qcar_c001_1) resistor r=1k
CINTQ_c001_1 (Qcar_c001_1 0) capacitor c=80p
save bpf_c001_1 Icar_c001_1 Qcar_c001_1

// bl001, carrier_2: 750000000 Hz coherent I/Q phase-window verification-demod path
CBPF_c001_2 (bl001 n_cbpf_c001_2) capacitor c=4.503163717437e-14
LBPF_c001_2 (n_cbpf_c001_2 bpf_c001_2) inductor l=1.000000000000e-06
RBPF_c001_2 (bpf_c001_2 0) resistor r=2.356194490192e+02
EMIXI_c001_2_00 (mix_i_src_c001_2_00 0 bpf_c001_2 0) vcvs gain=9.807852804032e-01
SMIXI_c001_2_00 (mix_i_src_c001_2_00 mix_i_c001_2 win_2_00 0) relay vt1=-1m vt2=1m ropen=ropen_mix rclosed=rclosed_mix
EMIXQ_c001_2_00 (mix_q_src_c001_2_00 0 bpf_c001_2 0) vcvs gain=1.950903220161e-01
SMIXQ_c001_2_00 (mix_q_src_c001_2_00 mix_q_c001_2 win_2_00 0) relay vt1=-1m vt2=1m ropen=ropen_mix rclosed=rclosed_mix
EMIXI_c001_2_01 (mix_i_src_c001_2_01 0 bpf_c001_2 0) vcvs gain=8.314696123025e-01
SMIXI_c001_2_01 (mix_i_src_c001_2_01 mix_i_c001_2 win_2_01 0) relay vt1=-1m vt2=1m ropen=ropen_mix rclosed=rclosed_mix
EMIXQ_c001_2_01 (mix_q_src_c001_2_01 0 bpf_c001_2 0) vcvs gain=5.555702330196e-01
SMIXQ_c001_2_01 (mix_q_src_c001_2_01 mix_q_c001_2 win_2_01 0) relay vt1=-1m vt2=1m ropen=ropen_mix rclosed=rclosed_mix
EMIXI_c001_2_02 (mix_i_src_c001_2_02 0 bpf_c001_2 0) vcvs gain=5.555702330196e-01
SMIXI_c001_2_02 (mix_i_src_c001_2_02 mix_i_c001_2 win_2_02 0) relay vt1=-1m vt2=1m ropen=ropen_mix rclosed=rclosed_mix
EMIXQ_c001_2_02 (mix_q_src_c001_2_02 0 bpf_c001_2 0) vcvs gain=8.314696123025e-01
SMIXQ_c001_2_02 (mix_q_src_c001_2_02 mix_q_c001_2 win_2_02 0) relay vt1=-1m vt2=1m ropen=ropen_mix rclosed=rclosed_mix
EMIXI_c001_2_03 (mix_i_src_c001_2_03 0 bpf_c001_2 0) vcvs gain=1.950903220161e-01
SMIXI_c001_2_03 (mix_i_src_c001_2_03 mix_i_c001_2 win_2_03 0) relay vt1=-1m vt2=1m ropen=ropen_mix rclosed=rclosed_mix
EMIXQ_c001_2_03 (mix_q_src_c001_2_03 0 bpf_c001_2 0) vcvs gain=9.807852804032e-01
SMIXQ_c001_2_03 (mix_q_src_c001_2_03 mix_q_c001_2 win_2_03 0) relay vt1=-1m vt2=1m ropen=ropen_mix rclosed=rclosed_mix
EMIXI_c001_2_04 (mix_i_src_c001_2_04 0 bpf_c001_2 0) vcvs gain=-1.950903220161e-01
SMIXI_c001_2_04 (mix_i_src_c001_2_04 mix_i_c001_2 win_2_04 0) relay vt1=-1m vt2=1m ropen=ropen_mix rclosed=rclosed_mix
EMIXQ_c001_2_04 (mix_q_src_c001_2_04 0 bpf_c001_2 0) vcvs gain=9.807852804032e-01
SMIXQ_c001_2_04 (mix_q_src_c001_2_04 mix_q_c001_2 win_2_04 0) relay vt1=-1m vt2=1m ropen=ropen_mix rclosed=rclosed_mix
EMIXI_c001_2_05 (mix_i_src_c001_2_05 0 bpf_c001_2 0) vcvs gain=-5.555702330196e-01
SMIXI_c001_2_05 (mix_i_src_c001_2_05 mix_i_c001_2 win_2_05 0) relay vt1=-1m vt2=1m ropen=ropen_mix rclosed=rclosed_mix
EMIXQ_c001_2_05 (mix_q_src_c001_2_05 0 bpf_c001_2 0) vcvs gain=8.314696123025e-01
SMIXQ_c001_2_05 (mix_q_src_c001_2_05 mix_q_c001_2 win_2_05 0) relay vt1=-1m vt2=1m ropen=ropen_mix rclosed=rclosed_mix
EMIXI_c001_2_06 (mix_i_src_c001_2_06 0 bpf_c001_2 0) vcvs gain=-8.314696123025e-01
SMIXI_c001_2_06 (mix_i_src_c001_2_06 mix_i_c001_2 win_2_06 0) relay vt1=-1m vt2=1m ropen=ropen_mix rclosed=rclosed_mix
EMIXQ_c001_2_06 (mix_q_src_c001_2_06 0 bpf_c001_2 0) vcvs gain=5.555702330196e-01
SMIXQ_c001_2_06 (mix_q_src_c001_2_06 mix_q_c001_2 win_2_06 0) relay vt1=-1m vt2=1m ropen=ropen_mix rclosed=rclosed_mix
EMIXI_c001_2_07 (mix_i_src_c001_2_07 0 bpf_c001_2 0) vcvs gain=-9.807852804032e-01
SMIXI_c001_2_07 (mix_i_src_c001_2_07 mix_i_c001_2 win_2_07 0) relay vt1=-1m vt2=1m ropen=ropen_mix rclosed=rclosed_mix
EMIXQ_c001_2_07 (mix_q_src_c001_2_07 0 bpf_c001_2 0) vcvs gain=1.950903220161e-01
SMIXQ_c001_2_07 (mix_q_src_c001_2_07 mix_q_c001_2 win_2_07 0) relay vt1=-1m vt2=1m ropen=ropen_mix rclosed=rclosed_mix
EMIXI_c001_2_08 (mix_i_src_c001_2_08 0 bpf_c001_2 0) vcvs gain=-9.807852804032e-01
SMIXI_c001_2_08 (mix_i_src_c001_2_08 mix_i_c001_2 win_2_08 0) relay vt1=-1m vt2=1m ropen=ropen_mix rclosed=rclosed_mix
EMIXQ_c001_2_08 (mix_q_src_c001_2_08 0 bpf_c001_2 0) vcvs gain=-1.950903220161e-01
SMIXQ_c001_2_08 (mix_q_src_c001_2_08 mix_q_c001_2 win_2_08 0) relay vt1=-1m vt2=1m ropen=ropen_mix rclosed=rclosed_mix
EMIXI_c001_2_09 (mix_i_src_c001_2_09 0 bpf_c001_2 0) vcvs gain=-8.314696123025e-01
SMIXI_c001_2_09 (mix_i_src_c001_2_09 mix_i_c001_2 win_2_09 0) relay vt1=-1m vt2=1m ropen=ropen_mix rclosed=rclosed_mix
EMIXQ_c001_2_09 (mix_q_src_c001_2_09 0 bpf_c001_2 0) vcvs gain=-5.555702330196e-01
SMIXQ_c001_2_09 (mix_q_src_c001_2_09 mix_q_c001_2 win_2_09 0) relay vt1=-1m vt2=1m ropen=ropen_mix rclosed=rclosed_mix
EMIXI_c001_2_10 (mix_i_src_c001_2_10 0 bpf_c001_2 0) vcvs gain=-5.555702330196e-01
SMIXI_c001_2_10 (mix_i_src_c001_2_10 mix_i_c001_2 win_2_10 0) relay vt1=-1m vt2=1m ropen=ropen_mix rclosed=rclosed_mix
EMIXQ_c001_2_10 (mix_q_src_c001_2_10 0 bpf_c001_2 0) vcvs gain=-8.314696123025e-01
SMIXQ_c001_2_10 (mix_q_src_c001_2_10 mix_q_c001_2 win_2_10 0) relay vt1=-1m vt2=1m ropen=ropen_mix rclosed=rclosed_mix
EMIXI_c001_2_11 (mix_i_src_c001_2_11 0 bpf_c001_2 0) vcvs gain=-1.950903220161e-01
SMIXI_c001_2_11 (mix_i_src_c001_2_11 mix_i_c001_2 win_2_11 0) relay vt1=-1m vt2=1m ropen=ropen_mix rclosed=rclosed_mix
EMIXQ_c001_2_11 (mix_q_src_c001_2_11 0 bpf_c001_2 0) vcvs gain=-9.807852804032e-01
SMIXQ_c001_2_11 (mix_q_src_c001_2_11 mix_q_c001_2 win_2_11 0) relay vt1=-1m vt2=1m ropen=ropen_mix rclosed=rclosed_mix
EMIXI_c001_2_12 (mix_i_src_c001_2_12 0 bpf_c001_2 0) vcvs gain=1.950903220161e-01
SMIXI_c001_2_12 (mix_i_src_c001_2_12 mix_i_c001_2 win_2_12 0) relay vt1=-1m vt2=1m ropen=ropen_mix rclosed=rclosed_mix
EMIXQ_c001_2_12 (mix_q_src_c001_2_12 0 bpf_c001_2 0) vcvs gain=-9.807852804032e-01
SMIXQ_c001_2_12 (mix_q_src_c001_2_12 mix_q_c001_2 win_2_12 0) relay vt1=-1m vt2=1m ropen=ropen_mix rclosed=rclosed_mix
EMIXI_c001_2_13 (mix_i_src_c001_2_13 0 bpf_c001_2 0) vcvs gain=5.555702330196e-01
SMIXI_c001_2_13 (mix_i_src_c001_2_13 mix_i_c001_2 win_2_13 0) relay vt1=-1m vt2=1m ropen=ropen_mix rclosed=rclosed_mix
EMIXQ_c001_2_13 (mix_q_src_c001_2_13 0 bpf_c001_2 0) vcvs gain=-8.314696123025e-01
SMIXQ_c001_2_13 (mix_q_src_c001_2_13 mix_q_c001_2 win_2_13 0) relay vt1=-1m vt2=1m ropen=ropen_mix rclosed=rclosed_mix
EMIXI_c001_2_14 (mix_i_src_c001_2_14 0 bpf_c001_2 0) vcvs gain=8.314696123025e-01
SMIXI_c001_2_14 (mix_i_src_c001_2_14 mix_i_c001_2 win_2_14 0) relay vt1=-1m vt2=1m ropen=ropen_mix rclosed=rclosed_mix
EMIXQ_c001_2_14 (mix_q_src_c001_2_14 0 bpf_c001_2 0) vcvs gain=-5.555702330196e-01
SMIXQ_c001_2_14 (mix_q_src_c001_2_14 mix_q_c001_2 win_2_14 0) relay vt1=-1m vt2=1m ropen=ropen_mix rclosed=rclosed_mix
EMIXI_c001_2_15 (mix_i_src_c001_2_15 0 bpf_c001_2 0) vcvs gain=9.807852804032e-01
SMIXI_c001_2_15 (mix_i_src_c001_2_15 mix_i_c001_2 win_2_15 0) relay vt1=-1m vt2=1m ropen=ropen_mix rclosed=rclosed_mix
EMIXQ_c001_2_15 (mix_q_src_c001_2_15 0 bpf_c001_2 0) vcvs gain=-1.950903220161e-01
SMIXQ_c001_2_15 (mix_q_src_c001_2_15 mix_q_c001_2 win_2_15 0) relay vt1=-1m vt2=1m ropen=ropen_mix rclosed=rclosed_mix
RMIXI_c001_2 (mix_i_c001_2 0) resistor r=1G
RMIXQ_c001_2 (mix_q_c001_2 0) resistor r=1G
RINTI_c001_2 (mix_i_c001_2 Icar_c001_2) resistor r=1k
CINTI_c001_2 (Icar_c001_2 0) capacitor c=80p
RINTQ_c001_2 (mix_q_c001_2 Qcar_c001_2) resistor r=1k
CINTQ_c001_2 (Qcar_c001_2 0) capacitor c=80p
save bpf_c001_2 Icar_c001_2 Qcar_c001_2

// bl001, carrier_3: 1000000000 Hz coherent I/Q phase-window verification-demod path
CBPF_c001_3 (bl001 n_cbpf_c001_3) capacitor c=2.533029591058e-14
LBPF_c001_3 (n_cbpf_c001_3 bpf_c001_3) inductor l=1.000000000000e-06
RBPF_c001_3 (bpf_c001_3 0) resistor r=3.141592653590e+02
EMIXI_c001_3_00 (mix_i_src_c001_3_00 0 bpf_c001_3 0) vcvs gain=9.807852804032e-01
SMIXI_c001_3_00 (mix_i_src_c001_3_00 mix_i_c001_3 win_3_00 0) relay vt1=-1m vt2=1m ropen=ropen_mix rclosed=rclosed_mix
EMIXQ_c001_3_00 (mix_q_src_c001_3_00 0 bpf_c001_3 0) vcvs gain=1.950903220161e-01
SMIXQ_c001_3_00 (mix_q_src_c001_3_00 mix_q_c001_3 win_3_00 0) relay vt1=-1m vt2=1m ropen=ropen_mix rclosed=rclosed_mix
EMIXI_c001_3_01 (mix_i_src_c001_3_01 0 bpf_c001_3 0) vcvs gain=8.314696123025e-01
SMIXI_c001_3_01 (mix_i_src_c001_3_01 mix_i_c001_3 win_3_01 0) relay vt1=-1m vt2=1m ropen=ropen_mix rclosed=rclosed_mix
EMIXQ_c001_3_01 (mix_q_src_c001_3_01 0 bpf_c001_3 0) vcvs gain=5.555702330196e-01
SMIXQ_c001_3_01 (mix_q_src_c001_3_01 mix_q_c001_3 win_3_01 0) relay vt1=-1m vt2=1m ropen=ropen_mix rclosed=rclosed_mix
EMIXI_c001_3_02 (mix_i_src_c001_3_02 0 bpf_c001_3 0) vcvs gain=5.555702330196e-01
SMIXI_c001_3_02 (mix_i_src_c001_3_02 mix_i_c001_3 win_3_02 0) relay vt1=-1m vt2=1m ropen=ropen_mix rclosed=rclosed_mix
EMIXQ_c001_3_02 (mix_q_src_c001_3_02 0 bpf_c001_3 0) vcvs gain=8.314696123025e-01
SMIXQ_c001_3_02 (mix_q_src_c001_3_02 mix_q_c001_3 win_3_02 0) relay vt1=-1m vt2=1m ropen=ropen_mix rclosed=rclosed_mix
EMIXI_c001_3_03 (mix_i_src_c001_3_03 0 bpf_c001_3 0) vcvs gain=1.950903220161e-01
SMIXI_c001_3_03 (mix_i_src_c001_3_03 mix_i_c001_3 win_3_03 0) relay vt1=-1m vt2=1m ropen=ropen_mix rclosed=rclosed_mix
EMIXQ_c001_3_03 (mix_q_src_c001_3_03 0 bpf_c001_3 0) vcvs gain=9.807852804032e-01
SMIXQ_c001_3_03 (mix_q_src_c001_3_03 mix_q_c001_3 win_3_03 0) relay vt1=-1m vt2=1m ropen=ropen_mix rclosed=rclosed_mix
EMIXI_c001_3_04 (mix_i_src_c001_3_04 0 bpf_c001_3 0) vcvs gain=-1.950903220161e-01
SMIXI_c001_3_04 (mix_i_src_c001_3_04 mix_i_c001_3 win_3_04 0) relay vt1=-1m vt2=1m ropen=ropen_mix rclosed=rclosed_mix
EMIXQ_c001_3_04 (mix_q_src_c001_3_04 0 bpf_c001_3 0) vcvs gain=9.807852804032e-01
SMIXQ_c001_3_04 (mix_q_src_c001_3_04 mix_q_c001_3 win_3_04 0) relay vt1=-1m vt2=1m ropen=ropen_mix rclosed=rclosed_mix
EMIXI_c001_3_05 (mix_i_src_c001_3_05 0 bpf_c001_3 0) vcvs gain=-5.555702330196e-01
SMIXI_c001_3_05 (mix_i_src_c001_3_05 mix_i_c001_3 win_3_05 0) relay vt1=-1m vt2=1m ropen=ropen_mix rclosed=rclosed_mix
EMIXQ_c001_3_05 (mix_q_src_c001_3_05 0 bpf_c001_3 0) vcvs gain=8.314696123025e-01
SMIXQ_c001_3_05 (mix_q_src_c001_3_05 mix_q_c001_3 win_3_05 0) relay vt1=-1m vt2=1m ropen=ropen_mix rclosed=rclosed_mix
EMIXI_c001_3_06 (mix_i_src_c001_3_06 0 bpf_c001_3 0) vcvs gain=-8.314696123025e-01
SMIXI_c001_3_06 (mix_i_src_c001_3_06 mix_i_c001_3 win_3_06 0) relay vt1=-1m vt2=1m ropen=ropen_mix rclosed=rclosed_mix
EMIXQ_c001_3_06 (mix_q_src_c001_3_06 0 bpf_c001_3 0) vcvs gain=5.555702330196e-01
SMIXQ_c001_3_06 (mix_q_src_c001_3_06 mix_q_c001_3 win_3_06 0) relay vt1=-1m vt2=1m ropen=ropen_mix rclosed=rclosed_mix
EMIXI_c001_3_07 (mix_i_src_c001_3_07 0 bpf_c001_3 0) vcvs gain=-9.807852804032e-01
SMIXI_c001_3_07 (mix_i_src_c001_3_07 mix_i_c001_3 win_3_07 0) relay vt1=-1m vt2=1m ropen=ropen_mix rclosed=rclosed_mix
EMIXQ_c001_3_07 (mix_q_src_c001_3_07 0 bpf_c001_3 0) vcvs gain=1.950903220161e-01
SMIXQ_c001_3_07 (mix_q_src_c001_3_07 mix_q_c001_3 win_3_07 0) relay vt1=-1m vt2=1m ropen=ropen_mix rclosed=rclosed_mix
EMIXI_c001_3_08 (mix_i_src_c001_3_08 0 bpf_c001_3 0) vcvs gain=-9.807852804032e-01
SMIXI_c001_3_08 (mix_i_src_c001_3_08 mix_i_c001_3 win_3_08 0) relay vt1=-1m vt2=1m ropen=ropen_mix rclosed=rclosed_mix
EMIXQ_c001_3_08 (mix_q_src_c001_3_08 0 bpf_c001_3 0) vcvs gain=-1.950903220161e-01
SMIXQ_c001_3_08 (mix_q_src_c001_3_08 mix_q_c001_3 win_3_08 0) relay vt1=-1m vt2=1m ropen=ropen_mix rclosed=rclosed_mix
EMIXI_c001_3_09 (mix_i_src_c001_3_09 0 bpf_c001_3 0) vcvs gain=-8.314696123025e-01
SMIXI_c001_3_09 (mix_i_src_c001_3_09 mix_i_c001_3 win_3_09 0) relay vt1=-1m vt2=1m ropen=ropen_mix rclosed=rclosed_mix
EMIXQ_c001_3_09 (mix_q_src_c001_3_09 0 bpf_c001_3 0) vcvs gain=-5.555702330196e-01
SMIXQ_c001_3_09 (mix_q_src_c001_3_09 mix_q_c001_3 win_3_09 0) relay vt1=-1m vt2=1m ropen=ropen_mix rclosed=rclosed_mix
EMIXI_c001_3_10 (mix_i_src_c001_3_10 0 bpf_c001_3 0) vcvs gain=-5.555702330196e-01
SMIXI_c001_3_10 (mix_i_src_c001_3_10 mix_i_c001_3 win_3_10 0) relay vt1=-1m vt2=1m ropen=ropen_mix rclosed=rclosed_mix
EMIXQ_c001_3_10 (mix_q_src_c001_3_10 0 bpf_c001_3 0) vcvs gain=-8.314696123025e-01
SMIXQ_c001_3_10 (mix_q_src_c001_3_10 mix_q_c001_3 win_3_10 0) relay vt1=-1m vt2=1m ropen=ropen_mix rclosed=rclosed_mix
EMIXI_c001_3_11 (mix_i_src_c001_3_11 0 bpf_c001_3 0) vcvs gain=-1.950903220161e-01
SMIXI_c001_3_11 (mix_i_src_c001_3_11 mix_i_c001_3 win_3_11 0) relay vt1=-1m vt2=1m ropen=ropen_mix rclosed=rclosed_mix
EMIXQ_c001_3_11 (mix_q_src_c001_3_11 0 bpf_c001_3 0) vcvs gain=-9.807852804032e-01
SMIXQ_c001_3_11 (mix_q_src_c001_3_11 mix_q_c001_3 win_3_11 0) relay vt1=-1m vt2=1m ropen=ropen_mix rclosed=rclosed_mix
EMIXI_c001_3_12 (mix_i_src_c001_3_12 0 bpf_c001_3 0) vcvs gain=1.950903220161e-01
SMIXI_c001_3_12 (mix_i_src_c001_3_12 mix_i_c001_3 win_3_12 0) relay vt1=-1m vt2=1m ropen=ropen_mix rclosed=rclosed_mix
EMIXQ_c001_3_12 (mix_q_src_c001_3_12 0 bpf_c001_3 0) vcvs gain=-9.807852804032e-01
SMIXQ_c001_3_12 (mix_q_src_c001_3_12 mix_q_c001_3 win_3_12 0) relay vt1=-1m vt2=1m ropen=ropen_mix rclosed=rclosed_mix
EMIXI_c001_3_13 (mix_i_src_c001_3_13 0 bpf_c001_3 0) vcvs gain=5.555702330196e-01
SMIXI_c001_3_13 (mix_i_src_c001_3_13 mix_i_c001_3 win_3_13 0) relay vt1=-1m vt2=1m ropen=ropen_mix rclosed=rclosed_mix
EMIXQ_c001_3_13 (mix_q_src_c001_3_13 0 bpf_c001_3 0) vcvs gain=-8.314696123025e-01
SMIXQ_c001_3_13 (mix_q_src_c001_3_13 mix_q_c001_3 win_3_13 0) relay vt1=-1m vt2=1m ropen=ropen_mix rclosed=rclosed_mix
EMIXI_c001_3_14 (mix_i_src_c001_3_14 0 bpf_c001_3 0) vcvs gain=8.314696123025e-01
SMIXI_c001_3_14 (mix_i_src_c001_3_14 mix_i_c001_3 win_3_14 0) relay vt1=-1m vt2=1m ropen=ropen_mix rclosed=rclosed_mix
EMIXQ_c001_3_14 (mix_q_src_c001_3_14 0 bpf_c001_3 0) vcvs gain=-5.555702330196e-01
SMIXQ_c001_3_14 (mix_q_src_c001_3_14 mix_q_c001_3 win_3_14 0) relay vt1=-1m vt2=1m ropen=ropen_mix rclosed=rclosed_mix
EMIXI_c001_3_15 (mix_i_src_c001_3_15 0 bpf_c001_3 0) vcvs gain=9.807852804032e-01
SMIXI_c001_3_15 (mix_i_src_c001_3_15 mix_i_c001_3 win_3_15 0) relay vt1=-1m vt2=1m ropen=ropen_mix rclosed=rclosed_mix
EMIXQ_c001_3_15 (mix_q_src_c001_3_15 0 bpf_c001_3 0) vcvs gain=-1.950903220161e-01
SMIXQ_c001_3_15 (mix_q_src_c001_3_15 mix_q_c001_3 win_3_15 0) relay vt1=-1m vt2=1m ropen=ropen_mix rclosed=rclosed_mix
RMIXI_c001_3 (mix_i_c001_3 0) resistor r=1G
RMIXQ_c001_3 (mix_q_c001_3 0) resistor r=1G
RINTI_c001_3 (mix_i_c001_3 Icar_c001_3) resistor r=1k
CINTI_c001_3 (Icar_c001_3 0) capacitor c=80p
RINTQ_c001_3 (mix_q_c001_3 Qcar_c001_3) resistor r=1k
CINTQ_c001_3 (Qcar_c001_3 0) capacitor c=80p
save bpf_c001_3 Icar_c001_3 Qcar_c001_3

// bl002, carrier_0: 250000000 Hz coherent I/Q phase-window verification-demod path
CBPF_c002_0 (bl002 n_cbpf_c002_0) capacitor c=4.052847345694e-13
LBPF_c002_0 (n_cbpf_c002_0 bpf_c002_0) inductor l=1.000000000000e-06
RBPF_c002_0 (bpf_c002_0 0) resistor r=7.853981633974e+01
EMIXI_c002_0_00 (mix_i_src_c002_0_00 0 bpf_c002_0 0) vcvs gain=9.807852804032e-01
SMIXI_c002_0_00 (mix_i_src_c002_0_00 mix_i_c002_0 win_0_00 0) relay vt1=-1m vt2=1m ropen=ropen_mix rclosed=rclosed_mix
EMIXQ_c002_0_00 (mix_q_src_c002_0_00 0 bpf_c002_0 0) vcvs gain=1.950903220161e-01
SMIXQ_c002_0_00 (mix_q_src_c002_0_00 mix_q_c002_0 win_0_00 0) relay vt1=-1m vt2=1m ropen=ropen_mix rclosed=rclosed_mix
EMIXI_c002_0_01 (mix_i_src_c002_0_01 0 bpf_c002_0 0) vcvs gain=8.314696123025e-01
SMIXI_c002_0_01 (mix_i_src_c002_0_01 mix_i_c002_0 win_0_01 0) relay vt1=-1m vt2=1m ropen=ropen_mix rclosed=rclosed_mix
EMIXQ_c002_0_01 (mix_q_src_c002_0_01 0 bpf_c002_0 0) vcvs gain=5.555702330196e-01
SMIXQ_c002_0_01 (mix_q_src_c002_0_01 mix_q_c002_0 win_0_01 0) relay vt1=-1m vt2=1m ropen=ropen_mix rclosed=rclosed_mix
EMIXI_c002_0_02 (mix_i_src_c002_0_02 0 bpf_c002_0 0) vcvs gain=5.555702330196e-01
SMIXI_c002_0_02 (mix_i_src_c002_0_02 mix_i_c002_0 win_0_02 0) relay vt1=-1m vt2=1m ropen=ropen_mix rclosed=rclosed_mix
EMIXQ_c002_0_02 (mix_q_src_c002_0_02 0 bpf_c002_0 0) vcvs gain=8.314696123025e-01
SMIXQ_c002_0_02 (mix_q_src_c002_0_02 mix_q_c002_0 win_0_02 0) relay vt1=-1m vt2=1m ropen=ropen_mix rclosed=rclosed_mix
EMIXI_c002_0_03 (mix_i_src_c002_0_03 0 bpf_c002_0 0) vcvs gain=1.950903220161e-01
SMIXI_c002_0_03 (mix_i_src_c002_0_03 mix_i_c002_0 win_0_03 0) relay vt1=-1m vt2=1m ropen=ropen_mix rclosed=rclosed_mix
EMIXQ_c002_0_03 (mix_q_src_c002_0_03 0 bpf_c002_0 0) vcvs gain=9.807852804032e-01
SMIXQ_c002_0_03 (mix_q_src_c002_0_03 mix_q_c002_0 win_0_03 0) relay vt1=-1m vt2=1m ropen=ropen_mix rclosed=rclosed_mix
EMIXI_c002_0_04 (mix_i_src_c002_0_04 0 bpf_c002_0 0) vcvs gain=-1.950903220161e-01
SMIXI_c002_0_04 (mix_i_src_c002_0_04 mix_i_c002_0 win_0_04 0) relay vt1=-1m vt2=1m ropen=ropen_mix rclosed=rclosed_mix
EMIXQ_c002_0_04 (mix_q_src_c002_0_04 0 bpf_c002_0 0) vcvs gain=9.807852804032e-01
SMIXQ_c002_0_04 (mix_q_src_c002_0_04 mix_q_c002_0 win_0_04 0) relay vt1=-1m vt2=1m ropen=ropen_mix rclosed=rclosed_mix
EMIXI_c002_0_05 (mix_i_src_c002_0_05 0 bpf_c002_0 0) vcvs gain=-5.555702330196e-01
SMIXI_c002_0_05 (mix_i_src_c002_0_05 mix_i_c002_0 win_0_05 0) relay vt1=-1m vt2=1m ropen=ropen_mix rclosed=rclosed_mix
EMIXQ_c002_0_05 (mix_q_src_c002_0_05 0 bpf_c002_0 0) vcvs gain=8.314696123025e-01
SMIXQ_c002_0_05 (mix_q_src_c002_0_05 mix_q_c002_0 win_0_05 0) relay vt1=-1m vt2=1m ropen=ropen_mix rclosed=rclosed_mix
EMIXI_c002_0_06 (mix_i_src_c002_0_06 0 bpf_c002_0 0) vcvs gain=-8.314696123025e-01
SMIXI_c002_0_06 (mix_i_src_c002_0_06 mix_i_c002_0 win_0_06 0) relay vt1=-1m vt2=1m ropen=ropen_mix rclosed=rclosed_mix
EMIXQ_c002_0_06 (mix_q_src_c002_0_06 0 bpf_c002_0 0) vcvs gain=5.555702330196e-01
SMIXQ_c002_0_06 (mix_q_src_c002_0_06 mix_q_c002_0 win_0_06 0) relay vt1=-1m vt2=1m ropen=ropen_mix rclosed=rclosed_mix
EMIXI_c002_0_07 (mix_i_src_c002_0_07 0 bpf_c002_0 0) vcvs gain=-9.807852804032e-01
SMIXI_c002_0_07 (mix_i_src_c002_0_07 mix_i_c002_0 win_0_07 0) relay vt1=-1m vt2=1m ropen=ropen_mix rclosed=rclosed_mix
EMIXQ_c002_0_07 (mix_q_src_c002_0_07 0 bpf_c002_0 0) vcvs gain=1.950903220161e-01
SMIXQ_c002_0_07 (mix_q_src_c002_0_07 mix_q_c002_0 win_0_07 0) relay vt1=-1m vt2=1m ropen=ropen_mix rclosed=rclosed_mix
EMIXI_c002_0_08 (mix_i_src_c002_0_08 0 bpf_c002_0 0) vcvs gain=-9.807852804032e-01
SMIXI_c002_0_08 (mix_i_src_c002_0_08 mix_i_c002_0 win_0_08 0) relay vt1=-1m vt2=1m ropen=ropen_mix rclosed=rclosed_mix
EMIXQ_c002_0_08 (mix_q_src_c002_0_08 0 bpf_c002_0 0) vcvs gain=-1.950903220161e-01
SMIXQ_c002_0_08 (mix_q_src_c002_0_08 mix_q_c002_0 win_0_08 0) relay vt1=-1m vt2=1m ropen=ropen_mix rclosed=rclosed_mix
EMIXI_c002_0_09 (mix_i_src_c002_0_09 0 bpf_c002_0 0) vcvs gain=-8.314696123025e-01
SMIXI_c002_0_09 (mix_i_src_c002_0_09 mix_i_c002_0 win_0_09 0) relay vt1=-1m vt2=1m ropen=ropen_mix rclosed=rclosed_mix
EMIXQ_c002_0_09 (mix_q_src_c002_0_09 0 bpf_c002_0 0) vcvs gain=-5.555702330196e-01
SMIXQ_c002_0_09 (mix_q_src_c002_0_09 mix_q_c002_0 win_0_09 0) relay vt1=-1m vt2=1m ropen=ropen_mix rclosed=rclosed_mix
EMIXI_c002_0_10 (mix_i_src_c002_0_10 0 bpf_c002_0 0) vcvs gain=-5.555702330196e-01
SMIXI_c002_0_10 (mix_i_src_c002_0_10 mix_i_c002_0 win_0_10 0) relay vt1=-1m vt2=1m ropen=ropen_mix rclosed=rclosed_mix
EMIXQ_c002_0_10 (mix_q_src_c002_0_10 0 bpf_c002_0 0) vcvs gain=-8.314696123025e-01
SMIXQ_c002_0_10 (mix_q_src_c002_0_10 mix_q_c002_0 win_0_10 0) relay vt1=-1m vt2=1m ropen=ropen_mix rclosed=rclosed_mix
EMIXI_c002_0_11 (mix_i_src_c002_0_11 0 bpf_c002_0 0) vcvs gain=-1.950903220161e-01
SMIXI_c002_0_11 (mix_i_src_c002_0_11 mix_i_c002_0 win_0_11 0) relay vt1=-1m vt2=1m ropen=ropen_mix rclosed=rclosed_mix
EMIXQ_c002_0_11 (mix_q_src_c002_0_11 0 bpf_c002_0 0) vcvs gain=-9.807852804032e-01
SMIXQ_c002_0_11 (mix_q_src_c002_0_11 mix_q_c002_0 win_0_11 0) relay vt1=-1m vt2=1m ropen=ropen_mix rclosed=rclosed_mix
EMIXI_c002_0_12 (mix_i_src_c002_0_12 0 bpf_c002_0 0) vcvs gain=1.950903220161e-01
SMIXI_c002_0_12 (mix_i_src_c002_0_12 mix_i_c002_0 win_0_12 0) relay vt1=-1m vt2=1m ropen=ropen_mix rclosed=rclosed_mix
EMIXQ_c002_0_12 (mix_q_src_c002_0_12 0 bpf_c002_0 0) vcvs gain=-9.807852804032e-01
SMIXQ_c002_0_12 (mix_q_src_c002_0_12 mix_q_c002_0 win_0_12 0) relay vt1=-1m vt2=1m ropen=ropen_mix rclosed=rclosed_mix
EMIXI_c002_0_13 (mix_i_src_c002_0_13 0 bpf_c002_0 0) vcvs gain=5.555702330196e-01
SMIXI_c002_0_13 (mix_i_src_c002_0_13 mix_i_c002_0 win_0_13 0) relay vt1=-1m vt2=1m ropen=ropen_mix rclosed=rclosed_mix
EMIXQ_c002_0_13 (mix_q_src_c002_0_13 0 bpf_c002_0 0) vcvs gain=-8.314696123025e-01
SMIXQ_c002_0_13 (mix_q_src_c002_0_13 mix_q_c002_0 win_0_13 0) relay vt1=-1m vt2=1m ropen=ropen_mix rclosed=rclosed_mix
EMIXI_c002_0_14 (mix_i_src_c002_0_14 0 bpf_c002_0 0) vcvs gain=8.314696123025e-01
SMIXI_c002_0_14 (mix_i_src_c002_0_14 mix_i_c002_0 win_0_14 0) relay vt1=-1m vt2=1m ropen=ropen_mix rclosed=rclosed_mix
EMIXQ_c002_0_14 (mix_q_src_c002_0_14 0 bpf_c002_0 0) vcvs gain=-5.555702330196e-01
SMIXQ_c002_0_14 (mix_q_src_c002_0_14 mix_q_c002_0 win_0_14 0) relay vt1=-1m vt2=1m ropen=ropen_mix rclosed=rclosed_mix
EMIXI_c002_0_15 (mix_i_src_c002_0_15 0 bpf_c002_0 0) vcvs gain=9.807852804032e-01
SMIXI_c002_0_15 (mix_i_src_c002_0_15 mix_i_c002_0 win_0_15 0) relay vt1=-1m vt2=1m ropen=ropen_mix rclosed=rclosed_mix
EMIXQ_c002_0_15 (mix_q_src_c002_0_15 0 bpf_c002_0 0) vcvs gain=-1.950903220161e-01
SMIXQ_c002_0_15 (mix_q_src_c002_0_15 mix_q_c002_0 win_0_15 0) relay vt1=-1m vt2=1m ropen=ropen_mix rclosed=rclosed_mix
RMIXI_c002_0 (mix_i_c002_0 0) resistor r=1G
RMIXQ_c002_0 (mix_q_c002_0 0) resistor r=1G
RINTI_c002_0 (mix_i_c002_0 Icar_c002_0) resistor r=1k
CINTI_c002_0 (Icar_c002_0 0) capacitor c=80p
RINTQ_c002_0 (mix_q_c002_0 Qcar_c002_0) resistor r=1k
CINTQ_c002_0 (Qcar_c002_0 0) capacitor c=80p
save bpf_c002_0 Icar_c002_0 Qcar_c002_0

// bl002, carrier_1: 500000000 Hz coherent I/Q phase-window verification-demod path
CBPF_c002_1 (bl002 n_cbpf_c002_1) capacitor c=1.013211836423e-13
LBPF_c002_1 (n_cbpf_c002_1 bpf_c002_1) inductor l=1.000000000000e-06
RBPF_c002_1 (bpf_c002_1 0) resistor r=1.570796326795e+02
EMIXI_c002_1_00 (mix_i_src_c002_1_00 0 bpf_c002_1 0) vcvs gain=9.807852804032e-01
SMIXI_c002_1_00 (mix_i_src_c002_1_00 mix_i_c002_1 win_1_00 0) relay vt1=-1m vt2=1m ropen=ropen_mix rclosed=rclosed_mix
EMIXQ_c002_1_00 (mix_q_src_c002_1_00 0 bpf_c002_1 0) vcvs gain=1.950903220161e-01
SMIXQ_c002_1_00 (mix_q_src_c002_1_00 mix_q_c002_1 win_1_00 0) relay vt1=-1m vt2=1m ropen=ropen_mix rclosed=rclosed_mix
EMIXI_c002_1_01 (mix_i_src_c002_1_01 0 bpf_c002_1 0) vcvs gain=8.314696123025e-01
SMIXI_c002_1_01 (mix_i_src_c002_1_01 mix_i_c002_1 win_1_01 0) relay vt1=-1m vt2=1m ropen=ropen_mix rclosed=rclosed_mix
EMIXQ_c002_1_01 (mix_q_src_c002_1_01 0 bpf_c002_1 0) vcvs gain=5.555702330196e-01
SMIXQ_c002_1_01 (mix_q_src_c002_1_01 mix_q_c002_1 win_1_01 0) relay vt1=-1m vt2=1m ropen=ropen_mix rclosed=rclosed_mix
EMIXI_c002_1_02 (mix_i_src_c002_1_02 0 bpf_c002_1 0) vcvs gain=5.555702330196e-01
SMIXI_c002_1_02 (mix_i_src_c002_1_02 mix_i_c002_1 win_1_02 0) relay vt1=-1m vt2=1m ropen=ropen_mix rclosed=rclosed_mix
EMIXQ_c002_1_02 (mix_q_src_c002_1_02 0 bpf_c002_1 0) vcvs gain=8.314696123025e-01
SMIXQ_c002_1_02 (mix_q_src_c002_1_02 mix_q_c002_1 win_1_02 0) relay vt1=-1m vt2=1m ropen=ropen_mix rclosed=rclosed_mix
EMIXI_c002_1_03 (mix_i_src_c002_1_03 0 bpf_c002_1 0) vcvs gain=1.950903220161e-01
SMIXI_c002_1_03 (mix_i_src_c002_1_03 mix_i_c002_1 win_1_03 0) relay vt1=-1m vt2=1m ropen=ropen_mix rclosed=rclosed_mix
EMIXQ_c002_1_03 (mix_q_src_c002_1_03 0 bpf_c002_1 0) vcvs gain=9.807852804032e-01
SMIXQ_c002_1_03 (mix_q_src_c002_1_03 mix_q_c002_1 win_1_03 0) relay vt1=-1m vt2=1m ropen=ropen_mix rclosed=rclosed_mix
EMIXI_c002_1_04 (mix_i_src_c002_1_04 0 bpf_c002_1 0) vcvs gain=-1.950903220161e-01
SMIXI_c002_1_04 (mix_i_src_c002_1_04 mix_i_c002_1 win_1_04 0) relay vt1=-1m vt2=1m ropen=ropen_mix rclosed=rclosed_mix
EMIXQ_c002_1_04 (mix_q_src_c002_1_04 0 bpf_c002_1 0) vcvs gain=9.807852804032e-01
SMIXQ_c002_1_04 (mix_q_src_c002_1_04 mix_q_c002_1 win_1_04 0) relay vt1=-1m vt2=1m ropen=ropen_mix rclosed=rclosed_mix
EMIXI_c002_1_05 (mix_i_src_c002_1_05 0 bpf_c002_1 0) vcvs gain=-5.555702330196e-01
SMIXI_c002_1_05 (mix_i_src_c002_1_05 mix_i_c002_1 win_1_05 0) relay vt1=-1m vt2=1m ropen=ropen_mix rclosed=rclosed_mix
EMIXQ_c002_1_05 (mix_q_src_c002_1_05 0 bpf_c002_1 0) vcvs gain=8.314696123025e-01
SMIXQ_c002_1_05 (mix_q_src_c002_1_05 mix_q_c002_1 win_1_05 0) relay vt1=-1m vt2=1m ropen=ropen_mix rclosed=rclosed_mix
EMIXI_c002_1_06 (mix_i_src_c002_1_06 0 bpf_c002_1 0) vcvs gain=-8.314696123025e-01
SMIXI_c002_1_06 (mix_i_src_c002_1_06 mix_i_c002_1 win_1_06 0) relay vt1=-1m vt2=1m ropen=ropen_mix rclosed=rclosed_mix
EMIXQ_c002_1_06 (mix_q_src_c002_1_06 0 bpf_c002_1 0) vcvs gain=5.555702330196e-01
SMIXQ_c002_1_06 (mix_q_src_c002_1_06 mix_q_c002_1 win_1_06 0) relay vt1=-1m vt2=1m ropen=ropen_mix rclosed=rclosed_mix
EMIXI_c002_1_07 (mix_i_src_c002_1_07 0 bpf_c002_1 0) vcvs gain=-9.807852804032e-01
SMIXI_c002_1_07 (mix_i_src_c002_1_07 mix_i_c002_1 win_1_07 0) relay vt1=-1m vt2=1m ropen=ropen_mix rclosed=rclosed_mix
EMIXQ_c002_1_07 (mix_q_src_c002_1_07 0 bpf_c002_1 0) vcvs gain=1.950903220161e-01
SMIXQ_c002_1_07 (mix_q_src_c002_1_07 mix_q_c002_1 win_1_07 0) relay vt1=-1m vt2=1m ropen=ropen_mix rclosed=rclosed_mix
EMIXI_c002_1_08 (mix_i_src_c002_1_08 0 bpf_c002_1 0) vcvs gain=-9.807852804032e-01
SMIXI_c002_1_08 (mix_i_src_c002_1_08 mix_i_c002_1 win_1_08 0) relay vt1=-1m vt2=1m ropen=ropen_mix rclosed=rclosed_mix
EMIXQ_c002_1_08 (mix_q_src_c002_1_08 0 bpf_c002_1 0) vcvs gain=-1.950903220161e-01
SMIXQ_c002_1_08 (mix_q_src_c002_1_08 mix_q_c002_1 win_1_08 0) relay vt1=-1m vt2=1m ropen=ropen_mix rclosed=rclosed_mix
EMIXI_c002_1_09 (mix_i_src_c002_1_09 0 bpf_c002_1 0) vcvs gain=-8.314696123025e-01
SMIXI_c002_1_09 (mix_i_src_c002_1_09 mix_i_c002_1 win_1_09 0) relay vt1=-1m vt2=1m ropen=ropen_mix rclosed=rclosed_mix
EMIXQ_c002_1_09 (mix_q_src_c002_1_09 0 bpf_c002_1 0) vcvs gain=-5.555702330196e-01
SMIXQ_c002_1_09 (mix_q_src_c002_1_09 mix_q_c002_1 win_1_09 0) relay vt1=-1m vt2=1m ropen=ropen_mix rclosed=rclosed_mix
EMIXI_c002_1_10 (mix_i_src_c002_1_10 0 bpf_c002_1 0) vcvs gain=-5.555702330196e-01
SMIXI_c002_1_10 (mix_i_src_c002_1_10 mix_i_c002_1 win_1_10 0) relay vt1=-1m vt2=1m ropen=ropen_mix rclosed=rclosed_mix
EMIXQ_c002_1_10 (mix_q_src_c002_1_10 0 bpf_c002_1 0) vcvs gain=-8.314696123025e-01
SMIXQ_c002_1_10 (mix_q_src_c002_1_10 mix_q_c002_1 win_1_10 0) relay vt1=-1m vt2=1m ropen=ropen_mix rclosed=rclosed_mix
EMIXI_c002_1_11 (mix_i_src_c002_1_11 0 bpf_c002_1 0) vcvs gain=-1.950903220161e-01
SMIXI_c002_1_11 (mix_i_src_c002_1_11 mix_i_c002_1 win_1_11 0) relay vt1=-1m vt2=1m ropen=ropen_mix rclosed=rclosed_mix
EMIXQ_c002_1_11 (mix_q_src_c002_1_11 0 bpf_c002_1 0) vcvs gain=-9.807852804032e-01
SMIXQ_c002_1_11 (mix_q_src_c002_1_11 mix_q_c002_1 win_1_11 0) relay vt1=-1m vt2=1m ropen=ropen_mix rclosed=rclosed_mix
EMIXI_c002_1_12 (mix_i_src_c002_1_12 0 bpf_c002_1 0) vcvs gain=1.950903220161e-01
SMIXI_c002_1_12 (mix_i_src_c002_1_12 mix_i_c002_1 win_1_12 0) relay vt1=-1m vt2=1m ropen=ropen_mix rclosed=rclosed_mix
EMIXQ_c002_1_12 (mix_q_src_c002_1_12 0 bpf_c002_1 0) vcvs gain=-9.807852804032e-01
SMIXQ_c002_1_12 (mix_q_src_c002_1_12 mix_q_c002_1 win_1_12 0) relay vt1=-1m vt2=1m ropen=ropen_mix rclosed=rclosed_mix
EMIXI_c002_1_13 (mix_i_src_c002_1_13 0 bpf_c002_1 0) vcvs gain=5.555702330196e-01
SMIXI_c002_1_13 (mix_i_src_c002_1_13 mix_i_c002_1 win_1_13 0) relay vt1=-1m vt2=1m ropen=ropen_mix rclosed=rclosed_mix
EMIXQ_c002_1_13 (mix_q_src_c002_1_13 0 bpf_c002_1 0) vcvs gain=-8.314696123025e-01
SMIXQ_c002_1_13 (mix_q_src_c002_1_13 mix_q_c002_1 win_1_13 0) relay vt1=-1m vt2=1m ropen=ropen_mix rclosed=rclosed_mix
EMIXI_c002_1_14 (mix_i_src_c002_1_14 0 bpf_c002_1 0) vcvs gain=8.314696123025e-01
SMIXI_c002_1_14 (mix_i_src_c002_1_14 mix_i_c002_1 win_1_14 0) relay vt1=-1m vt2=1m ropen=ropen_mix rclosed=rclosed_mix
EMIXQ_c002_1_14 (mix_q_src_c002_1_14 0 bpf_c002_1 0) vcvs gain=-5.555702330196e-01
SMIXQ_c002_1_14 (mix_q_src_c002_1_14 mix_q_c002_1 win_1_14 0) relay vt1=-1m vt2=1m ropen=ropen_mix rclosed=rclosed_mix
EMIXI_c002_1_15 (mix_i_src_c002_1_15 0 bpf_c002_1 0) vcvs gain=9.807852804032e-01
SMIXI_c002_1_15 (mix_i_src_c002_1_15 mix_i_c002_1 win_1_15 0) relay vt1=-1m vt2=1m ropen=ropen_mix rclosed=rclosed_mix
EMIXQ_c002_1_15 (mix_q_src_c002_1_15 0 bpf_c002_1 0) vcvs gain=-1.950903220161e-01
SMIXQ_c002_1_15 (mix_q_src_c002_1_15 mix_q_c002_1 win_1_15 0) relay vt1=-1m vt2=1m ropen=ropen_mix rclosed=rclosed_mix
RMIXI_c002_1 (mix_i_c002_1 0) resistor r=1G
RMIXQ_c002_1 (mix_q_c002_1 0) resistor r=1G
RINTI_c002_1 (mix_i_c002_1 Icar_c002_1) resistor r=1k
CINTI_c002_1 (Icar_c002_1 0) capacitor c=80p
RINTQ_c002_1 (mix_q_c002_1 Qcar_c002_1) resistor r=1k
CINTQ_c002_1 (Qcar_c002_1 0) capacitor c=80p
save bpf_c002_1 Icar_c002_1 Qcar_c002_1

// bl002, carrier_2: 750000000 Hz coherent I/Q phase-window verification-demod path
CBPF_c002_2 (bl002 n_cbpf_c002_2) capacitor c=4.503163717437e-14
LBPF_c002_2 (n_cbpf_c002_2 bpf_c002_2) inductor l=1.000000000000e-06
RBPF_c002_2 (bpf_c002_2 0) resistor r=2.356194490192e+02
EMIXI_c002_2_00 (mix_i_src_c002_2_00 0 bpf_c002_2 0) vcvs gain=9.807852804032e-01
SMIXI_c002_2_00 (mix_i_src_c002_2_00 mix_i_c002_2 win_2_00 0) relay vt1=-1m vt2=1m ropen=ropen_mix rclosed=rclosed_mix
EMIXQ_c002_2_00 (mix_q_src_c002_2_00 0 bpf_c002_2 0) vcvs gain=1.950903220161e-01
SMIXQ_c002_2_00 (mix_q_src_c002_2_00 mix_q_c002_2 win_2_00 0) relay vt1=-1m vt2=1m ropen=ropen_mix rclosed=rclosed_mix
EMIXI_c002_2_01 (mix_i_src_c002_2_01 0 bpf_c002_2 0) vcvs gain=8.314696123025e-01
SMIXI_c002_2_01 (mix_i_src_c002_2_01 mix_i_c002_2 win_2_01 0) relay vt1=-1m vt2=1m ropen=ropen_mix rclosed=rclosed_mix
EMIXQ_c002_2_01 (mix_q_src_c002_2_01 0 bpf_c002_2 0) vcvs gain=5.555702330196e-01
SMIXQ_c002_2_01 (mix_q_src_c002_2_01 mix_q_c002_2 win_2_01 0) relay vt1=-1m vt2=1m ropen=ropen_mix rclosed=rclosed_mix
EMIXI_c002_2_02 (mix_i_src_c002_2_02 0 bpf_c002_2 0) vcvs gain=5.555702330196e-01
SMIXI_c002_2_02 (mix_i_src_c002_2_02 mix_i_c002_2 win_2_02 0) relay vt1=-1m vt2=1m ropen=ropen_mix rclosed=rclosed_mix
EMIXQ_c002_2_02 (mix_q_src_c002_2_02 0 bpf_c002_2 0) vcvs gain=8.314696123025e-01
SMIXQ_c002_2_02 (mix_q_src_c002_2_02 mix_q_c002_2 win_2_02 0) relay vt1=-1m vt2=1m ropen=ropen_mix rclosed=rclosed_mix
EMIXI_c002_2_03 (mix_i_src_c002_2_03 0 bpf_c002_2 0) vcvs gain=1.950903220161e-01
SMIXI_c002_2_03 (mix_i_src_c002_2_03 mix_i_c002_2 win_2_03 0) relay vt1=-1m vt2=1m ropen=ropen_mix rclosed=rclosed_mix
EMIXQ_c002_2_03 (mix_q_src_c002_2_03 0 bpf_c002_2 0) vcvs gain=9.807852804032e-01
SMIXQ_c002_2_03 (mix_q_src_c002_2_03 mix_q_c002_2 win_2_03 0) relay vt1=-1m vt2=1m ropen=ropen_mix rclosed=rclosed_mix
EMIXI_c002_2_04 (mix_i_src_c002_2_04 0 bpf_c002_2 0) vcvs gain=-1.950903220161e-01
SMIXI_c002_2_04 (mix_i_src_c002_2_04 mix_i_c002_2 win_2_04 0) relay vt1=-1m vt2=1m ropen=ropen_mix rclosed=rclosed_mix
EMIXQ_c002_2_04 (mix_q_src_c002_2_04 0 bpf_c002_2 0) vcvs gain=9.807852804032e-01
SMIXQ_c002_2_04 (mix_q_src_c002_2_04 mix_q_c002_2 win_2_04 0) relay vt1=-1m vt2=1m ropen=ropen_mix rclosed=rclosed_mix
EMIXI_c002_2_05 (mix_i_src_c002_2_05 0 bpf_c002_2 0) vcvs gain=-5.555702330196e-01
SMIXI_c002_2_05 (mix_i_src_c002_2_05 mix_i_c002_2 win_2_05 0) relay vt1=-1m vt2=1m ropen=ropen_mix rclosed=rclosed_mix
EMIXQ_c002_2_05 (mix_q_src_c002_2_05 0 bpf_c002_2 0) vcvs gain=8.314696123025e-01
SMIXQ_c002_2_05 (mix_q_src_c002_2_05 mix_q_c002_2 win_2_05 0) relay vt1=-1m vt2=1m ropen=ropen_mix rclosed=rclosed_mix
EMIXI_c002_2_06 (mix_i_src_c002_2_06 0 bpf_c002_2 0) vcvs gain=-8.314696123025e-01
SMIXI_c002_2_06 (mix_i_src_c002_2_06 mix_i_c002_2 win_2_06 0) relay vt1=-1m vt2=1m ropen=ropen_mix rclosed=rclosed_mix
EMIXQ_c002_2_06 (mix_q_src_c002_2_06 0 bpf_c002_2 0) vcvs gain=5.555702330196e-01
SMIXQ_c002_2_06 (mix_q_src_c002_2_06 mix_q_c002_2 win_2_06 0) relay vt1=-1m vt2=1m ropen=ropen_mix rclosed=rclosed_mix
EMIXI_c002_2_07 (mix_i_src_c002_2_07 0 bpf_c002_2 0) vcvs gain=-9.807852804032e-01
SMIXI_c002_2_07 (mix_i_src_c002_2_07 mix_i_c002_2 win_2_07 0) relay vt1=-1m vt2=1m ropen=ropen_mix rclosed=rclosed_mix
EMIXQ_c002_2_07 (mix_q_src_c002_2_07 0 bpf_c002_2 0) vcvs gain=1.950903220161e-01
SMIXQ_c002_2_07 (mix_q_src_c002_2_07 mix_q_c002_2 win_2_07 0) relay vt1=-1m vt2=1m ropen=ropen_mix rclosed=rclosed_mix
EMIXI_c002_2_08 (mix_i_src_c002_2_08 0 bpf_c002_2 0) vcvs gain=-9.807852804032e-01
SMIXI_c002_2_08 (mix_i_src_c002_2_08 mix_i_c002_2 win_2_08 0) relay vt1=-1m vt2=1m ropen=ropen_mix rclosed=rclosed_mix
EMIXQ_c002_2_08 (mix_q_src_c002_2_08 0 bpf_c002_2 0) vcvs gain=-1.950903220161e-01
SMIXQ_c002_2_08 (mix_q_src_c002_2_08 mix_q_c002_2 win_2_08 0) relay vt1=-1m vt2=1m ropen=ropen_mix rclosed=rclosed_mix
EMIXI_c002_2_09 (mix_i_src_c002_2_09 0 bpf_c002_2 0) vcvs gain=-8.314696123025e-01
SMIXI_c002_2_09 (mix_i_src_c002_2_09 mix_i_c002_2 win_2_09 0) relay vt1=-1m vt2=1m ropen=ropen_mix rclosed=rclosed_mix
EMIXQ_c002_2_09 (mix_q_src_c002_2_09 0 bpf_c002_2 0) vcvs gain=-5.555702330196e-01
SMIXQ_c002_2_09 (mix_q_src_c002_2_09 mix_q_c002_2 win_2_09 0) relay vt1=-1m vt2=1m ropen=ropen_mix rclosed=rclosed_mix
EMIXI_c002_2_10 (mix_i_src_c002_2_10 0 bpf_c002_2 0) vcvs gain=-5.555702330196e-01
SMIXI_c002_2_10 (mix_i_src_c002_2_10 mix_i_c002_2 win_2_10 0) relay vt1=-1m vt2=1m ropen=ropen_mix rclosed=rclosed_mix
EMIXQ_c002_2_10 (mix_q_src_c002_2_10 0 bpf_c002_2 0) vcvs gain=-8.314696123025e-01
SMIXQ_c002_2_10 (mix_q_src_c002_2_10 mix_q_c002_2 win_2_10 0) relay vt1=-1m vt2=1m ropen=ropen_mix rclosed=rclosed_mix
EMIXI_c002_2_11 (mix_i_src_c002_2_11 0 bpf_c002_2 0) vcvs gain=-1.950903220161e-01
SMIXI_c002_2_11 (mix_i_src_c002_2_11 mix_i_c002_2 win_2_11 0) relay vt1=-1m vt2=1m ropen=ropen_mix rclosed=rclosed_mix
EMIXQ_c002_2_11 (mix_q_src_c002_2_11 0 bpf_c002_2 0) vcvs gain=-9.807852804032e-01
SMIXQ_c002_2_11 (mix_q_src_c002_2_11 mix_q_c002_2 win_2_11 0) relay vt1=-1m vt2=1m ropen=ropen_mix rclosed=rclosed_mix
EMIXI_c002_2_12 (mix_i_src_c002_2_12 0 bpf_c002_2 0) vcvs gain=1.950903220161e-01
SMIXI_c002_2_12 (mix_i_src_c002_2_12 mix_i_c002_2 win_2_12 0) relay vt1=-1m vt2=1m ropen=ropen_mix rclosed=rclosed_mix
EMIXQ_c002_2_12 (mix_q_src_c002_2_12 0 bpf_c002_2 0) vcvs gain=-9.807852804032e-01
SMIXQ_c002_2_12 (mix_q_src_c002_2_12 mix_q_c002_2 win_2_12 0) relay vt1=-1m vt2=1m ropen=ropen_mix rclosed=rclosed_mix
EMIXI_c002_2_13 (mix_i_src_c002_2_13 0 bpf_c002_2 0) vcvs gain=5.555702330196e-01
SMIXI_c002_2_13 (mix_i_src_c002_2_13 mix_i_c002_2 win_2_13 0) relay vt1=-1m vt2=1m ropen=ropen_mix rclosed=rclosed_mix
EMIXQ_c002_2_13 (mix_q_src_c002_2_13 0 bpf_c002_2 0) vcvs gain=-8.314696123025e-01
SMIXQ_c002_2_13 (mix_q_src_c002_2_13 mix_q_c002_2 win_2_13 0) relay vt1=-1m vt2=1m ropen=ropen_mix rclosed=rclosed_mix
EMIXI_c002_2_14 (mix_i_src_c002_2_14 0 bpf_c002_2 0) vcvs gain=8.314696123025e-01
SMIXI_c002_2_14 (mix_i_src_c002_2_14 mix_i_c002_2 win_2_14 0) relay vt1=-1m vt2=1m ropen=ropen_mix rclosed=rclosed_mix
EMIXQ_c002_2_14 (mix_q_src_c002_2_14 0 bpf_c002_2 0) vcvs gain=-5.555702330196e-01
SMIXQ_c002_2_14 (mix_q_src_c002_2_14 mix_q_c002_2 win_2_14 0) relay vt1=-1m vt2=1m ropen=ropen_mix rclosed=rclosed_mix
EMIXI_c002_2_15 (mix_i_src_c002_2_15 0 bpf_c002_2 0) vcvs gain=9.807852804032e-01
SMIXI_c002_2_15 (mix_i_src_c002_2_15 mix_i_c002_2 win_2_15 0) relay vt1=-1m vt2=1m ropen=ropen_mix rclosed=rclosed_mix
EMIXQ_c002_2_15 (mix_q_src_c002_2_15 0 bpf_c002_2 0) vcvs gain=-1.950903220161e-01
SMIXQ_c002_2_15 (mix_q_src_c002_2_15 mix_q_c002_2 win_2_15 0) relay vt1=-1m vt2=1m ropen=ropen_mix rclosed=rclosed_mix
RMIXI_c002_2 (mix_i_c002_2 0) resistor r=1G
RMIXQ_c002_2 (mix_q_c002_2 0) resistor r=1G
RINTI_c002_2 (mix_i_c002_2 Icar_c002_2) resistor r=1k
CINTI_c002_2 (Icar_c002_2 0) capacitor c=80p
RINTQ_c002_2 (mix_q_c002_2 Qcar_c002_2) resistor r=1k
CINTQ_c002_2 (Qcar_c002_2 0) capacitor c=80p
save bpf_c002_2 Icar_c002_2 Qcar_c002_2

// bl002, carrier_3: 1000000000 Hz coherent I/Q phase-window verification-demod path
CBPF_c002_3 (bl002 n_cbpf_c002_3) capacitor c=2.533029591058e-14
LBPF_c002_3 (n_cbpf_c002_3 bpf_c002_3) inductor l=1.000000000000e-06
RBPF_c002_3 (bpf_c002_3 0) resistor r=3.141592653590e+02
EMIXI_c002_3_00 (mix_i_src_c002_3_00 0 bpf_c002_3 0) vcvs gain=9.807852804032e-01
SMIXI_c002_3_00 (mix_i_src_c002_3_00 mix_i_c002_3 win_3_00 0) relay vt1=-1m vt2=1m ropen=ropen_mix rclosed=rclosed_mix
EMIXQ_c002_3_00 (mix_q_src_c002_3_00 0 bpf_c002_3 0) vcvs gain=1.950903220161e-01
SMIXQ_c002_3_00 (mix_q_src_c002_3_00 mix_q_c002_3 win_3_00 0) relay vt1=-1m vt2=1m ropen=ropen_mix rclosed=rclosed_mix
EMIXI_c002_3_01 (mix_i_src_c002_3_01 0 bpf_c002_3 0) vcvs gain=8.314696123025e-01
SMIXI_c002_3_01 (mix_i_src_c002_3_01 mix_i_c002_3 win_3_01 0) relay vt1=-1m vt2=1m ropen=ropen_mix rclosed=rclosed_mix
EMIXQ_c002_3_01 (mix_q_src_c002_3_01 0 bpf_c002_3 0) vcvs gain=5.555702330196e-01
SMIXQ_c002_3_01 (mix_q_src_c002_3_01 mix_q_c002_3 win_3_01 0) relay vt1=-1m vt2=1m ropen=ropen_mix rclosed=rclosed_mix
EMIXI_c002_3_02 (mix_i_src_c002_3_02 0 bpf_c002_3 0) vcvs gain=5.555702330196e-01
SMIXI_c002_3_02 (mix_i_src_c002_3_02 mix_i_c002_3 win_3_02 0) relay vt1=-1m vt2=1m ropen=ropen_mix rclosed=rclosed_mix
EMIXQ_c002_3_02 (mix_q_src_c002_3_02 0 bpf_c002_3 0) vcvs gain=8.314696123025e-01
SMIXQ_c002_3_02 (mix_q_src_c002_3_02 mix_q_c002_3 win_3_02 0) relay vt1=-1m vt2=1m ropen=ropen_mix rclosed=rclosed_mix
EMIXI_c002_3_03 (mix_i_src_c002_3_03 0 bpf_c002_3 0) vcvs gain=1.950903220161e-01
SMIXI_c002_3_03 (mix_i_src_c002_3_03 mix_i_c002_3 win_3_03 0) relay vt1=-1m vt2=1m ropen=ropen_mix rclosed=rclosed_mix
EMIXQ_c002_3_03 (mix_q_src_c002_3_03 0 bpf_c002_3 0) vcvs gain=9.807852804032e-01
SMIXQ_c002_3_03 (mix_q_src_c002_3_03 mix_q_c002_3 win_3_03 0) relay vt1=-1m vt2=1m ropen=ropen_mix rclosed=rclosed_mix
EMIXI_c002_3_04 (mix_i_src_c002_3_04 0 bpf_c002_3 0) vcvs gain=-1.950903220161e-01
SMIXI_c002_3_04 (mix_i_src_c002_3_04 mix_i_c002_3 win_3_04 0) relay vt1=-1m vt2=1m ropen=ropen_mix rclosed=rclosed_mix
EMIXQ_c002_3_04 (mix_q_src_c002_3_04 0 bpf_c002_3 0) vcvs gain=9.807852804032e-01
SMIXQ_c002_3_04 (mix_q_src_c002_3_04 mix_q_c002_3 win_3_04 0) relay vt1=-1m vt2=1m ropen=ropen_mix rclosed=rclosed_mix
EMIXI_c002_3_05 (mix_i_src_c002_3_05 0 bpf_c002_3 0) vcvs gain=-5.555702330196e-01
SMIXI_c002_3_05 (mix_i_src_c002_3_05 mix_i_c002_3 win_3_05 0) relay vt1=-1m vt2=1m ropen=ropen_mix rclosed=rclosed_mix
EMIXQ_c002_3_05 (mix_q_src_c002_3_05 0 bpf_c002_3 0) vcvs gain=8.314696123025e-01
SMIXQ_c002_3_05 (mix_q_src_c002_3_05 mix_q_c002_3 win_3_05 0) relay vt1=-1m vt2=1m ropen=ropen_mix rclosed=rclosed_mix
EMIXI_c002_3_06 (mix_i_src_c002_3_06 0 bpf_c002_3 0) vcvs gain=-8.314696123025e-01
SMIXI_c002_3_06 (mix_i_src_c002_3_06 mix_i_c002_3 win_3_06 0) relay vt1=-1m vt2=1m ropen=ropen_mix rclosed=rclosed_mix
EMIXQ_c002_3_06 (mix_q_src_c002_3_06 0 bpf_c002_3 0) vcvs gain=5.555702330196e-01
SMIXQ_c002_3_06 (mix_q_src_c002_3_06 mix_q_c002_3 win_3_06 0) relay vt1=-1m vt2=1m ropen=ropen_mix rclosed=rclosed_mix
EMIXI_c002_3_07 (mix_i_src_c002_3_07 0 bpf_c002_3 0) vcvs gain=-9.807852804032e-01
SMIXI_c002_3_07 (mix_i_src_c002_3_07 mix_i_c002_3 win_3_07 0) relay vt1=-1m vt2=1m ropen=ropen_mix rclosed=rclosed_mix
EMIXQ_c002_3_07 (mix_q_src_c002_3_07 0 bpf_c002_3 0) vcvs gain=1.950903220161e-01
SMIXQ_c002_3_07 (mix_q_src_c002_3_07 mix_q_c002_3 win_3_07 0) relay vt1=-1m vt2=1m ropen=ropen_mix rclosed=rclosed_mix
EMIXI_c002_3_08 (mix_i_src_c002_3_08 0 bpf_c002_3 0) vcvs gain=-9.807852804032e-01
SMIXI_c002_3_08 (mix_i_src_c002_3_08 mix_i_c002_3 win_3_08 0) relay vt1=-1m vt2=1m ropen=ropen_mix rclosed=rclosed_mix
EMIXQ_c002_3_08 (mix_q_src_c002_3_08 0 bpf_c002_3 0) vcvs gain=-1.950903220161e-01
SMIXQ_c002_3_08 (mix_q_src_c002_3_08 mix_q_c002_3 win_3_08 0) relay vt1=-1m vt2=1m ropen=ropen_mix rclosed=rclosed_mix
EMIXI_c002_3_09 (mix_i_src_c002_3_09 0 bpf_c002_3 0) vcvs gain=-8.314696123025e-01
SMIXI_c002_3_09 (mix_i_src_c002_3_09 mix_i_c002_3 win_3_09 0) relay vt1=-1m vt2=1m ropen=ropen_mix rclosed=rclosed_mix
EMIXQ_c002_3_09 (mix_q_src_c002_3_09 0 bpf_c002_3 0) vcvs gain=-5.555702330196e-01
SMIXQ_c002_3_09 (mix_q_src_c002_3_09 mix_q_c002_3 win_3_09 0) relay vt1=-1m vt2=1m ropen=ropen_mix rclosed=rclosed_mix
EMIXI_c002_3_10 (mix_i_src_c002_3_10 0 bpf_c002_3 0) vcvs gain=-5.555702330196e-01
SMIXI_c002_3_10 (mix_i_src_c002_3_10 mix_i_c002_3 win_3_10 0) relay vt1=-1m vt2=1m ropen=ropen_mix rclosed=rclosed_mix
EMIXQ_c002_3_10 (mix_q_src_c002_3_10 0 bpf_c002_3 0) vcvs gain=-8.314696123025e-01
SMIXQ_c002_3_10 (mix_q_src_c002_3_10 mix_q_c002_3 win_3_10 0) relay vt1=-1m vt2=1m ropen=ropen_mix rclosed=rclosed_mix
EMIXI_c002_3_11 (mix_i_src_c002_3_11 0 bpf_c002_3 0) vcvs gain=-1.950903220161e-01
SMIXI_c002_3_11 (mix_i_src_c002_3_11 mix_i_c002_3 win_3_11 0) relay vt1=-1m vt2=1m ropen=ropen_mix rclosed=rclosed_mix
EMIXQ_c002_3_11 (mix_q_src_c002_3_11 0 bpf_c002_3 0) vcvs gain=-9.807852804032e-01
SMIXQ_c002_3_11 (mix_q_src_c002_3_11 mix_q_c002_3 win_3_11 0) relay vt1=-1m vt2=1m ropen=ropen_mix rclosed=rclosed_mix
EMIXI_c002_3_12 (mix_i_src_c002_3_12 0 bpf_c002_3 0) vcvs gain=1.950903220161e-01
SMIXI_c002_3_12 (mix_i_src_c002_3_12 mix_i_c002_3 win_3_12 0) relay vt1=-1m vt2=1m ropen=ropen_mix rclosed=rclosed_mix
EMIXQ_c002_3_12 (mix_q_src_c002_3_12 0 bpf_c002_3 0) vcvs gain=-9.807852804032e-01
SMIXQ_c002_3_12 (mix_q_src_c002_3_12 mix_q_c002_3 win_3_12 0) relay vt1=-1m vt2=1m ropen=ropen_mix rclosed=rclosed_mix
EMIXI_c002_3_13 (mix_i_src_c002_3_13 0 bpf_c002_3 0) vcvs gain=5.555702330196e-01
SMIXI_c002_3_13 (mix_i_src_c002_3_13 mix_i_c002_3 win_3_13 0) relay vt1=-1m vt2=1m ropen=ropen_mix rclosed=rclosed_mix
EMIXQ_c002_3_13 (mix_q_src_c002_3_13 0 bpf_c002_3 0) vcvs gain=-8.314696123025e-01
SMIXQ_c002_3_13 (mix_q_src_c002_3_13 mix_q_c002_3 win_3_13 0) relay vt1=-1m vt2=1m ropen=ropen_mix rclosed=rclosed_mix
EMIXI_c002_3_14 (mix_i_src_c002_3_14 0 bpf_c002_3 0) vcvs gain=8.314696123025e-01
SMIXI_c002_3_14 (mix_i_src_c002_3_14 mix_i_c002_3 win_3_14 0) relay vt1=-1m vt2=1m ropen=ropen_mix rclosed=rclosed_mix
EMIXQ_c002_3_14 (mix_q_src_c002_3_14 0 bpf_c002_3 0) vcvs gain=-5.555702330196e-01
SMIXQ_c002_3_14 (mix_q_src_c002_3_14 mix_q_c002_3 win_3_14 0) relay vt1=-1m vt2=1m ropen=ropen_mix rclosed=rclosed_mix
EMIXI_c002_3_15 (mix_i_src_c002_3_15 0 bpf_c002_3 0) vcvs gain=9.807852804032e-01
SMIXI_c002_3_15 (mix_i_src_c002_3_15 mix_i_c002_3 win_3_15 0) relay vt1=-1m vt2=1m ropen=ropen_mix rclosed=rclosed_mix
EMIXQ_c002_3_15 (mix_q_src_c002_3_15 0 bpf_c002_3 0) vcvs gain=-1.950903220161e-01
SMIXQ_c002_3_15 (mix_q_src_c002_3_15 mix_q_c002_3 win_3_15 0) relay vt1=-1m vt2=1m ropen=ropen_mix rclosed=rclosed_mix
RMIXI_c002_3 (mix_i_c002_3 0) resistor r=1G
RMIXQ_c002_3 (mix_q_c002_3 0) resistor r=1G
RINTI_c002_3 (mix_i_c002_3 Icar_c002_3) resistor r=1k
CINTI_c002_3 (Icar_c002_3 0) capacitor c=80p
RINTQ_c002_3 (mix_q_c002_3 Qcar_c002_3) resistor r=1k
CINTQ_c002_3 (Qcar_c002_3 0) capacitor c=80p
save bpf_c002_3 Icar_c002_3 Qcar_c002_3

// bl003, carrier_0: 250000000 Hz coherent I/Q phase-window verification-demod path
CBPF_c003_0 (bl003 n_cbpf_c003_0) capacitor c=4.052847345694e-13
LBPF_c003_0 (n_cbpf_c003_0 bpf_c003_0) inductor l=1.000000000000e-06
RBPF_c003_0 (bpf_c003_0 0) resistor r=7.853981633974e+01
EMIXI_c003_0_00 (mix_i_src_c003_0_00 0 bpf_c003_0 0) vcvs gain=9.807852804032e-01
SMIXI_c003_0_00 (mix_i_src_c003_0_00 mix_i_c003_0 win_0_00 0) relay vt1=-1m vt2=1m ropen=ropen_mix rclosed=rclosed_mix
EMIXQ_c003_0_00 (mix_q_src_c003_0_00 0 bpf_c003_0 0) vcvs gain=1.950903220161e-01
SMIXQ_c003_0_00 (mix_q_src_c003_0_00 mix_q_c003_0 win_0_00 0) relay vt1=-1m vt2=1m ropen=ropen_mix rclosed=rclosed_mix
EMIXI_c003_0_01 (mix_i_src_c003_0_01 0 bpf_c003_0 0) vcvs gain=8.314696123025e-01
SMIXI_c003_0_01 (mix_i_src_c003_0_01 mix_i_c003_0 win_0_01 0) relay vt1=-1m vt2=1m ropen=ropen_mix rclosed=rclosed_mix
EMIXQ_c003_0_01 (mix_q_src_c003_0_01 0 bpf_c003_0 0) vcvs gain=5.555702330196e-01
SMIXQ_c003_0_01 (mix_q_src_c003_0_01 mix_q_c003_0 win_0_01 0) relay vt1=-1m vt2=1m ropen=ropen_mix rclosed=rclosed_mix
EMIXI_c003_0_02 (mix_i_src_c003_0_02 0 bpf_c003_0 0) vcvs gain=5.555702330196e-01
SMIXI_c003_0_02 (mix_i_src_c003_0_02 mix_i_c003_0 win_0_02 0) relay vt1=-1m vt2=1m ropen=ropen_mix rclosed=rclosed_mix
EMIXQ_c003_0_02 (mix_q_src_c003_0_02 0 bpf_c003_0 0) vcvs gain=8.314696123025e-01
SMIXQ_c003_0_02 (mix_q_src_c003_0_02 mix_q_c003_0 win_0_02 0) relay vt1=-1m vt2=1m ropen=ropen_mix rclosed=rclosed_mix
EMIXI_c003_0_03 (mix_i_src_c003_0_03 0 bpf_c003_0 0) vcvs gain=1.950903220161e-01
SMIXI_c003_0_03 (mix_i_src_c003_0_03 mix_i_c003_0 win_0_03 0) relay vt1=-1m vt2=1m ropen=ropen_mix rclosed=rclosed_mix
EMIXQ_c003_0_03 (mix_q_src_c003_0_03 0 bpf_c003_0 0) vcvs gain=9.807852804032e-01
SMIXQ_c003_0_03 (mix_q_src_c003_0_03 mix_q_c003_0 win_0_03 0) relay vt1=-1m vt2=1m ropen=ropen_mix rclosed=rclosed_mix
EMIXI_c003_0_04 (mix_i_src_c003_0_04 0 bpf_c003_0 0) vcvs gain=-1.950903220161e-01
SMIXI_c003_0_04 (mix_i_src_c003_0_04 mix_i_c003_0 win_0_04 0) relay vt1=-1m vt2=1m ropen=ropen_mix rclosed=rclosed_mix
EMIXQ_c003_0_04 (mix_q_src_c003_0_04 0 bpf_c003_0 0) vcvs gain=9.807852804032e-01
SMIXQ_c003_0_04 (mix_q_src_c003_0_04 mix_q_c003_0 win_0_04 0) relay vt1=-1m vt2=1m ropen=ropen_mix rclosed=rclosed_mix
EMIXI_c003_0_05 (mix_i_src_c003_0_05 0 bpf_c003_0 0) vcvs gain=-5.555702330196e-01
SMIXI_c003_0_05 (mix_i_src_c003_0_05 mix_i_c003_0 win_0_05 0) relay vt1=-1m vt2=1m ropen=ropen_mix rclosed=rclosed_mix
EMIXQ_c003_0_05 (mix_q_src_c003_0_05 0 bpf_c003_0 0) vcvs gain=8.314696123025e-01
SMIXQ_c003_0_05 (mix_q_src_c003_0_05 mix_q_c003_0 win_0_05 0) relay vt1=-1m vt2=1m ropen=ropen_mix rclosed=rclosed_mix
EMIXI_c003_0_06 (mix_i_src_c003_0_06 0 bpf_c003_0 0) vcvs gain=-8.314696123025e-01
SMIXI_c003_0_06 (mix_i_src_c003_0_06 mix_i_c003_0 win_0_06 0) relay vt1=-1m vt2=1m ropen=ropen_mix rclosed=rclosed_mix
EMIXQ_c003_0_06 (mix_q_src_c003_0_06 0 bpf_c003_0 0) vcvs gain=5.555702330196e-01
SMIXQ_c003_0_06 (mix_q_src_c003_0_06 mix_q_c003_0 win_0_06 0) relay vt1=-1m vt2=1m ropen=ropen_mix rclosed=rclosed_mix
EMIXI_c003_0_07 (mix_i_src_c003_0_07 0 bpf_c003_0 0) vcvs gain=-9.807852804032e-01
SMIXI_c003_0_07 (mix_i_src_c003_0_07 mix_i_c003_0 win_0_07 0) relay vt1=-1m vt2=1m ropen=ropen_mix rclosed=rclosed_mix
EMIXQ_c003_0_07 (mix_q_src_c003_0_07 0 bpf_c003_0 0) vcvs gain=1.950903220161e-01
SMIXQ_c003_0_07 (mix_q_src_c003_0_07 mix_q_c003_0 win_0_07 0) relay vt1=-1m vt2=1m ropen=ropen_mix rclosed=rclosed_mix
EMIXI_c003_0_08 (mix_i_src_c003_0_08 0 bpf_c003_0 0) vcvs gain=-9.807852804032e-01
SMIXI_c003_0_08 (mix_i_src_c003_0_08 mix_i_c003_0 win_0_08 0) relay vt1=-1m vt2=1m ropen=ropen_mix rclosed=rclosed_mix
EMIXQ_c003_0_08 (mix_q_src_c003_0_08 0 bpf_c003_0 0) vcvs gain=-1.950903220161e-01
SMIXQ_c003_0_08 (mix_q_src_c003_0_08 mix_q_c003_0 win_0_08 0) relay vt1=-1m vt2=1m ropen=ropen_mix rclosed=rclosed_mix
EMIXI_c003_0_09 (mix_i_src_c003_0_09 0 bpf_c003_0 0) vcvs gain=-8.314696123025e-01
SMIXI_c003_0_09 (mix_i_src_c003_0_09 mix_i_c003_0 win_0_09 0) relay vt1=-1m vt2=1m ropen=ropen_mix rclosed=rclosed_mix
EMIXQ_c003_0_09 (mix_q_src_c003_0_09 0 bpf_c003_0 0) vcvs gain=-5.555702330196e-01
SMIXQ_c003_0_09 (mix_q_src_c003_0_09 mix_q_c003_0 win_0_09 0) relay vt1=-1m vt2=1m ropen=ropen_mix rclosed=rclosed_mix
EMIXI_c003_0_10 (mix_i_src_c003_0_10 0 bpf_c003_0 0) vcvs gain=-5.555702330196e-01
SMIXI_c003_0_10 (mix_i_src_c003_0_10 mix_i_c003_0 win_0_10 0) relay vt1=-1m vt2=1m ropen=ropen_mix rclosed=rclosed_mix
EMIXQ_c003_0_10 (mix_q_src_c003_0_10 0 bpf_c003_0 0) vcvs gain=-8.314696123025e-01
SMIXQ_c003_0_10 (mix_q_src_c003_0_10 mix_q_c003_0 win_0_10 0) relay vt1=-1m vt2=1m ropen=ropen_mix rclosed=rclosed_mix
EMIXI_c003_0_11 (mix_i_src_c003_0_11 0 bpf_c003_0 0) vcvs gain=-1.950903220161e-01
SMIXI_c003_0_11 (mix_i_src_c003_0_11 mix_i_c003_0 win_0_11 0) relay vt1=-1m vt2=1m ropen=ropen_mix rclosed=rclosed_mix
EMIXQ_c003_0_11 (mix_q_src_c003_0_11 0 bpf_c003_0 0) vcvs gain=-9.807852804032e-01
SMIXQ_c003_0_11 (mix_q_src_c003_0_11 mix_q_c003_0 win_0_11 0) relay vt1=-1m vt2=1m ropen=ropen_mix rclosed=rclosed_mix
EMIXI_c003_0_12 (mix_i_src_c003_0_12 0 bpf_c003_0 0) vcvs gain=1.950903220161e-01
SMIXI_c003_0_12 (mix_i_src_c003_0_12 mix_i_c003_0 win_0_12 0) relay vt1=-1m vt2=1m ropen=ropen_mix rclosed=rclosed_mix
EMIXQ_c003_0_12 (mix_q_src_c003_0_12 0 bpf_c003_0 0) vcvs gain=-9.807852804032e-01
SMIXQ_c003_0_12 (mix_q_src_c003_0_12 mix_q_c003_0 win_0_12 0) relay vt1=-1m vt2=1m ropen=ropen_mix rclosed=rclosed_mix
EMIXI_c003_0_13 (mix_i_src_c003_0_13 0 bpf_c003_0 0) vcvs gain=5.555702330196e-01
SMIXI_c003_0_13 (mix_i_src_c003_0_13 mix_i_c003_0 win_0_13 0) relay vt1=-1m vt2=1m ropen=ropen_mix rclosed=rclosed_mix
EMIXQ_c003_0_13 (mix_q_src_c003_0_13 0 bpf_c003_0 0) vcvs gain=-8.314696123025e-01
SMIXQ_c003_0_13 (mix_q_src_c003_0_13 mix_q_c003_0 win_0_13 0) relay vt1=-1m vt2=1m ropen=ropen_mix rclosed=rclosed_mix
EMIXI_c003_0_14 (mix_i_src_c003_0_14 0 bpf_c003_0 0) vcvs gain=8.314696123025e-01
SMIXI_c003_0_14 (mix_i_src_c003_0_14 mix_i_c003_0 win_0_14 0) relay vt1=-1m vt2=1m ropen=ropen_mix rclosed=rclosed_mix
EMIXQ_c003_0_14 (mix_q_src_c003_0_14 0 bpf_c003_0 0) vcvs gain=-5.555702330196e-01
SMIXQ_c003_0_14 (mix_q_src_c003_0_14 mix_q_c003_0 win_0_14 0) relay vt1=-1m vt2=1m ropen=ropen_mix rclosed=rclosed_mix
EMIXI_c003_0_15 (mix_i_src_c003_0_15 0 bpf_c003_0 0) vcvs gain=9.807852804032e-01
SMIXI_c003_0_15 (mix_i_src_c003_0_15 mix_i_c003_0 win_0_15 0) relay vt1=-1m vt2=1m ropen=ropen_mix rclosed=rclosed_mix
EMIXQ_c003_0_15 (mix_q_src_c003_0_15 0 bpf_c003_0 0) vcvs gain=-1.950903220161e-01
SMIXQ_c003_0_15 (mix_q_src_c003_0_15 mix_q_c003_0 win_0_15 0) relay vt1=-1m vt2=1m ropen=ropen_mix rclosed=rclosed_mix
RMIXI_c003_0 (mix_i_c003_0 0) resistor r=1G
RMIXQ_c003_0 (mix_q_c003_0 0) resistor r=1G
RINTI_c003_0 (mix_i_c003_0 Icar_c003_0) resistor r=1k
CINTI_c003_0 (Icar_c003_0 0) capacitor c=80p
RINTQ_c003_0 (mix_q_c003_0 Qcar_c003_0) resistor r=1k
CINTQ_c003_0 (Qcar_c003_0 0) capacitor c=80p
save bpf_c003_0 Icar_c003_0 Qcar_c003_0

// bl003, carrier_1: 500000000 Hz coherent I/Q phase-window verification-demod path
CBPF_c003_1 (bl003 n_cbpf_c003_1) capacitor c=1.013211836423e-13
LBPF_c003_1 (n_cbpf_c003_1 bpf_c003_1) inductor l=1.000000000000e-06
RBPF_c003_1 (bpf_c003_1 0) resistor r=1.570796326795e+02
EMIXI_c003_1_00 (mix_i_src_c003_1_00 0 bpf_c003_1 0) vcvs gain=9.807852804032e-01
SMIXI_c003_1_00 (mix_i_src_c003_1_00 mix_i_c003_1 win_1_00 0) relay vt1=-1m vt2=1m ropen=ropen_mix rclosed=rclosed_mix
EMIXQ_c003_1_00 (mix_q_src_c003_1_00 0 bpf_c003_1 0) vcvs gain=1.950903220161e-01
SMIXQ_c003_1_00 (mix_q_src_c003_1_00 mix_q_c003_1 win_1_00 0) relay vt1=-1m vt2=1m ropen=ropen_mix rclosed=rclosed_mix
EMIXI_c003_1_01 (mix_i_src_c003_1_01 0 bpf_c003_1 0) vcvs gain=8.314696123025e-01
SMIXI_c003_1_01 (mix_i_src_c003_1_01 mix_i_c003_1 win_1_01 0) relay vt1=-1m vt2=1m ropen=ropen_mix rclosed=rclosed_mix
EMIXQ_c003_1_01 (mix_q_src_c003_1_01 0 bpf_c003_1 0) vcvs gain=5.555702330196e-01
SMIXQ_c003_1_01 (mix_q_src_c003_1_01 mix_q_c003_1 win_1_01 0) relay vt1=-1m vt2=1m ropen=ropen_mix rclosed=rclosed_mix
EMIXI_c003_1_02 (mix_i_src_c003_1_02 0 bpf_c003_1 0) vcvs gain=5.555702330196e-01
SMIXI_c003_1_02 (mix_i_src_c003_1_02 mix_i_c003_1 win_1_02 0) relay vt1=-1m vt2=1m ropen=ropen_mix rclosed=rclosed_mix
EMIXQ_c003_1_02 (mix_q_src_c003_1_02 0 bpf_c003_1 0) vcvs gain=8.314696123025e-01
SMIXQ_c003_1_02 (mix_q_src_c003_1_02 mix_q_c003_1 win_1_02 0) relay vt1=-1m vt2=1m ropen=ropen_mix rclosed=rclosed_mix
EMIXI_c003_1_03 (mix_i_src_c003_1_03 0 bpf_c003_1 0) vcvs gain=1.950903220161e-01
SMIXI_c003_1_03 (mix_i_src_c003_1_03 mix_i_c003_1 win_1_03 0) relay vt1=-1m vt2=1m ropen=ropen_mix rclosed=rclosed_mix
EMIXQ_c003_1_03 (mix_q_src_c003_1_03 0 bpf_c003_1 0) vcvs gain=9.807852804032e-01
SMIXQ_c003_1_03 (mix_q_src_c003_1_03 mix_q_c003_1 win_1_03 0) relay vt1=-1m vt2=1m ropen=ropen_mix rclosed=rclosed_mix
EMIXI_c003_1_04 (mix_i_src_c003_1_04 0 bpf_c003_1 0) vcvs gain=-1.950903220161e-01
SMIXI_c003_1_04 (mix_i_src_c003_1_04 mix_i_c003_1 win_1_04 0) relay vt1=-1m vt2=1m ropen=ropen_mix rclosed=rclosed_mix
EMIXQ_c003_1_04 (mix_q_src_c003_1_04 0 bpf_c003_1 0) vcvs gain=9.807852804032e-01
SMIXQ_c003_1_04 (mix_q_src_c003_1_04 mix_q_c003_1 win_1_04 0) relay vt1=-1m vt2=1m ropen=ropen_mix rclosed=rclosed_mix
EMIXI_c003_1_05 (mix_i_src_c003_1_05 0 bpf_c003_1 0) vcvs gain=-5.555702330196e-01
SMIXI_c003_1_05 (mix_i_src_c003_1_05 mix_i_c003_1 win_1_05 0) relay vt1=-1m vt2=1m ropen=ropen_mix rclosed=rclosed_mix
EMIXQ_c003_1_05 (mix_q_src_c003_1_05 0 bpf_c003_1 0) vcvs gain=8.314696123025e-01
SMIXQ_c003_1_05 (mix_q_src_c003_1_05 mix_q_c003_1 win_1_05 0) relay vt1=-1m vt2=1m ropen=ropen_mix rclosed=rclosed_mix
EMIXI_c003_1_06 (mix_i_src_c003_1_06 0 bpf_c003_1 0) vcvs gain=-8.314696123025e-01
SMIXI_c003_1_06 (mix_i_src_c003_1_06 mix_i_c003_1 win_1_06 0) relay vt1=-1m vt2=1m ropen=ropen_mix rclosed=rclosed_mix
EMIXQ_c003_1_06 (mix_q_src_c003_1_06 0 bpf_c003_1 0) vcvs gain=5.555702330196e-01
SMIXQ_c003_1_06 (mix_q_src_c003_1_06 mix_q_c003_1 win_1_06 0) relay vt1=-1m vt2=1m ropen=ropen_mix rclosed=rclosed_mix
EMIXI_c003_1_07 (mix_i_src_c003_1_07 0 bpf_c003_1 0) vcvs gain=-9.807852804032e-01
SMIXI_c003_1_07 (mix_i_src_c003_1_07 mix_i_c003_1 win_1_07 0) relay vt1=-1m vt2=1m ropen=ropen_mix rclosed=rclosed_mix
EMIXQ_c003_1_07 (mix_q_src_c003_1_07 0 bpf_c003_1 0) vcvs gain=1.950903220161e-01
SMIXQ_c003_1_07 (mix_q_src_c003_1_07 mix_q_c003_1 win_1_07 0) relay vt1=-1m vt2=1m ropen=ropen_mix rclosed=rclosed_mix
EMIXI_c003_1_08 (mix_i_src_c003_1_08 0 bpf_c003_1 0) vcvs gain=-9.807852804032e-01
SMIXI_c003_1_08 (mix_i_src_c003_1_08 mix_i_c003_1 win_1_08 0) relay vt1=-1m vt2=1m ropen=ropen_mix rclosed=rclosed_mix
EMIXQ_c003_1_08 (mix_q_src_c003_1_08 0 bpf_c003_1 0) vcvs gain=-1.950903220161e-01
SMIXQ_c003_1_08 (mix_q_src_c003_1_08 mix_q_c003_1 win_1_08 0) relay vt1=-1m vt2=1m ropen=ropen_mix rclosed=rclosed_mix
EMIXI_c003_1_09 (mix_i_src_c003_1_09 0 bpf_c003_1 0) vcvs gain=-8.314696123025e-01
SMIXI_c003_1_09 (mix_i_src_c003_1_09 mix_i_c003_1 win_1_09 0) relay vt1=-1m vt2=1m ropen=ropen_mix rclosed=rclosed_mix
EMIXQ_c003_1_09 (mix_q_src_c003_1_09 0 bpf_c003_1 0) vcvs gain=-5.555702330196e-01
SMIXQ_c003_1_09 (mix_q_src_c003_1_09 mix_q_c003_1 win_1_09 0) relay vt1=-1m vt2=1m ropen=ropen_mix rclosed=rclosed_mix
EMIXI_c003_1_10 (mix_i_src_c003_1_10 0 bpf_c003_1 0) vcvs gain=-5.555702330196e-01
SMIXI_c003_1_10 (mix_i_src_c003_1_10 mix_i_c003_1 win_1_10 0) relay vt1=-1m vt2=1m ropen=ropen_mix rclosed=rclosed_mix
EMIXQ_c003_1_10 (mix_q_src_c003_1_10 0 bpf_c003_1 0) vcvs gain=-8.314696123025e-01
SMIXQ_c003_1_10 (mix_q_src_c003_1_10 mix_q_c003_1 win_1_10 0) relay vt1=-1m vt2=1m ropen=ropen_mix rclosed=rclosed_mix
EMIXI_c003_1_11 (mix_i_src_c003_1_11 0 bpf_c003_1 0) vcvs gain=-1.950903220161e-01
SMIXI_c003_1_11 (mix_i_src_c003_1_11 mix_i_c003_1 win_1_11 0) relay vt1=-1m vt2=1m ropen=ropen_mix rclosed=rclosed_mix
EMIXQ_c003_1_11 (mix_q_src_c003_1_11 0 bpf_c003_1 0) vcvs gain=-9.807852804032e-01
SMIXQ_c003_1_11 (mix_q_src_c003_1_11 mix_q_c003_1 win_1_11 0) relay vt1=-1m vt2=1m ropen=ropen_mix rclosed=rclosed_mix
EMIXI_c003_1_12 (mix_i_src_c003_1_12 0 bpf_c003_1 0) vcvs gain=1.950903220161e-01
SMIXI_c003_1_12 (mix_i_src_c003_1_12 mix_i_c003_1 win_1_12 0) relay vt1=-1m vt2=1m ropen=ropen_mix rclosed=rclosed_mix
EMIXQ_c003_1_12 (mix_q_src_c003_1_12 0 bpf_c003_1 0) vcvs gain=-9.807852804032e-01
SMIXQ_c003_1_12 (mix_q_src_c003_1_12 mix_q_c003_1 win_1_12 0) relay vt1=-1m vt2=1m ropen=ropen_mix rclosed=rclosed_mix
EMIXI_c003_1_13 (mix_i_src_c003_1_13 0 bpf_c003_1 0) vcvs gain=5.555702330196e-01
SMIXI_c003_1_13 (mix_i_src_c003_1_13 mix_i_c003_1 win_1_13 0) relay vt1=-1m vt2=1m ropen=ropen_mix rclosed=rclosed_mix
EMIXQ_c003_1_13 (mix_q_src_c003_1_13 0 bpf_c003_1 0) vcvs gain=-8.314696123025e-01
SMIXQ_c003_1_13 (mix_q_src_c003_1_13 mix_q_c003_1 win_1_13 0) relay vt1=-1m vt2=1m ropen=ropen_mix rclosed=rclosed_mix
EMIXI_c003_1_14 (mix_i_src_c003_1_14 0 bpf_c003_1 0) vcvs gain=8.314696123025e-01
SMIXI_c003_1_14 (mix_i_src_c003_1_14 mix_i_c003_1 win_1_14 0) relay vt1=-1m vt2=1m ropen=ropen_mix rclosed=rclosed_mix
EMIXQ_c003_1_14 (mix_q_src_c003_1_14 0 bpf_c003_1 0) vcvs gain=-5.555702330196e-01
SMIXQ_c003_1_14 (mix_q_src_c003_1_14 mix_q_c003_1 win_1_14 0) relay vt1=-1m vt2=1m ropen=ropen_mix rclosed=rclosed_mix
EMIXI_c003_1_15 (mix_i_src_c003_1_15 0 bpf_c003_1 0) vcvs gain=9.807852804032e-01
SMIXI_c003_1_15 (mix_i_src_c003_1_15 mix_i_c003_1 win_1_15 0) relay vt1=-1m vt2=1m ropen=ropen_mix rclosed=rclosed_mix
EMIXQ_c003_1_15 (mix_q_src_c003_1_15 0 bpf_c003_1 0) vcvs gain=-1.950903220161e-01
SMIXQ_c003_1_15 (mix_q_src_c003_1_15 mix_q_c003_1 win_1_15 0) relay vt1=-1m vt2=1m ropen=ropen_mix rclosed=rclosed_mix
RMIXI_c003_1 (mix_i_c003_1 0) resistor r=1G
RMIXQ_c003_1 (mix_q_c003_1 0) resistor r=1G
RINTI_c003_1 (mix_i_c003_1 Icar_c003_1) resistor r=1k
CINTI_c003_1 (Icar_c003_1 0) capacitor c=80p
RINTQ_c003_1 (mix_q_c003_1 Qcar_c003_1) resistor r=1k
CINTQ_c003_1 (Qcar_c003_1 0) capacitor c=80p
save bpf_c003_1 Icar_c003_1 Qcar_c003_1

// bl003, carrier_2: 750000000 Hz coherent I/Q phase-window verification-demod path
CBPF_c003_2 (bl003 n_cbpf_c003_2) capacitor c=4.503163717437e-14
LBPF_c003_2 (n_cbpf_c003_2 bpf_c003_2) inductor l=1.000000000000e-06
RBPF_c003_2 (bpf_c003_2 0) resistor r=2.356194490192e+02
EMIXI_c003_2_00 (mix_i_src_c003_2_00 0 bpf_c003_2 0) vcvs gain=9.807852804032e-01
SMIXI_c003_2_00 (mix_i_src_c003_2_00 mix_i_c003_2 win_2_00 0) relay vt1=-1m vt2=1m ropen=ropen_mix rclosed=rclosed_mix
EMIXQ_c003_2_00 (mix_q_src_c003_2_00 0 bpf_c003_2 0) vcvs gain=1.950903220161e-01
SMIXQ_c003_2_00 (mix_q_src_c003_2_00 mix_q_c003_2 win_2_00 0) relay vt1=-1m vt2=1m ropen=ropen_mix rclosed=rclosed_mix
EMIXI_c003_2_01 (mix_i_src_c003_2_01 0 bpf_c003_2 0) vcvs gain=8.314696123025e-01
SMIXI_c003_2_01 (mix_i_src_c003_2_01 mix_i_c003_2 win_2_01 0) relay vt1=-1m vt2=1m ropen=ropen_mix rclosed=rclosed_mix
EMIXQ_c003_2_01 (mix_q_src_c003_2_01 0 bpf_c003_2 0) vcvs gain=5.555702330196e-01
SMIXQ_c003_2_01 (mix_q_src_c003_2_01 mix_q_c003_2 win_2_01 0) relay vt1=-1m vt2=1m ropen=ropen_mix rclosed=rclosed_mix
EMIXI_c003_2_02 (mix_i_src_c003_2_02 0 bpf_c003_2 0) vcvs gain=5.555702330196e-01
SMIXI_c003_2_02 (mix_i_src_c003_2_02 mix_i_c003_2 win_2_02 0) relay vt1=-1m vt2=1m ropen=ropen_mix rclosed=rclosed_mix
EMIXQ_c003_2_02 (mix_q_src_c003_2_02 0 bpf_c003_2 0) vcvs gain=8.314696123025e-01
SMIXQ_c003_2_02 (mix_q_src_c003_2_02 mix_q_c003_2 win_2_02 0) relay vt1=-1m vt2=1m ropen=ropen_mix rclosed=rclosed_mix
EMIXI_c003_2_03 (mix_i_src_c003_2_03 0 bpf_c003_2 0) vcvs gain=1.950903220161e-01
SMIXI_c003_2_03 (mix_i_src_c003_2_03 mix_i_c003_2 win_2_03 0) relay vt1=-1m vt2=1m ropen=ropen_mix rclosed=rclosed_mix
EMIXQ_c003_2_03 (mix_q_src_c003_2_03 0 bpf_c003_2 0) vcvs gain=9.807852804032e-01
SMIXQ_c003_2_03 (mix_q_src_c003_2_03 mix_q_c003_2 win_2_03 0) relay vt1=-1m vt2=1m ropen=ropen_mix rclosed=rclosed_mix
EMIXI_c003_2_04 (mix_i_src_c003_2_04 0 bpf_c003_2 0) vcvs gain=-1.950903220161e-01
SMIXI_c003_2_04 (mix_i_src_c003_2_04 mix_i_c003_2 win_2_04 0) relay vt1=-1m vt2=1m ropen=ropen_mix rclosed=rclosed_mix
EMIXQ_c003_2_04 (mix_q_src_c003_2_04 0 bpf_c003_2 0) vcvs gain=9.807852804032e-01
SMIXQ_c003_2_04 (mix_q_src_c003_2_04 mix_q_c003_2 win_2_04 0) relay vt1=-1m vt2=1m ropen=ropen_mix rclosed=rclosed_mix
EMIXI_c003_2_05 (mix_i_src_c003_2_05 0 bpf_c003_2 0) vcvs gain=-5.555702330196e-01
SMIXI_c003_2_05 (mix_i_src_c003_2_05 mix_i_c003_2 win_2_05 0) relay vt1=-1m vt2=1m ropen=ropen_mix rclosed=rclosed_mix
EMIXQ_c003_2_05 (mix_q_src_c003_2_05 0 bpf_c003_2 0) vcvs gain=8.314696123025e-01
SMIXQ_c003_2_05 (mix_q_src_c003_2_05 mix_q_c003_2 win_2_05 0) relay vt1=-1m vt2=1m ropen=ropen_mix rclosed=rclosed_mix
EMIXI_c003_2_06 (mix_i_src_c003_2_06 0 bpf_c003_2 0) vcvs gain=-8.314696123025e-01
SMIXI_c003_2_06 (mix_i_src_c003_2_06 mix_i_c003_2 win_2_06 0) relay vt1=-1m vt2=1m ropen=ropen_mix rclosed=rclosed_mix
EMIXQ_c003_2_06 (mix_q_src_c003_2_06 0 bpf_c003_2 0) vcvs gain=5.555702330196e-01
SMIXQ_c003_2_06 (mix_q_src_c003_2_06 mix_q_c003_2 win_2_06 0) relay vt1=-1m vt2=1m ropen=ropen_mix rclosed=rclosed_mix
EMIXI_c003_2_07 (mix_i_src_c003_2_07 0 bpf_c003_2 0) vcvs gain=-9.807852804032e-01
SMIXI_c003_2_07 (mix_i_src_c003_2_07 mix_i_c003_2 win_2_07 0) relay vt1=-1m vt2=1m ropen=ropen_mix rclosed=rclosed_mix
EMIXQ_c003_2_07 (mix_q_src_c003_2_07 0 bpf_c003_2 0) vcvs gain=1.950903220161e-01
SMIXQ_c003_2_07 (mix_q_src_c003_2_07 mix_q_c003_2 win_2_07 0) relay vt1=-1m vt2=1m ropen=ropen_mix rclosed=rclosed_mix
EMIXI_c003_2_08 (mix_i_src_c003_2_08 0 bpf_c003_2 0) vcvs gain=-9.807852804032e-01
SMIXI_c003_2_08 (mix_i_src_c003_2_08 mix_i_c003_2 win_2_08 0) relay vt1=-1m vt2=1m ropen=ropen_mix rclosed=rclosed_mix
EMIXQ_c003_2_08 (mix_q_src_c003_2_08 0 bpf_c003_2 0) vcvs gain=-1.950903220161e-01
SMIXQ_c003_2_08 (mix_q_src_c003_2_08 mix_q_c003_2 win_2_08 0) relay vt1=-1m vt2=1m ropen=ropen_mix rclosed=rclosed_mix
EMIXI_c003_2_09 (mix_i_src_c003_2_09 0 bpf_c003_2 0) vcvs gain=-8.314696123025e-01
SMIXI_c003_2_09 (mix_i_src_c003_2_09 mix_i_c003_2 win_2_09 0) relay vt1=-1m vt2=1m ropen=ropen_mix rclosed=rclosed_mix
EMIXQ_c003_2_09 (mix_q_src_c003_2_09 0 bpf_c003_2 0) vcvs gain=-5.555702330196e-01
SMIXQ_c003_2_09 (mix_q_src_c003_2_09 mix_q_c003_2 win_2_09 0) relay vt1=-1m vt2=1m ropen=ropen_mix rclosed=rclosed_mix
EMIXI_c003_2_10 (mix_i_src_c003_2_10 0 bpf_c003_2 0) vcvs gain=-5.555702330196e-01
SMIXI_c003_2_10 (mix_i_src_c003_2_10 mix_i_c003_2 win_2_10 0) relay vt1=-1m vt2=1m ropen=ropen_mix rclosed=rclosed_mix
EMIXQ_c003_2_10 (mix_q_src_c003_2_10 0 bpf_c003_2 0) vcvs gain=-8.314696123025e-01
SMIXQ_c003_2_10 (mix_q_src_c003_2_10 mix_q_c003_2 win_2_10 0) relay vt1=-1m vt2=1m ropen=ropen_mix rclosed=rclosed_mix
EMIXI_c003_2_11 (mix_i_src_c003_2_11 0 bpf_c003_2 0) vcvs gain=-1.950903220161e-01
SMIXI_c003_2_11 (mix_i_src_c003_2_11 mix_i_c003_2 win_2_11 0) relay vt1=-1m vt2=1m ropen=ropen_mix rclosed=rclosed_mix
EMIXQ_c003_2_11 (mix_q_src_c003_2_11 0 bpf_c003_2 0) vcvs gain=-9.807852804032e-01
SMIXQ_c003_2_11 (mix_q_src_c003_2_11 mix_q_c003_2 win_2_11 0) relay vt1=-1m vt2=1m ropen=ropen_mix rclosed=rclosed_mix
EMIXI_c003_2_12 (mix_i_src_c003_2_12 0 bpf_c003_2 0) vcvs gain=1.950903220161e-01
SMIXI_c003_2_12 (mix_i_src_c003_2_12 mix_i_c003_2 win_2_12 0) relay vt1=-1m vt2=1m ropen=ropen_mix rclosed=rclosed_mix
EMIXQ_c003_2_12 (mix_q_src_c003_2_12 0 bpf_c003_2 0) vcvs gain=-9.807852804032e-01
SMIXQ_c003_2_12 (mix_q_src_c003_2_12 mix_q_c003_2 win_2_12 0) relay vt1=-1m vt2=1m ropen=ropen_mix rclosed=rclosed_mix
EMIXI_c003_2_13 (mix_i_src_c003_2_13 0 bpf_c003_2 0) vcvs gain=5.555702330196e-01
SMIXI_c003_2_13 (mix_i_src_c003_2_13 mix_i_c003_2 win_2_13 0) relay vt1=-1m vt2=1m ropen=ropen_mix rclosed=rclosed_mix
EMIXQ_c003_2_13 (mix_q_src_c003_2_13 0 bpf_c003_2 0) vcvs gain=-8.314696123025e-01
SMIXQ_c003_2_13 (mix_q_src_c003_2_13 mix_q_c003_2 win_2_13 0) relay vt1=-1m vt2=1m ropen=ropen_mix rclosed=rclosed_mix
EMIXI_c003_2_14 (mix_i_src_c003_2_14 0 bpf_c003_2 0) vcvs gain=8.314696123025e-01
SMIXI_c003_2_14 (mix_i_src_c003_2_14 mix_i_c003_2 win_2_14 0) relay vt1=-1m vt2=1m ropen=ropen_mix rclosed=rclosed_mix
EMIXQ_c003_2_14 (mix_q_src_c003_2_14 0 bpf_c003_2 0) vcvs gain=-5.555702330196e-01
SMIXQ_c003_2_14 (mix_q_src_c003_2_14 mix_q_c003_2 win_2_14 0) relay vt1=-1m vt2=1m ropen=ropen_mix rclosed=rclosed_mix
EMIXI_c003_2_15 (mix_i_src_c003_2_15 0 bpf_c003_2 0) vcvs gain=9.807852804032e-01
SMIXI_c003_2_15 (mix_i_src_c003_2_15 mix_i_c003_2 win_2_15 0) relay vt1=-1m vt2=1m ropen=ropen_mix rclosed=rclosed_mix
EMIXQ_c003_2_15 (mix_q_src_c003_2_15 0 bpf_c003_2 0) vcvs gain=-1.950903220161e-01
SMIXQ_c003_2_15 (mix_q_src_c003_2_15 mix_q_c003_2 win_2_15 0) relay vt1=-1m vt2=1m ropen=ropen_mix rclosed=rclosed_mix
RMIXI_c003_2 (mix_i_c003_2 0) resistor r=1G
RMIXQ_c003_2 (mix_q_c003_2 0) resistor r=1G
RINTI_c003_2 (mix_i_c003_2 Icar_c003_2) resistor r=1k
CINTI_c003_2 (Icar_c003_2 0) capacitor c=80p
RINTQ_c003_2 (mix_q_c003_2 Qcar_c003_2) resistor r=1k
CINTQ_c003_2 (Qcar_c003_2 0) capacitor c=80p
save bpf_c003_2 Icar_c003_2 Qcar_c003_2

// bl003, carrier_3: 1000000000 Hz coherent I/Q phase-window verification-demod path
CBPF_c003_3 (bl003 n_cbpf_c003_3) capacitor c=2.533029591058e-14
LBPF_c003_3 (n_cbpf_c003_3 bpf_c003_3) inductor l=1.000000000000e-06
RBPF_c003_3 (bpf_c003_3 0) resistor r=3.141592653590e+02
EMIXI_c003_3_00 (mix_i_src_c003_3_00 0 bpf_c003_3 0) vcvs gain=9.807852804032e-01
SMIXI_c003_3_00 (mix_i_src_c003_3_00 mix_i_c003_3 win_3_00 0) relay vt1=-1m vt2=1m ropen=ropen_mix rclosed=rclosed_mix
EMIXQ_c003_3_00 (mix_q_src_c003_3_00 0 bpf_c003_3 0) vcvs gain=1.950903220161e-01
SMIXQ_c003_3_00 (mix_q_src_c003_3_00 mix_q_c003_3 win_3_00 0) relay vt1=-1m vt2=1m ropen=ropen_mix rclosed=rclosed_mix
EMIXI_c003_3_01 (mix_i_src_c003_3_01 0 bpf_c003_3 0) vcvs gain=8.314696123025e-01
SMIXI_c003_3_01 (mix_i_src_c003_3_01 mix_i_c003_3 win_3_01 0) relay vt1=-1m vt2=1m ropen=ropen_mix rclosed=rclosed_mix
EMIXQ_c003_3_01 (mix_q_src_c003_3_01 0 bpf_c003_3 0) vcvs gain=5.555702330196e-01
SMIXQ_c003_3_01 (mix_q_src_c003_3_01 mix_q_c003_3 win_3_01 0) relay vt1=-1m vt2=1m ropen=ropen_mix rclosed=rclosed_mix
EMIXI_c003_3_02 (mix_i_src_c003_3_02 0 bpf_c003_3 0) vcvs gain=5.555702330196e-01
SMIXI_c003_3_02 (mix_i_src_c003_3_02 mix_i_c003_3 win_3_02 0) relay vt1=-1m vt2=1m ropen=ropen_mix rclosed=rclosed_mix
EMIXQ_c003_3_02 (mix_q_src_c003_3_02 0 bpf_c003_3 0) vcvs gain=8.314696123025e-01
SMIXQ_c003_3_02 (mix_q_src_c003_3_02 mix_q_c003_3 win_3_02 0) relay vt1=-1m vt2=1m ropen=ropen_mix rclosed=rclosed_mix
EMIXI_c003_3_03 (mix_i_src_c003_3_03 0 bpf_c003_3 0) vcvs gain=1.950903220161e-01
SMIXI_c003_3_03 (mix_i_src_c003_3_03 mix_i_c003_3 win_3_03 0) relay vt1=-1m vt2=1m ropen=ropen_mix rclosed=rclosed_mix
EMIXQ_c003_3_03 (mix_q_src_c003_3_03 0 bpf_c003_3 0) vcvs gain=9.807852804032e-01
SMIXQ_c003_3_03 (mix_q_src_c003_3_03 mix_q_c003_3 win_3_03 0) relay vt1=-1m vt2=1m ropen=ropen_mix rclosed=rclosed_mix
EMIXI_c003_3_04 (mix_i_src_c003_3_04 0 bpf_c003_3 0) vcvs gain=-1.950903220161e-01
SMIXI_c003_3_04 (mix_i_src_c003_3_04 mix_i_c003_3 win_3_04 0) relay vt1=-1m vt2=1m ropen=ropen_mix rclosed=rclosed_mix
EMIXQ_c003_3_04 (mix_q_src_c003_3_04 0 bpf_c003_3 0) vcvs gain=9.807852804032e-01
SMIXQ_c003_3_04 (mix_q_src_c003_3_04 mix_q_c003_3 win_3_04 0) relay vt1=-1m vt2=1m ropen=ropen_mix rclosed=rclosed_mix
EMIXI_c003_3_05 (mix_i_src_c003_3_05 0 bpf_c003_3 0) vcvs gain=-5.555702330196e-01
SMIXI_c003_3_05 (mix_i_src_c003_3_05 mix_i_c003_3 win_3_05 0) relay vt1=-1m vt2=1m ropen=ropen_mix rclosed=rclosed_mix
EMIXQ_c003_3_05 (mix_q_src_c003_3_05 0 bpf_c003_3 0) vcvs gain=8.314696123025e-01
SMIXQ_c003_3_05 (mix_q_src_c003_3_05 mix_q_c003_3 win_3_05 0) relay vt1=-1m vt2=1m ropen=ropen_mix rclosed=rclosed_mix
EMIXI_c003_3_06 (mix_i_src_c003_3_06 0 bpf_c003_3 0) vcvs gain=-8.314696123025e-01
SMIXI_c003_3_06 (mix_i_src_c003_3_06 mix_i_c003_3 win_3_06 0) relay vt1=-1m vt2=1m ropen=ropen_mix rclosed=rclosed_mix
EMIXQ_c003_3_06 (mix_q_src_c003_3_06 0 bpf_c003_3 0) vcvs gain=5.555702330196e-01
SMIXQ_c003_3_06 (mix_q_src_c003_3_06 mix_q_c003_3 win_3_06 0) relay vt1=-1m vt2=1m ropen=ropen_mix rclosed=rclosed_mix
EMIXI_c003_3_07 (mix_i_src_c003_3_07 0 bpf_c003_3 0) vcvs gain=-9.807852804032e-01
SMIXI_c003_3_07 (mix_i_src_c003_3_07 mix_i_c003_3 win_3_07 0) relay vt1=-1m vt2=1m ropen=ropen_mix rclosed=rclosed_mix
EMIXQ_c003_3_07 (mix_q_src_c003_3_07 0 bpf_c003_3 0) vcvs gain=1.950903220161e-01
SMIXQ_c003_3_07 (mix_q_src_c003_3_07 mix_q_c003_3 win_3_07 0) relay vt1=-1m vt2=1m ropen=ropen_mix rclosed=rclosed_mix
EMIXI_c003_3_08 (mix_i_src_c003_3_08 0 bpf_c003_3 0) vcvs gain=-9.807852804032e-01
SMIXI_c003_3_08 (mix_i_src_c003_3_08 mix_i_c003_3 win_3_08 0) relay vt1=-1m vt2=1m ropen=ropen_mix rclosed=rclosed_mix
EMIXQ_c003_3_08 (mix_q_src_c003_3_08 0 bpf_c003_3 0) vcvs gain=-1.950903220161e-01
SMIXQ_c003_3_08 (mix_q_src_c003_3_08 mix_q_c003_3 win_3_08 0) relay vt1=-1m vt2=1m ropen=ropen_mix rclosed=rclosed_mix
EMIXI_c003_3_09 (mix_i_src_c003_3_09 0 bpf_c003_3 0) vcvs gain=-8.314696123025e-01
SMIXI_c003_3_09 (mix_i_src_c003_3_09 mix_i_c003_3 win_3_09 0) relay vt1=-1m vt2=1m ropen=ropen_mix rclosed=rclosed_mix
EMIXQ_c003_3_09 (mix_q_src_c003_3_09 0 bpf_c003_3 0) vcvs gain=-5.555702330196e-01
SMIXQ_c003_3_09 (mix_q_src_c003_3_09 mix_q_c003_3 win_3_09 0) relay vt1=-1m vt2=1m ropen=ropen_mix rclosed=rclosed_mix
EMIXI_c003_3_10 (mix_i_src_c003_3_10 0 bpf_c003_3 0) vcvs gain=-5.555702330196e-01
SMIXI_c003_3_10 (mix_i_src_c003_3_10 mix_i_c003_3 win_3_10 0) relay vt1=-1m vt2=1m ropen=ropen_mix rclosed=rclosed_mix
EMIXQ_c003_3_10 (mix_q_src_c003_3_10 0 bpf_c003_3 0) vcvs gain=-8.314696123025e-01
SMIXQ_c003_3_10 (mix_q_src_c003_3_10 mix_q_c003_3 win_3_10 0) relay vt1=-1m vt2=1m ropen=ropen_mix rclosed=rclosed_mix
EMIXI_c003_3_11 (mix_i_src_c003_3_11 0 bpf_c003_3 0) vcvs gain=-1.950903220161e-01
SMIXI_c003_3_11 (mix_i_src_c003_3_11 mix_i_c003_3 win_3_11 0) relay vt1=-1m vt2=1m ropen=ropen_mix rclosed=rclosed_mix
EMIXQ_c003_3_11 (mix_q_src_c003_3_11 0 bpf_c003_3 0) vcvs gain=-9.807852804032e-01
SMIXQ_c003_3_11 (mix_q_src_c003_3_11 mix_q_c003_3 win_3_11 0) relay vt1=-1m vt2=1m ropen=ropen_mix rclosed=rclosed_mix
EMIXI_c003_3_12 (mix_i_src_c003_3_12 0 bpf_c003_3 0) vcvs gain=1.950903220161e-01
SMIXI_c003_3_12 (mix_i_src_c003_3_12 mix_i_c003_3 win_3_12 0) relay vt1=-1m vt2=1m ropen=ropen_mix rclosed=rclosed_mix
EMIXQ_c003_3_12 (mix_q_src_c003_3_12 0 bpf_c003_3 0) vcvs gain=-9.807852804032e-01
SMIXQ_c003_3_12 (mix_q_src_c003_3_12 mix_q_c003_3 win_3_12 0) relay vt1=-1m vt2=1m ropen=ropen_mix rclosed=rclosed_mix
EMIXI_c003_3_13 (mix_i_src_c003_3_13 0 bpf_c003_3 0) vcvs gain=5.555702330196e-01
SMIXI_c003_3_13 (mix_i_src_c003_3_13 mix_i_c003_3 win_3_13 0) relay vt1=-1m vt2=1m ropen=ropen_mix rclosed=rclosed_mix
EMIXQ_c003_3_13 (mix_q_src_c003_3_13 0 bpf_c003_3 0) vcvs gain=-8.314696123025e-01
SMIXQ_c003_3_13 (mix_q_src_c003_3_13 mix_q_c003_3 win_3_13 0) relay vt1=-1m vt2=1m ropen=ropen_mix rclosed=rclosed_mix
EMIXI_c003_3_14 (mix_i_src_c003_3_14 0 bpf_c003_3 0) vcvs gain=8.314696123025e-01
SMIXI_c003_3_14 (mix_i_src_c003_3_14 mix_i_c003_3 win_3_14 0) relay vt1=-1m vt2=1m ropen=ropen_mix rclosed=rclosed_mix
EMIXQ_c003_3_14 (mix_q_src_c003_3_14 0 bpf_c003_3 0) vcvs gain=-5.555702330196e-01
SMIXQ_c003_3_14 (mix_q_src_c003_3_14 mix_q_c003_3 win_3_14 0) relay vt1=-1m vt2=1m ropen=ropen_mix rclosed=rclosed_mix
EMIXI_c003_3_15 (mix_i_src_c003_3_15 0 bpf_c003_3 0) vcvs gain=9.807852804032e-01
SMIXI_c003_3_15 (mix_i_src_c003_3_15 mix_i_c003_3 win_3_15 0) relay vt1=-1m vt2=1m ropen=ropen_mix rclosed=rclosed_mix
EMIXQ_c003_3_15 (mix_q_src_c003_3_15 0 bpf_c003_3 0) vcvs gain=-1.950903220161e-01
SMIXQ_c003_3_15 (mix_q_src_c003_3_15 mix_q_c003_3 win_3_15 0) relay vt1=-1m vt2=1m ropen=ropen_mix rclosed=rclosed_mix
RMIXI_c003_3 (mix_i_c003_3 0) resistor r=1G
RMIXQ_c003_3 (mix_q_c003_3 0) resistor r=1G
RINTI_c003_3 (mix_i_c003_3 Icar_c003_3) resistor r=1k
CINTI_c003_3 (Icar_c003_3 0) capacitor c=80p
RINTQ_c003_3 (mix_q_c003_3 Qcar_c003_3) resistor r=1k
CINTQ_c003_3 (Qcar_c003_3 0) capacitor c=80p
save bpf_c003_3 Icar_c003_3 Qcar_c003_3

// bl004, carrier_0: 250000000 Hz coherent I/Q phase-window verification-demod path
CBPF_c004_0 (bl004 n_cbpf_c004_0) capacitor c=4.052847345694e-13
LBPF_c004_0 (n_cbpf_c004_0 bpf_c004_0) inductor l=1.000000000000e-06
RBPF_c004_0 (bpf_c004_0 0) resistor r=7.853981633974e+01
EMIXI_c004_0_00 (mix_i_src_c004_0_00 0 bpf_c004_0 0) vcvs gain=9.807852804032e-01
SMIXI_c004_0_00 (mix_i_src_c004_0_00 mix_i_c004_0 win_0_00 0) relay vt1=-1m vt2=1m ropen=ropen_mix rclosed=rclosed_mix
EMIXQ_c004_0_00 (mix_q_src_c004_0_00 0 bpf_c004_0 0) vcvs gain=1.950903220161e-01
SMIXQ_c004_0_00 (mix_q_src_c004_0_00 mix_q_c004_0 win_0_00 0) relay vt1=-1m vt2=1m ropen=ropen_mix rclosed=rclosed_mix
EMIXI_c004_0_01 (mix_i_src_c004_0_01 0 bpf_c004_0 0) vcvs gain=8.314696123025e-01
SMIXI_c004_0_01 (mix_i_src_c004_0_01 mix_i_c004_0 win_0_01 0) relay vt1=-1m vt2=1m ropen=ropen_mix rclosed=rclosed_mix
EMIXQ_c004_0_01 (mix_q_src_c004_0_01 0 bpf_c004_0 0) vcvs gain=5.555702330196e-01
SMIXQ_c004_0_01 (mix_q_src_c004_0_01 mix_q_c004_0 win_0_01 0) relay vt1=-1m vt2=1m ropen=ropen_mix rclosed=rclosed_mix
EMIXI_c004_0_02 (mix_i_src_c004_0_02 0 bpf_c004_0 0) vcvs gain=5.555702330196e-01
SMIXI_c004_0_02 (mix_i_src_c004_0_02 mix_i_c004_0 win_0_02 0) relay vt1=-1m vt2=1m ropen=ropen_mix rclosed=rclosed_mix
EMIXQ_c004_0_02 (mix_q_src_c004_0_02 0 bpf_c004_0 0) vcvs gain=8.314696123025e-01
SMIXQ_c004_0_02 (mix_q_src_c004_0_02 mix_q_c004_0 win_0_02 0) relay vt1=-1m vt2=1m ropen=ropen_mix rclosed=rclosed_mix
EMIXI_c004_0_03 (mix_i_src_c004_0_03 0 bpf_c004_0 0) vcvs gain=1.950903220161e-01
SMIXI_c004_0_03 (mix_i_src_c004_0_03 mix_i_c004_0 win_0_03 0) relay vt1=-1m vt2=1m ropen=ropen_mix rclosed=rclosed_mix
EMIXQ_c004_0_03 (mix_q_src_c004_0_03 0 bpf_c004_0 0) vcvs gain=9.807852804032e-01
SMIXQ_c004_0_03 (mix_q_src_c004_0_03 mix_q_c004_0 win_0_03 0) relay vt1=-1m vt2=1m ropen=ropen_mix rclosed=rclosed_mix
EMIXI_c004_0_04 (mix_i_src_c004_0_04 0 bpf_c004_0 0) vcvs gain=-1.950903220161e-01
SMIXI_c004_0_04 (mix_i_src_c004_0_04 mix_i_c004_0 win_0_04 0) relay vt1=-1m vt2=1m ropen=ropen_mix rclosed=rclosed_mix
EMIXQ_c004_0_04 (mix_q_src_c004_0_04 0 bpf_c004_0 0) vcvs gain=9.807852804032e-01
SMIXQ_c004_0_04 (mix_q_src_c004_0_04 mix_q_c004_0 win_0_04 0) relay vt1=-1m vt2=1m ropen=ropen_mix rclosed=rclosed_mix
EMIXI_c004_0_05 (mix_i_src_c004_0_05 0 bpf_c004_0 0) vcvs gain=-5.555702330196e-01
SMIXI_c004_0_05 (mix_i_src_c004_0_05 mix_i_c004_0 win_0_05 0) relay vt1=-1m vt2=1m ropen=ropen_mix rclosed=rclosed_mix
EMIXQ_c004_0_05 (mix_q_src_c004_0_05 0 bpf_c004_0 0) vcvs gain=8.314696123025e-01
SMIXQ_c004_0_05 (mix_q_src_c004_0_05 mix_q_c004_0 win_0_05 0) relay vt1=-1m vt2=1m ropen=ropen_mix rclosed=rclosed_mix
EMIXI_c004_0_06 (mix_i_src_c004_0_06 0 bpf_c004_0 0) vcvs gain=-8.314696123025e-01
SMIXI_c004_0_06 (mix_i_src_c004_0_06 mix_i_c004_0 win_0_06 0) relay vt1=-1m vt2=1m ropen=ropen_mix rclosed=rclosed_mix
EMIXQ_c004_0_06 (mix_q_src_c004_0_06 0 bpf_c004_0 0) vcvs gain=5.555702330196e-01
SMIXQ_c004_0_06 (mix_q_src_c004_0_06 mix_q_c004_0 win_0_06 0) relay vt1=-1m vt2=1m ropen=ropen_mix rclosed=rclosed_mix
EMIXI_c004_0_07 (mix_i_src_c004_0_07 0 bpf_c004_0 0) vcvs gain=-9.807852804032e-01
SMIXI_c004_0_07 (mix_i_src_c004_0_07 mix_i_c004_0 win_0_07 0) relay vt1=-1m vt2=1m ropen=ropen_mix rclosed=rclosed_mix
EMIXQ_c004_0_07 (mix_q_src_c004_0_07 0 bpf_c004_0 0) vcvs gain=1.950903220161e-01
SMIXQ_c004_0_07 (mix_q_src_c004_0_07 mix_q_c004_0 win_0_07 0) relay vt1=-1m vt2=1m ropen=ropen_mix rclosed=rclosed_mix
EMIXI_c004_0_08 (mix_i_src_c004_0_08 0 bpf_c004_0 0) vcvs gain=-9.807852804032e-01
SMIXI_c004_0_08 (mix_i_src_c004_0_08 mix_i_c004_0 win_0_08 0) relay vt1=-1m vt2=1m ropen=ropen_mix rclosed=rclosed_mix
EMIXQ_c004_0_08 (mix_q_src_c004_0_08 0 bpf_c004_0 0) vcvs gain=-1.950903220161e-01
SMIXQ_c004_0_08 (mix_q_src_c004_0_08 mix_q_c004_0 win_0_08 0) relay vt1=-1m vt2=1m ropen=ropen_mix rclosed=rclosed_mix
EMIXI_c004_0_09 (mix_i_src_c004_0_09 0 bpf_c004_0 0) vcvs gain=-8.314696123025e-01
SMIXI_c004_0_09 (mix_i_src_c004_0_09 mix_i_c004_0 win_0_09 0) relay vt1=-1m vt2=1m ropen=ropen_mix rclosed=rclosed_mix
EMIXQ_c004_0_09 (mix_q_src_c004_0_09 0 bpf_c004_0 0) vcvs gain=-5.555702330196e-01
SMIXQ_c004_0_09 (mix_q_src_c004_0_09 mix_q_c004_0 win_0_09 0) relay vt1=-1m vt2=1m ropen=ropen_mix rclosed=rclosed_mix
EMIXI_c004_0_10 (mix_i_src_c004_0_10 0 bpf_c004_0 0) vcvs gain=-5.555702330196e-01
SMIXI_c004_0_10 (mix_i_src_c004_0_10 mix_i_c004_0 win_0_10 0) relay vt1=-1m vt2=1m ropen=ropen_mix rclosed=rclosed_mix
EMIXQ_c004_0_10 (mix_q_src_c004_0_10 0 bpf_c004_0 0) vcvs gain=-8.314696123025e-01
SMIXQ_c004_0_10 (mix_q_src_c004_0_10 mix_q_c004_0 win_0_10 0) relay vt1=-1m vt2=1m ropen=ropen_mix rclosed=rclosed_mix
EMIXI_c004_0_11 (mix_i_src_c004_0_11 0 bpf_c004_0 0) vcvs gain=-1.950903220161e-01
SMIXI_c004_0_11 (mix_i_src_c004_0_11 mix_i_c004_0 win_0_11 0) relay vt1=-1m vt2=1m ropen=ropen_mix rclosed=rclosed_mix
EMIXQ_c004_0_11 (mix_q_src_c004_0_11 0 bpf_c004_0 0) vcvs gain=-9.807852804032e-01
SMIXQ_c004_0_11 (mix_q_src_c004_0_11 mix_q_c004_0 win_0_11 0) relay vt1=-1m vt2=1m ropen=ropen_mix rclosed=rclosed_mix
EMIXI_c004_0_12 (mix_i_src_c004_0_12 0 bpf_c004_0 0) vcvs gain=1.950903220161e-01
SMIXI_c004_0_12 (mix_i_src_c004_0_12 mix_i_c004_0 win_0_12 0) relay vt1=-1m vt2=1m ropen=ropen_mix rclosed=rclosed_mix
EMIXQ_c004_0_12 (mix_q_src_c004_0_12 0 bpf_c004_0 0) vcvs gain=-9.807852804032e-01
SMIXQ_c004_0_12 (mix_q_src_c004_0_12 mix_q_c004_0 win_0_12 0) relay vt1=-1m vt2=1m ropen=ropen_mix rclosed=rclosed_mix
EMIXI_c004_0_13 (mix_i_src_c004_0_13 0 bpf_c004_0 0) vcvs gain=5.555702330196e-01
SMIXI_c004_0_13 (mix_i_src_c004_0_13 mix_i_c004_0 win_0_13 0) relay vt1=-1m vt2=1m ropen=ropen_mix rclosed=rclosed_mix
EMIXQ_c004_0_13 (mix_q_src_c004_0_13 0 bpf_c004_0 0) vcvs gain=-8.314696123025e-01
SMIXQ_c004_0_13 (mix_q_src_c004_0_13 mix_q_c004_0 win_0_13 0) relay vt1=-1m vt2=1m ropen=ropen_mix rclosed=rclosed_mix
EMIXI_c004_0_14 (mix_i_src_c004_0_14 0 bpf_c004_0 0) vcvs gain=8.314696123025e-01
SMIXI_c004_0_14 (mix_i_src_c004_0_14 mix_i_c004_0 win_0_14 0) relay vt1=-1m vt2=1m ropen=ropen_mix rclosed=rclosed_mix
EMIXQ_c004_0_14 (mix_q_src_c004_0_14 0 bpf_c004_0 0) vcvs gain=-5.555702330196e-01
SMIXQ_c004_0_14 (mix_q_src_c004_0_14 mix_q_c004_0 win_0_14 0) relay vt1=-1m vt2=1m ropen=ropen_mix rclosed=rclosed_mix
EMIXI_c004_0_15 (mix_i_src_c004_0_15 0 bpf_c004_0 0) vcvs gain=9.807852804032e-01
SMIXI_c004_0_15 (mix_i_src_c004_0_15 mix_i_c004_0 win_0_15 0) relay vt1=-1m vt2=1m ropen=ropen_mix rclosed=rclosed_mix
EMIXQ_c004_0_15 (mix_q_src_c004_0_15 0 bpf_c004_0 0) vcvs gain=-1.950903220161e-01
SMIXQ_c004_0_15 (mix_q_src_c004_0_15 mix_q_c004_0 win_0_15 0) relay vt1=-1m vt2=1m ropen=ropen_mix rclosed=rclosed_mix
RMIXI_c004_0 (mix_i_c004_0 0) resistor r=1G
RMIXQ_c004_0 (mix_q_c004_0 0) resistor r=1G
RINTI_c004_0 (mix_i_c004_0 Icar_c004_0) resistor r=1k
CINTI_c004_0 (Icar_c004_0 0) capacitor c=80p
RINTQ_c004_0 (mix_q_c004_0 Qcar_c004_0) resistor r=1k
CINTQ_c004_0 (Qcar_c004_0 0) capacitor c=80p
save bpf_c004_0 Icar_c004_0 Qcar_c004_0

// bl004, carrier_1: 500000000 Hz coherent I/Q phase-window verification-demod path
CBPF_c004_1 (bl004 n_cbpf_c004_1) capacitor c=1.013211836423e-13
LBPF_c004_1 (n_cbpf_c004_1 bpf_c004_1) inductor l=1.000000000000e-06
RBPF_c004_1 (bpf_c004_1 0) resistor r=1.570796326795e+02
EMIXI_c004_1_00 (mix_i_src_c004_1_00 0 bpf_c004_1 0) vcvs gain=9.807852804032e-01
SMIXI_c004_1_00 (mix_i_src_c004_1_00 mix_i_c004_1 win_1_00 0) relay vt1=-1m vt2=1m ropen=ropen_mix rclosed=rclosed_mix
EMIXQ_c004_1_00 (mix_q_src_c004_1_00 0 bpf_c004_1 0) vcvs gain=1.950903220161e-01
SMIXQ_c004_1_00 (mix_q_src_c004_1_00 mix_q_c004_1 win_1_00 0) relay vt1=-1m vt2=1m ropen=ropen_mix rclosed=rclosed_mix
EMIXI_c004_1_01 (mix_i_src_c004_1_01 0 bpf_c004_1 0) vcvs gain=8.314696123025e-01
SMIXI_c004_1_01 (mix_i_src_c004_1_01 mix_i_c004_1 win_1_01 0) relay vt1=-1m vt2=1m ropen=ropen_mix rclosed=rclosed_mix
EMIXQ_c004_1_01 (mix_q_src_c004_1_01 0 bpf_c004_1 0) vcvs gain=5.555702330196e-01
SMIXQ_c004_1_01 (mix_q_src_c004_1_01 mix_q_c004_1 win_1_01 0) relay vt1=-1m vt2=1m ropen=ropen_mix rclosed=rclosed_mix
EMIXI_c004_1_02 (mix_i_src_c004_1_02 0 bpf_c004_1 0) vcvs gain=5.555702330196e-01
SMIXI_c004_1_02 (mix_i_src_c004_1_02 mix_i_c004_1 win_1_02 0) relay vt1=-1m vt2=1m ropen=ropen_mix rclosed=rclosed_mix
EMIXQ_c004_1_02 (mix_q_src_c004_1_02 0 bpf_c004_1 0) vcvs gain=8.314696123025e-01
SMIXQ_c004_1_02 (mix_q_src_c004_1_02 mix_q_c004_1 win_1_02 0) relay vt1=-1m vt2=1m ropen=ropen_mix rclosed=rclosed_mix
EMIXI_c004_1_03 (mix_i_src_c004_1_03 0 bpf_c004_1 0) vcvs gain=1.950903220161e-01
SMIXI_c004_1_03 (mix_i_src_c004_1_03 mix_i_c004_1 win_1_03 0) relay vt1=-1m vt2=1m ropen=ropen_mix rclosed=rclosed_mix
EMIXQ_c004_1_03 (mix_q_src_c004_1_03 0 bpf_c004_1 0) vcvs gain=9.807852804032e-01
SMIXQ_c004_1_03 (mix_q_src_c004_1_03 mix_q_c004_1 win_1_03 0) relay vt1=-1m vt2=1m ropen=ropen_mix rclosed=rclosed_mix
EMIXI_c004_1_04 (mix_i_src_c004_1_04 0 bpf_c004_1 0) vcvs gain=-1.950903220161e-01
SMIXI_c004_1_04 (mix_i_src_c004_1_04 mix_i_c004_1 win_1_04 0) relay vt1=-1m vt2=1m ropen=ropen_mix rclosed=rclosed_mix
EMIXQ_c004_1_04 (mix_q_src_c004_1_04 0 bpf_c004_1 0) vcvs gain=9.807852804032e-01
SMIXQ_c004_1_04 (mix_q_src_c004_1_04 mix_q_c004_1 win_1_04 0) relay vt1=-1m vt2=1m ropen=ropen_mix rclosed=rclosed_mix
EMIXI_c004_1_05 (mix_i_src_c004_1_05 0 bpf_c004_1 0) vcvs gain=-5.555702330196e-01
SMIXI_c004_1_05 (mix_i_src_c004_1_05 mix_i_c004_1 win_1_05 0) relay vt1=-1m vt2=1m ropen=ropen_mix rclosed=rclosed_mix
EMIXQ_c004_1_05 (mix_q_src_c004_1_05 0 bpf_c004_1 0) vcvs gain=8.314696123025e-01
SMIXQ_c004_1_05 (mix_q_src_c004_1_05 mix_q_c004_1 win_1_05 0) relay vt1=-1m vt2=1m ropen=ropen_mix rclosed=rclosed_mix
EMIXI_c004_1_06 (mix_i_src_c004_1_06 0 bpf_c004_1 0) vcvs gain=-8.314696123025e-01
SMIXI_c004_1_06 (mix_i_src_c004_1_06 mix_i_c004_1 win_1_06 0) relay vt1=-1m vt2=1m ropen=ropen_mix rclosed=rclosed_mix
EMIXQ_c004_1_06 (mix_q_src_c004_1_06 0 bpf_c004_1 0) vcvs gain=5.555702330196e-01
SMIXQ_c004_1_06 (mix_q_src_c004_1_06 mix_q_c004_1 win_1_06 0) relay vt1=-1m vt2=1m ropen=ropen_mix rclosed=rclosed_mix
EMIXI_c004_1_07 (mix_i_src_c004_1_07 0 bpf_c004_1 0) vcvs gain=-9.807852804032e-01
SMIXI_c004_1_07 (mix_i_src_c004_1_07 mix_i_c004_1 win_1_07 0) relay vt1=-1m vt2=1m ropen=ropen_mix rclosed=rclosed_mix
EMIXQ_c004_1_07 (mix_q_src_c004_1_07 0 bpf_c004_1 0) vcvs gain=1.950903220161e-01
SMIXQ_c004_1_07 (mix_q_src_c004_1_07 mix_q_c004_1 win_1_07 0) relay vt1=-1m vt2=1m ropen=ropen_mix rclosed=rclosed_mix
EMIXI_c004_1_08 (mix_i_src_c004_1_08 0 bpf_c004_1 0) vcvs gain=-9.807852804032e-01
SMIXI_c004_1_08 (mix_i_src_c004_1_08 mix_i_c004_1 win_1_08 0) relay vt1=-1m vt2=1m ropen=ropen_mix rclosed=rclosed_mix
EMIXQ_c004_1_08 (mix_q_src_c004_1_08 0 bpf_c004_1 0) vcvs gain=-1.950903220161e-01
SMIXQ_c004_1_08 (mix_q_src_c004_1_08 mix_q_c004_1 win_1_08 0) relay vt1=-1m vt2=1m ropen=ropen_mix rclosed=rclosed_mix
EMIXI_c004_1_09 (mix_i_src_c004_1_09 0 bpf_c004_1 0) vcvs gain=-8.314696123025e-01
SMIXI_c004_1_09 (mix_i_src_c004_1_09 mix_i_c004_1 win_1_09 0) relay vt1=-1m vt2=1m ropen=ropen_mix rclosed=rclosed_mix
EMIXQ_c004_1_09 (mix_q_src_c004_1_09 0 bpf_c004_1 0) vcvs gain=-5.555702330196e-01
SMIXQ_c004_1_09 (mix_q_src_c004_1_09 mix_q_c004_1 win_1_09 0) relay vt1=-1m vt2=1m ropen=ropen_mix rclosed=rclosed_mix
EMIXI_c004_1_10 (mix_i_src_c004_1_10 0 bpf_c004_1 0) vcvs gain=-5.555702330196e-01
SMIXI_c004_1_10 (mix_i_src_c004_1_10 mix_i_c004_1 win_1_10 0) relay vt1=-1m vt2=1m ropen=ropen_mix rclosed=rclosed_mix
EMIXQ_c004_1_10 (mix_q_src_c004_1_10 0 bpf_c004_1 0) vcvs gain=-8.314696123025e-01
SMIXQ_c004_1_10 (mix_q_src_c004_1_10 mix_q_c004_1 win_1_10 0) relay vt1=-1m vt2=1m ropen=ropen_mix rclosed=rclosed_mix
EMIXI_c004_1_11 (mix_i_src_c004_1_11 0 bpf_c004_1 0) vcvs gain=-1.950903220161e-01
SMIXI_c004_1_11 (mix_i_src_c004_1_11 mix_i_c004_1 win_1_11 0) relay vt1=-1m vt2=1m ropen=ropen_mix rclosed=rclosed_mix
EMIXQ_c004_1_11 (mix_q_src_c004_1_11 0 bpf_c004_1 0) vcvs gain=-9.807852804032e-01
SMIXQ_c004_1_11 (mix_q_src_c004_1_11 mix_q_c004_1 win_1_11 0) relay vt1=-1m vt2=1m ropen=ropen_mix rclosed=rclosed_mix
EMIXI_c004_1_12 (mix_i_src_c004_1_12 0 bpf_c004_1 0) vcvs gain=1.950903220161e-01
SMIXI_c004_1_12 (mix_i_src_c004_1_12 mix_i_c004_1 win_1_12 0) relay vt1=-1m vt2=1m ropen=ropen_mix rclosed=rclosed_mix
EMIXQ_c004_1_12 (mix_q_src_c004_1_12 0 bpf_c004_1 0) vcvs gain=-9.807852804032e-01
SMIXQ_c004_1_12 (mix_q_src_c004_1_12 mix_q_c004_1 win_1_12 0) relay vt1=-1m vt2=1m ropen=ropen_mix rclosed=rclosed_mix
EMIXI_c004_1_13 (mix_i_src_c004_1_13 0 bpf_c004_1 0) vcvs gain=5.555702330196e-01
SMIXI_c004_1_13 (mix_i_src_c004_1_13 mix_i_c004_1 win_1_13 0) relay vt1=-1m vt2=1m ropen=ropen_mix rclosed=rclosed_mix
EMIXQ_c004_1_13 (mix_q_src_c004_1_13 0 bpf_c004_1 0) vcvs gain=-8.314696123025e-01
SMIXQ_c004_1_13 (mix_q_src_c004_1_13 mix_q_c004_1 win_1_13 0) relay vt1=-1m vt2=1m ropen=ropen_mix rclosed=rclosed_mix
EMIXI_c004_1_14 (mix_i_src_c004_1_14 0 bpf_c004_1 0) vcvs gain=8.314696123025e-01
SMIXI_c004_1_14 (mix_i_src_c004_1_14 mix_i_c004_1 win_1_14 0) relay vt1=-1m vt2=1m ropen=ropen_mix rclosed=rclosed_mix
EMIXQ_c004_1_14 (mix_q_src_c004_1_14 0 bpf_c004_1 0) vcvs gain=-5.555702330196e-01
SMIXQ_c004_1_14 (mix_q_src_c004_1_14 mix_q_c004_1 win_1_14 0) relay vt1=-1m vt2=1m ropen=ropen_mix rclosed=rclosed_mix
EMIXI_c004_1_15 (mix_i_src_c004_1_15 0 bpf_c004_1 0) vcvs gain=9.807852804032e-01
SMIXI_c004_1_15 (mix_i_src_c004_1_15 mix_i_c004_1 win_1_15 0) relay vt1=-1m vt2=1m ropen=ropen_mix rclosed=rclosed_mix
EMIXQ_c004_1_15 (mix_q_src_c004_1_15 0 bpf_c004_1 0) vcvs gain=-1.950903220161e-01
SMIXQ_c004_1_15 (mix_q_src_c004_1_15 mix_q_c004_1 win_1_15 0) relay vt1=-1m vt2=1m ropen=ropen_mix rclosed=rclosed_mix
RMIXI_c004_1 (mix_i_c004_1 0) resistor r=1G
RMIXQ_c004_1 (mix_q_c004_1 0) resistor r=1G
RINTI_c004_1 (mix_i_c004_1 Icar_c004_1) resistor r=1k
CINTI_c004_1 (Icar_c004_1 0) capacitor c=80p
RINTQ_c004_1 (mix_q_c004_1 Qcar_c004_1) resistor r=1k
CINTQ_c004_1 (Qcar_c004_1 0) capacitor c=80p
save bpf_c004_1 Icar_c004_1 Qcar_c004_1

// bl004, carrier_2: 750000000 Hz coherent I/Q phase-window verification-demod path
CBPF_c004_2 (bl004 n_cbpf_c004_2) capacitor c=4.503163717437e-14
LBPF_c004_2 (n_cbpf_c004_2 bpf_c004_2) inductor l=1.000000000000e-06
RBPF_c004_2 (bpf_c004_2 0) resistor r=2.356194490192e+02
EMIXI_c004_2_00 (mix_i_src_c004_2_00 0 bpf_c004_2 0) vcvs gain=9.807852804032e-01
SMIXI_c004_2_00 (mix_i_src_c004_2_00 mix_i_c004_2 win_2_00 0) relay vt1=-1m vt2=1m ropen=ropen_mix rclosed=rclosed_mix
EMIXQ_c004_2_00 (mix_q_src_c004_2_00 0 bpf_c004_2 0) vcvs gain=1.950903220161e-01
SMIXQ_c004_2_00 (mix_q_src_c004_2_00 mix_q_c004_2 win_2_00 0) relay vt1=-1m vt2=1m ropen=ropen_mix rclosed=rclosed_mix
EMIXI_c004_2_01 (mix_i_src_c004_2_01 0 bpf_c004_2 0) vcvs gain=8.314696123025e-01
SMIXI_c004_2_01 (mix_i_src_c004_2_01 mix_i_c004_2 win_2_01 0) relay vt1=-1m vt2=1m ropen=ropen_mix rclosed=rclosed_mix
EMIXQ_c004_2_01 (mix_q_src_c004_2_01 0 bpf_c004_2 0) vcvs gain=5.555702330196e-01
SMIXQ_c004_2_01 (mix_q_src_c004_2_01 mix_q_c004_2 win_2_01 0) relay vt1=-1m vt2=1m ropen=ropen_mix rclosed=rclosed_mix
EMIXI_c004_2_02 (mix_i_src_c004_2_02 0 bpf_c004_2 0) vcvs gain=5.555702330196e-01
SMIXI_c004_2_02 (mix_i_src_c004_2_02 mix_i_c004_2 win_2_02 0) relay vt1=-1m vt2=1m ropen=ropen_mix rclosed=rclosed_mix
EMIXQ_c004_2_02 (mix_q_src_c004_2_02 0 bpf_c004_2 0) vcvs gain=8.314696123025e-01
SMIXQ_c004_2_02 (mix_q_src_c004_2_02 mix_q_c004_2 win_2_02 0) relay vt1=-1m vt2=1m ropen=ropen_mix rclosed=rclosed_mix
EMIXI_c004_2_03 (mix_i_src_c004_2_03 0 bpf_c004_2 0) vcvs gain=1.950903220161e-01
SMIXI_c004_2_03 (mix_i_src_c004_2_03 mix_i_c004_2 win_2_03 0) relay vt1=-1m vt2=1m ropen=ropen_mix rclosed=rclosed_mix
EMIXQ_c004_2_03 (mix_q_src_c004_2_03 0 bpf_c004_2 0) vcvs gain=9.807852804032e-01
SMIXQ_c004_2_03 (mix_q_src_c004_2_03 mix_q_c004_2 win_2_03 0) relay vt1=-1m vt2=1m ropen=ropen_mix rclosed=rclosed_mix
EMIXI_c004_2_04 (mix_i_src_c004_2_04 0 bpf_c004_2 0) vcvs gain=-1.950903220161e-01
SMIXI_c004_2_04 (mix_i_src_c004_2_04 mix_i_c004_2 win_2_04 0) relay vt1=-1m vt2=1m ropen=ropen_mix rclosed=rclosed_mix
EMIXQ_c004_2_04 (mix_q_src_c004_2_04 0 bpf_c004_2 0) vcvs gain=9.807852804032e-01
SMIXQ_c004_2_04 (mix_q_src_c004_2_04 mix_q_c004_2 win_2_04 0) relay vt1=-1m vt2=1m ropen=ropen_mix rclosed=rclosed_mix
EMIXI_c004_2_05 (mix_i_src_c004_2_05 0 bpf_c004_2 0) vcvs gain=-5.555702330196e-01
SMIXI_c004_2_05 (mix_i_src_c004_2_05 mix_i_c004_2 win_2_05 0) relay vt1=-1m vt2=1m ropen=ropen_mix rclosed=rclosed_mix
EMIXQ_c004_2_05 (mix_q_src_c004_2_05 0 bpf_c004_2 0) vcvs gain=8.314696123025e-01
SMIXQ_c004_2_05 (mix_q_src_c004_2_05 mix_q_c004_2 win_2_05 0) relay vt1=-1m vt2=1m ropen=ropen_mix rclosed=rclosed_mix
EMIXI_c004_2_06 (mix_i_src_c004_2_06 0 bpf_c004_2 0) vcvs gain=-8.314696123025e-01
SMIXI_c004_2_06 (mix_i_src_c004_2_06 mix_i_c004_2 win_2_06 0) relay vt1=-1m vt2=1m ropen=ropen_mix rclosed=rclosed_mix
EMIXQ_c004_2_06 (mix_q_src_c004_2_06 0 bpf_c004_2 0) vcvs gain=5.555702330196e-01
SMIXQ_c004_2_06 (mix_q_src_c004_2_06 mix_q_c004_2 win_2_06 0) relay vt1=-1m vt2=1m ropen=ropen_mix rclosed=rclosed_mix
EMIXI_c004_2_07 (mix_i_src_c004_2_07 0 bpf_c004_2 0) vcvs gain=-9.807852804032e-01
SMIXI_c004_2_07 (mix_i_src_c004_2_07 mix_i_c004_2 win_2_07 0) relay vt1=-1m vt2=1m ropen=ropen_mix rclosed=rclosed_mix
EMIXQ_c004_2_07 (mix_q_src_c004_2_07 0 bpf_c004_2 0) vcvs gain=1.950903220161e-01
SMIXQ_c004_2_07 (mix_q_src_c004_2_07 mix_q_c004_2 win_2_07 0) relay vt1=-1m vt2=1m ropen=ropen_mix rclosed=rclosed_mix
EMIXI_c004_2_08 (mix_i_src_c004_2_08 0 bpf_c004_2 0) vcvs gain=-9.807852804032e-01
SMIXI_c004_2_08 (mix_i_src_c004_2_08 mix_i_c004_2 win_2_08 0) relay vt1=-1m vt2=1m ropen=ropen_mix rclosed=rclosed_mix
EMIXQ_c004_2_08 (mix_q_src_c004_2_08 0 bpf_c004_2 0) vcvs gain=-1.950903220161e-01
SMIXQ_c004_2_08 (mix_q_src_c004_2_08 mix_q_c004_2 win_2_08 0) relay vt1=-1m vt2=1m ropen=ropen_mix rclosed=rclosed_mix
EMIXI_c004_2_09 (mix_i_src_c004_2_09 0 bpf_c004_2 0) vcvs gain=-8.314696123025e-01
SMIXI_c004_2_09 (mix_i_src_c004_2_09 mix_i_c004_2 win_2_09 0) relay vt1=-1m vt2=1m ropen=ropen_mix rclosed=rclosed_mix
EMIXQ_c004_2_09 (mix_q_src_c004_2_09 0 bpf_c004_2 0) vcvs gain=-5.555702330196e-01
SMIXQ_c004_2_09 (mix_q_src_c004_2_09 mix_q_c004_2 win_2_09 0) relay vt1=-1m vt2=1m ropen=ropen_mix rclosed=rclosed_mix
EMIXI_c004_2_10 (mix_i_src_c004_2_10 0 bpf_c004_2 0) vcvs gain=-5.555702330196e-01
SMIXI_c004_2_10 (mix_i_src_c004_2_10 mix_i_c004_2 win_2_10 0) relay vt1=-1m vt2=1m ropen=ropen_mix rclosed=rclosed_mix
EMIXQ_c004_2_10 (mix_q_src_c004_2_10 0 bpf_c004_2 0) vcvs gain=-8.314696123025e-01
SMIXQ_c004_2_10 (mix_q_src_c004_2_10 mix_q_c004_2 win_2_10 0) relay vt1=-1m vt2=1m ropen=ropen_mix rclosed=rclosed_mix
EMIXI_c004_2_11 (mix_i_src_c004_2_11 0 bpf_c004_2 0) vcvs gain=-1.950903220161e-01
SMIXI_c004_2_11 (mix_i_src_c004_2_11 mix_i_c004_2 win_2_11 0) relay vt1=-1m vt2=1m ropen=ropen_mix rclosed=rclosed_mix
EMIXQ_c004_2_11 (mix_q_src_c004_2_11 0 bpf_c004_2 0) vcvs gain=-9.807852804032e-01
SMIXQ_c004_2_11 (mix_q_src_c004_2_11 mix_q_c004_2 win_2_11 0) relay vt1=-1m vt2=1m ropen=ropen_mix rclosed=rclosed_mix
EMIXI_c004_2_12 (mix_i_src_c004_2_12 0 bpf_c004_2 0) vcvs gain=1.950903220161e-01
SMIXI_c004_2_12 (mix_i_src_c004_2_12 mix_i_c004_2 win_2_12 0) relay vt1=-1m vt2=1m ropen=ropen_mix rclosed=rclosed_mix
EMIXQ_c004_2_12 (mix_q_src_c004_2_12 0 bpf_c004_2 0) vcvs gain=-9.807852804032e-01
SMIXQ_c004_2_12 (mix_q_src_c004_2_12 mix_q_c004_2 win_2_12 0) relay vt1=-1m vt2=1m ropen=ropen_mix rclosed=rclosed_mix
EMIXI_c004_2_13 (mix_i_src_c004_2_13 0 bpf_c004_2 0) vcvs gain=5.555702330196e-01
SMIXI_c004_2_13 (mix_i_src_c004_2_13 mix_i_c004_2 win_2_13 0) relay vt1=-1m vt2=1m ropen=ropen_mix rclosed=rclosed_mix
EMIXQ_c004_2_13 (mix_q_src_c004_2_13 0 bpf_c004_2 0) vcvs gain=-8.314696123025e-01
SMIXQ_c004_2_13 (mix_q_src_c004_2_13 mix_q_c004_2 win_2_13 0) relay vt1=-1m vt2=1m ropen=ropen_mix rclosed=rclosed_mix
EMIXI_c004_2_14 (mix_i_src_c004_2_14 0 bpf_c004_2 0) vcvs gain=8.314696123025e-01
SMIXI_c004_2_14 (mix_i_src_c004_2_14 mix_i_c004_2 win_2_14 0) relay vt1=-1m vt2=1m ropen=ropen_mix rclosed=rclosed_mix
EMIXQ_c004_2_14 (mix_q_src_c004_2_14 0 bpf_c004_2 0) vcvs gain=-5.555702330196e-01
SMIXQ_c004_2_14 (mix_q_src_c004_2_14 mix_q_c004_2 win_2_14 0) relay vt1=-1m vt2=1m ropen=ropen_mix rclosed=rclosed_mix
EMIXI_c004_2_15 (mix_i_src_c004_2_15 0 bpf_c004_2 0) vcvs gain=9.807852804032e-01
SMIXI_c004_2_15 (mix_i_src_c004_2_15 mix_i_c004_2 win_2_15 0) relay vt1=-1m vt2=1m ropen=ropen_mix rclosed=rclosed_mix
EMIXQ_c004_2_15 (mix_q_src_c004_2_15 0 bpf_c004_2 0) vcvs gain=-1.950903220161e-01
SMIXQ_c004_2_15 (mix_q_src_c004_2_15 mix_q_c004_2 win_2_15 0) relay vt1=-1m vt2=1m ropen=ropen_mix rclosed=rclosed_mix
RMIXI_c004_2 (mix_i_c004_2 0) resistor r=1G
RMIXQ_c004_2 (mix_q_c004_2 0) resistor r=1G
RINTI_c004_2 (mix_i_c004_2 Icar_c004_2) resistor r=1k
CINTI_c004_2 (Icar_c004_2 0) capacitor c=80p
RINTQ_c004_2 (mix_q_c004_2 Qcar_c004_2) resistor r=1k
CINTQ_c004_2 (Qcar_c004_2 0) capacitor c=80p
save bpf_c004_2 Icar_c004_2 Qcar_c004_2

// bl004, carrier_3: 1000000000 Hz coherent I/Q phase-window verification-demod path
CBPF_c004_3 (bl004 n_cbpf_c004_3) capacitor c=2.533029591058e-14
LBPF_c004_3 (n_cbpf_c004_3 bpf_c004_3) inductor l=1.000000000000e-06
RBPF_c004_3 (bpf_c004_3 0) resistor r=3.141592653590e+02
EMIXI_c004_3_00 (mix_i_src_c004_3_00 0 bpf_c004_3 0) vcvs gain=9.807852804032e-01
SMIXI_c004_3_00 (mix_i_src_c004_3_00 mix_i_c004_3 win_3_00 0) relay vt1=-1m vt2=1m ropen=ropen_mix rclosed=rclosed_mix
EMIXQ_c004_3_00 (mix_q_src_c004_3_00 0 bpf_c004_3 0) vcvs gain=1.950903220161e-01
SMIXQ_c004_3_00 (mix_q_src_c004_3_00 mix_q_c004_3 win_3_00 0) relay vt1=-1m vt2=1m ropen=ropen_mix rclosed=rclosed_mix
EMIXI_c004_3_01 (mix_i_src_c004_3_01 0 bpf_c004_3 0) vcvs gain=8.314696123025e-01
SMIXI_c004_3_01 (mix_i_src_c004_3_01 mix_i_c004_3 win_3_01 0) relay vt1=-1m vt2=1m ropen=ropen_mix rclosed=rclosed_mix
EMIXQ_c004_3_01 (mix_q_src_c004_3_01 0 bpf_c004_3 0) vcvs gain=5.555702330196e-01
SMIXQ_c004_3_01 (mix_q_src_c004_3_01 mix_q_c004_3 win_3_01 0) relay vt1=-1m vt2=1m ropen=ropen_mix rclosed=rclosed_mix
EMIXI_c004_3_02 (mix_i_src_c004_3_02 0 bpf_c004_3 0) vcvs gain=5.555702330196e-01
SMIXI_c004_3_02 (mix_i_src_c004_3_02 mix_i_c004_3 win_3_02 0) relay vt1=-1m vt2=1m ropen=ropen_mix rclosed=rclosed_mix
EMIXQ_c004_3_02 (mix_q_src_c004_3_02 0 bpf_c004_3 0) vcvs gain=8.314696123025e-01
SMIXQ_c004_3_02 (mix_q_src_c004_3_02 mix_q_c004_3 win_3_02 0) relay vt1=-1m vt2=1m ropen=ropen_mix rclosed=rclosed_mix
EMIXI_c004_3_03 (mix_i_src_c004_3_03 0 bpf_c004_3 0) vcvs gain=1.950903220161e-01
SMIXI_c004_3_03 (mix_i_src_c004_3_03 mix_i_c004_3 win_3_03 0) relay vt1=-1m vt2=1m ropen=ropen_mix rclosed=rclosed_mix
EMIXQ_c004_3_03 (mix_q_src_c004_3_03 0 bpf_c004_3 0) vcvs gain=9.807852804032e-01
SMIXQ_c004_3_03 (mix_q_src_c004_3_03 mix_q_c004_3 win_3_03 0) relay vt1=-1m vt2=1m ropen=ropen_mix rclosed=rclosed_mix
EMIXI_c004_3_04 (mix_i_src_c004_3_04 0 bpf_c004_3 0) vcvs gain=-1.950903220161e-01
SMIXI_c004_3_04 (mix_i_src_c004_3_04 mix_i_c004_3 win_3_04 0) relay vt1=-1m vt2=1m ropen=ropen_mix rclosed=rclosed_mix
EMIXQ_c004_3_04 (mix_q_src_c004_3_04 0 bpf_c004_3 0) vcvs gain=9.807852804032e-01
SMIXQ_c004_3_04 (mix_q_src_c004_3_04 mix_q_c004_3 win_3_04 0) relay vt1=-1m vt2=1m ropen=ropen_mix rclosed=rclosed_mix
EMIXI_c004_3_05 (mix_i_src_c004_3_05 0 bpf_c004_3 0) vcvs gain=-5.555702330196e-01
SMIXI_c004_3_05 (mix_i_src_c004_3_05 mix_i_c004_3 win_3_05 0) relay vt1=-1m vt2=1m ropen=ropen_mix rclosed=rclosed_mix
EMIXQ_c004_3_05 (mix_q_src_c004_3_05 0 bpf_c004_3 0) vcvs gain=8.314696123025e-01
SMIXQ_c004_3_05 (mix_q_src_c004_3_05 mix_q_c004_3 win_3_05 0) relay vt1=-1m vt2=1m ropen=ropen_mix rclosed=rclosed_mix
EMIXI_c004_3_06 (mix_i_src_c004_3_06 0 bpf_c004_3 0) vcvs gain=-8.314696123025e-01
SMIXI_c004_3_06 (mix_i_src_c004_3_06 mix_i_c004_3 win_3_06 0) relay vt1=-1m vt2=1m ropen=ropen_mix rclosed=rclosed_mix
EMIXQ_c004_3_06 (mix_q_src_c004_3_06 0 bpf_c004_3 0) vcvs gain=5.555702330196e-01
SMIXQ_c004_3_06 (mix_q_src_c004_3_06 mix_q_c004_3 win_3_06 0) relay vt1=-1m vt2=1m ropen=ropen_mix rclosed=rclosed_mix
EMIXI_c004_3_07 (mix_i_src_c004_3_07 0 bpf_c004_3 0) vcvs gain=-9.807852804032e-01
SMIXI_c004_3_07 (mix_i_src_c004_3_07 mix_i_c004_3 win_3_07 0) relay vt1=-1m vt2=1m ropen=ropen_mix rclosed=rclosed_mix
EMIXQ_c004_3_07 (mix_q_src_c004_3_07 0 bpf_c004_3 0) vcvs gain=1.950903220161e-01
SMIXQ_c004_3_07 (mix_q_src_c004_3_07 mix_q_c004_3 win_3_07 0) relay vt1=-1m vt2=1m ropen=ropen_mix rclosed=rclosed_mix
EMIXI_c004_3_08 (mix_i_src_c004_3_08 0 bpf_c004_3 0) vcvs gain=-9.807852804032e-01
SMIXI_c004_3_08 (mix_i_src_c004_3_08 mix_i_c004_3 win_3_08 0) relay vt1=-1m vt2=1m ropen=ropen_mix rclosed=rclosed_mix
EMIXQ_c004_3_08 (mix_q_src_c004_3_08 0 bpf_c004_3 0) vcvs gain=-1.950903220161e-01
SMIXQ_c004_3_08 (mix_q_src_c004_3_08 mix_q_c004_3 win_3_08 0) relay vt1=-1m vt2=1m ropen=ropen_mix rclosed=rclosed_mix
EMIXI_c004_3_09 (mix_i_src_c004_3_09 0 bpf_c004_3 0) vcvs gain=-8.314696123025e-01
SMIXI_c004_3_09 (mix_i_src_c004_3_09 mix_i_c004_3 win_3_09 0) relay vt1=-1m vt2=1m ropen=ropen_mix rclosed=rclosed_mix
EMIXQ_c004_3_09 (mix_q_src_c004_3_09 0 bpf_c004_3 0) vcvs gain=-5.555702330196e-01
SMIXQ_c004_3_09 (mix_q_src_c004_3_09 mix_q_c004_3 win_3_09 0) relay vt1=-1m vt2=1m ropen=ropen_mix rclosed=rclosed_mix
EMIXI_c004_3_10 (mix_i_src_c004_3_10 0 bpf_c004_3 0) vcvs gain=-5.555702330196e-01
SMIXI_c004_3_10 (mix_i_src_c004_3_10 mix_i_c004_3 win_3_10 0) relay vt1=-1m vt2=1m ropen=ropen_mix rclosed=rclosed_mix
EMIXQ_c004_3_10 (mix_q_src_c004_3_10 0 bpf_c004_3 0) vcvs gain=-8.314696123025e-01
SMIXQ_c004_3_10 (mix_q_src_c004_3_10 mix_q_c004_3 win_3_10 0) relay vt1=-1m vt2=1m ropen=ropen_mix rclosed=rclosed_mix
EMIXI_c004_3_11 (mix_i_src_c004_3_11 0 bpf_c004_3 0) vcvs gain=-1.950903220161e-01
SMIXI_c004_3_11 (mix_i_src_c004_3_11 mix_i_c004_3 win_3_11 0) relay vt1=-1m vt2=1m ropen=ropen_mix rclosed=rclosed_mix
EMIXQ_c004_3_11 (mix_q_src_c004_3_11 0 bpf_c004_3 0) vcvs gain=-9.807852804032e-01
SMIXQ_c004_3_11 (mix_q_src_c004_3_11 mix_q_c004_3 win_3_11 0) relay vt1=-1m vt2=1m ropen=ropen_mix rclosed=rclosed_mix
EMIXI_c004_3_12 (mix_i_src_c004_3_12 0 bpf_c004_3 0) vcvs gain=1.950903220161e-01
SMIXI_c004_3_12 (mix_i_src_c004_3_12 mix_i_c004_3 win_3_12 0) relay vt1=-1m vt2=1m ropen=ropen_mix rclosed=rclosed_mix
EMIXQ_c004_3_12 (mix_q_src_c004_3_12 0 bpf_c004_3 0) vcvs gain=-9.807852804032e-01
SMIXQ_c004_3_12 (mix_q_src_c004_3_12 mix_q_c004_3 win_3_12 0) relay vt1=-1m vt2=1m ropen=ropen_mix rclosed=rclosed_mix
EMIXI_c004_3_13 (mix_i_src_c004_3_13 0 bpf_c004_3 0) vcvs gain=5.555702330196e-01
SMIXI_c004_3_13 (mix_i_src_c004_3_13 mix_i_c004_3 win_3_13 0) relay vt1=-1m vt2=1m ropen=ropen_mix rclosed=rclosed_mix
EMIXQ_c004_3_13 (mix_q_src_c004_3_13 0 bpf_c004_3 0) vcvs gain=-8.314696123025e-01
SMIXQ_c004_3_13 (mix_q_src_c004_3_13 mix_q_c004_3 win_3_13 0) relay vt1=-1m vt2=1m ropen=ropen_mix rclosed=rclosed_mix
EMIXI_c004_3_14 (mix_i_src_c004_3_14 0 bpf_c004_3 0) vcvs gain=8.314696123025e-01
SMIXI_c004_3_14 (mix_i_src_c004_3_14 mix_i_c004_3 win_3_14 0) relay vt1=-1m vt2=1m ropen=ropen_mix rclosed=rclosed_mix
EMIXQ_c004_3_14 (mix_q_src_c004_3_14 0 bpf_c004_3 0) vcvs gain=-5.555702330196e-01
SMIXQ_c004_3_14 (mix_q_src_c004_3_14 mix_q_c004_3 win_3_14 0) relay vt1=-1m vt2=1m ropen=ropen_mix rclosed=rclosed_mix
EMIXI_c004_3_15 (mix_i_src_c004_3_15 0 bpf_c004_3 0) vcvs gain=9.807852804032e-01
SMIXI_c004_3_15 (mix_i_src_c004_3_15 mix_i_c004_3 win_3_15 0) relay vt1=-1m vt2=1m ropen=ropen_mix rclosed=rclosed_mix
EMIXQ_c004_3_15 (mix_q_src_c004_3_15 0 bpf_c004_3 0) vcvs gain=-1.950903220161e-01
SMIXQ_c004_3_15 (mix_q_src_c004_3_15 mix_q_c004_3 win_3_15 0) relay vt1=-1m vt2=1m ropen=ropen_mix rclosed=rclosed_mix
RMIXI_c004_3 (mix_i_c004_3 0) resistor r=1G
RMIXQ_c004_3 (mix_q_c004_3 0) resistor r=1G
RINTI_c004_3 (mix_i_c004_3 Icar_c004_3) resistor r=1k
CINTI_c004_3 (Icar_c004_3 0) capacitor c=80p
RINTQ_c004_3 (mix_q_c004_3 Qcar_c004_3) resistor r=1k
CINTQ_c004_3 (Qcar_c004_3 0) capacitor c=80p
save bpf_c004_3 Icar_c004_3 Qcar_c004_3

// bl005, carrier_0: 250000000 Hz coherent I/Q phase-window verification-demod path
CBPF_c005_0 (bl005 n_cbpf_c005_0) capacitor c=4.052847345694e-13
LBPF_c005_0 (n_cbpf_c005_0 bpf_c005_0) inductor l=1.000000000000e-06
RBPF_c005_0 (bpf_c005_0 0) resistor r=7.853981633974e+01
EMIXI_c005_0_00 (mix_i_src_c005_0_00 0 bpf_c005_0 0) vcvs gain=9.807852804032e-01
SMIXI_c005_0_00 (mix_i_src_c005_0_00 mix_i_c005_0 win_0_00 0) relay vt1=-1m vt2=1m ropen=ropen_mix rclosed=rclosed_mix
EMIXQ_c005_0_00 (mix_q_src_c005_0_00 0 bpf_c005_0 0) vcvs gain=1.950903220161e-01
SMIXQ_c005_0_00 (mix_q_src_c005_0_00 mix_q_c005_0 win_0_00 0) relay vt1=-1m vt2=1m ropen=ropen_mix rclosed=rclosed_mix
EMIXI_c005_0_01 (mix_i_src_c005_0_01 0 bpf_c005_0 0) vcvs gain=8.314696123025e-01
SMIXI_c005_0_01 (mix_i_src_c005_0_01 mix_i_c005_0 win_0_01 0) relay vt1=-1m vt2=1m ropen=ropen_mix rclosed=rclosed_mix
EMIXQ_c005_0_01 (mix_q_src_c005_0_01 0 bpf_c005_0 0) vcvs gain=5.555702330196e-01
SMIXQ_c005_0_01 (mix_q_src_c005_0_01 mix_q_c005_0 win_0_01 0) relay vt1=-1m vt2=1m ropen=ropen_mix rclosed=rclosed_mix
EMIXI_c005_0_02 (mix_i_src_c005_0_02 0 bpf_c005_0 0) vcvs gain=5.555702330196e-01
SMIXI_c005_0_02 (mix_i_src_c005_0_02 mix_i_c005_0 win_0_02 0) relay vt1=-1m vt2=1m ropen=ropen_mix rclosed=rclosed_mix
EMIXQ_c005_0_02 (mix_q_src_c005_0_02 0 bpf_c005_0 0) vcvs gain=8.314696123025e-01
SMIXQ_c005_0_02 (mix_q_src_c005_0_02 mix_q_c005_0 win_0_02 0) relay vt1=-1m vt2=1m ropen=ropen_mix rclosed=rclosed_mix
EMIXI_c005_0_03 (mix_i_src_c005_0_03 0 bpf_c005_0 0) vcvs gain=1.950903220161e-01
SMIXI_c005_0_03 (mix_i_src_c005_0_03 mix_i_c005_0 win_0_03 0) relay vt1=-1m vt2=1m ropen=ropen_mix rclosed=rclosed_mix
EMIXQ_c005_0_03 (mix_q_src_c005_0_03 0 bpf_c005_0 0) vcvs gain=9.807852804032e-01
SMIXQ_c005_0_03 (mix_q_src_c005_0_03 mix_q_c005_0 win_0_03 0) relay vt1=-1m vt2=1m ropen=ropen_mix rclosed=rclosed_mix
EMIXI_c005_0_04 (mix_i_src_c005_0_04 0 bpf_c005_0 0) vcvs gain=-1.950903220161e-01
SMIXI_c005_0_04 (mix_i_src_c005_0_04 mix_i_c005_0 win_0_04 0) relay vt1=-1m vt2=1m ropen=ropen_mix rclosed=rclosed_mix
EMIXQ_c005_0_04 (mix_q_src_c005_0_04 0 bpf_c005_0 0) vcvs gain=9.807852804032e-01
SMIXQ_c005_0_04 (mix_q_src_c005_0_04 mix_q_c005_0 win_0_04 0) relay vt1=-1m vt2=1m ropen=ropen_mix rclosed=rclosed_mix
EMIXI_c005_0_05 (mix_i_src_c005_0_05 0 bpf_c005_0 0) vcvs gain=-5.555702330196e-01
SMIXI_c005_0_05 (mix_i_src_c005_0_05 mix_i_c005_0 win_0_05 0) relay vt1=-1m vt2=1m ropen=ropen_mix rclosed=rclosed_mix
EMIXQ_c005_0_05 (mix_q_src_c005_0_05 0 bpf_c005_0 0) vcvs gain=8.314696123025e-01
SMIXQ_c005_0_05 (mix_q_src_c005_0_05 mix_q_c005_0 win_0_05 0) relay vt1=-1m vt2=1m ropen=ropen_mix rclosed=rclosed_mix
EMIXI_c005_0_06 (mix_i_src_c005_0_06 0 bpf_c005_0 0) vcvs gain=-8.314696123025e-01
SMIXI_c005_0_06 (mix_i_src_c005_0_06 mix_i_c005_0 win_0_06 0) relay vt1=-1m vt2=1m ropen=ropen_mix rclosed=rclosed_mix
EMIXQ_c005_0_06 (mix_q_src_c005_0_06 0 bpf_c005_0 0) vcvs gain=5.555702330196e-01
SMIXQ_c005_0_06 (mix_q_src_c005_0_06 mix_q_c005_0 win_0_06 0) relay vt1=-1m vt2=1m ropen=ropen_mix rclosed=rclosed_mix
EMIXI_c005_0_07 (mix_i_src_c005_0_07 0 bpf_c005_0 0) vcvs gain=-9.807852804032e-01
SMIXI_c005_0_07 (mix_i_src_c005_0_07 mix_i_c005_0 win_0_07 0) relay vt1=-1m vt2=1m ropen=ropen_mix rclosed=rclosed_mix
EMIXQ_c005_0_07 (mix_q_src_c005_0_07 0 bpf_c005_0 0) vcvs gain=1.950903220161e-01
SMIXQ_c005_0_07 (mix_q_src_c005_0_07 mix_q_c005_0 win_0_07 0) relay vt1=-1m vt2=1m ropen=ropen_mix rclosed=rclosed_mix
EMIXI_c005_0_08 (mix_i_src_c005_0_08 0 bpf_c005_0 0) vcvs gain=-9.807852804032e-01
SMIXI_c005_0_08 (mix_i_src_c005_0_08 mix_i_c005_0 win_0_08 0) relay vt1=-1m vt2=1m ropen=ropen_mix rclosed=rclosed_mix
EMIXQ_c005_0_08 (mix_q_src_c005_0_08 0 bpf_c005_0 0) vcvs gain=-1.950903220161e-01
SMIXQ_c005_0_08 (mix_q_src_c005_0_08 mix_q_c005_0 win_0_08 0) relay vt1=-1m vt2=1m ropen=ropen_mix rclosed=rclosed_mix
EMIXI_c005_0_09 (mix_i_src_c005_0_09 0 bpf_c005_0 0) vcvs gain=-8.314696123025e-01
SMIXI_c005_0_09 (mix_i_src_c005_0_09 mix_i_c005_0 win_0_09 0) relay vt1=-1m vt2=1m ropen=ropen_mix rclosed=rclosed_mix
EMIXQ_c005_0_09 (mix_q_src_c005_0_09 0 bpf_c005_0 0) vcvs gain=-5.555702330196e-01
SMIXQ_c005_0_09 (mix_q_src_c005_0_09 mix_q_c005_0 win_0_09 0) relay vt1=-1m vt2=1m ropen=ropen_mix rclosed=rclosed_mix
EMIXI_c005_0_10 (mix_i_src_c005_0_10 0 bpf_c005_0 0) vcvs gain=-5.555702330196e-01
SMIXI_c005_0_10 (mix_i_src_c005_0_10 mix_i_c005_0 win_0_10 0) relay vt1=-1m vt2=1m ropen=ropen_mix rclosed=rclosed_mix
EMIXQ_c005_0_10 (mix_q_src_c005_0_10 0 bpf_c005_0 0) vcvs gain=-8.314696123025e-01
SMIXQ_c005_0_10 (mix_q_src_c005_0_10 mix_q_c005_0 win_0_10 0) relay vt1=-1m vt2=1m ropen=ropen_mix rclosed=rclosed_mix
EMIXI_c005_0_11 (mix_i_src_c005_0_11 0 bpf_c005_0 0) vcvs gain=-1.950903220161e-01
SMIXI_c005_0_11 (mix_i_src_c005_0_11 mix_i_c005_0 win_0_11 0) relay vt1=-1m vt2=1m ropen=ropen_mix rclosed=rclosed_mix
EMIXQ_c005_0_11 (mix_q_src_c005_0_11 0 bpf_c005_0 0) vcvs gain=-9.807852804032e-01
SMIXQ_c005_0_11 (mix_q_src_c005_0_11 mix_q_c005_0 win_0_11 0) relay vt1=-1m vt2=1m ropen=ropen_mix rclosed=rclosed_mix
EMIXI_c005_0_12 (mix_i_src_c005_0_12 0 bpf_c005_0 0) vcvs gain=1.950903220161e-01
SMIXI_c005_0_12 (mix_i_src_c005_0_12 mix_i_c005_0 win_0_12 0) relay vt1=-1m vt2=1m ropen=ropen_mix rclosed=rclosed_mix
EMIXQ_c005_0_12 (mix_q_src_c005_0_12 0 bpf_c005_0 0) vcvs gain=-9.807852804032e-01
SMIXQ_c005_0_12 (mix_q_src_c005_0_12 mix_q_c005_0 win_0_12 0) relay vt1=-1m vt2=1m ropen=ropen_mix rclosed=rclosed_mix
EMIXI_c005_0_13 (mix_i_src_c005_0_13 0 bpf_c005_0 0) vcvs gain=5.555702330196e-01
SMIXI_c005_0_13 (mix_i_src_c005_0_13 mix_i_c005_0 win_0_13 0) relay vt1=-1m vt2=1m ropen=ropen_mix rclosed=rclosed_mix
EMIXQ_c005_0_13 (mix_q_src_c005_0_13 0 bpf_c005_0 0) vcvs gain=-8.314696123025e-01
SMIXQ_c005_0_13 (mix_q_src_c005_0_13 mix_q_c005_0 win_0_13 0) relay vt1=-1m vt2=1m ropen=ropen_mix rclosed=rclosed_mix
EMIXI_c005_0_14 (mix_i_src_c005_0_14 0 bpf_c005_0 0) vcvs gain=8.314696123025e-01
SMIXI_c005_0_14 (mix_i_src_c005_0_14 mix_i_c005_0 win_0_14 0) relay vt1=-1m vt2=1m ropen=ropen_mix rclosed=rclosed_mix
EMIXQ_c005_0_14 (mix_q_src_c005_0_14 0 bpf_c005_0 0) vcvs gain=-5.555702330196e-01
SMIXQ_c005_0_14 (mix_q_src_c005_0_14 mix_q_c005_0 win_0_14 0) relay vt1=-1m vt2=1m ropen=ropen_mix rclosed=rclosed_mix
EMIXI_c005_0_15 (mix_i_src_c005_0_15 0 bpf_c005_0 0) vcvs gain=9.807852804032e-01
SMIXI_c005_0_15 (mix_i_src_c005_0_15 mix_i_c005_0 win_0_15 0) relay vt1=-1m vt2=1m ropen=ropen_mix rclosed=rclosed_mix
EMIXQ_c005_0_15 (mix_q_src_c005_0_15 0 bpf_c005_0 0) vcvs gain=-1.950903220161e-01
SMIXQ_c005_0_15 (mix_q_src_c005_0_15 mix_q_c005_0 win_0_15 0) relay vt1=-1m vt2=1m ropen=ropen_mix rclosed=rclosed_mix
RMIXI_c005_0 (mix_i_c005_0 0) resistor r=1G
RMIXQ_c005_0 (mix_q_c005_0 0) resistor r=1G
RINTI_c005_0 (mix_i_c005_0 Icar_c005_0) resistor r=1k
CINTI_c005_0 (Icar_c005_0 0) capacitor c=80p
RINTQ_c005_0 (mix_q_c005_0 Qcar_c005_0) resistor r=1k
CINTQ_c005_0 (Qcar_c005_0 0) capacitor c=80p
save bpf_c005_0 Icar_c005_0 Qcar_c005_0

// bl005, carrier_1: 500000000 Hz coherent I/Q phase-window verification-demod path
CBPF_c005_1 (bl005 n_cbpf_c005_1) capacitor c=1.013211836423e-13
LBPF_c005_1 (n_cbpf_c005_1 bpf_c005_1) inductor l=1.000000000000e-06
RBPF_c005_1 (bpf_c005_1 0) resistor r=1.570796326795e+02
EMIXI_c005_1_00 (mix_i_src_c005_1_00 0 bpf_c005_1 0) vcvs gain=9.807852804032e-01
SMIXI_c005_1_00 (mix_i_src_c005_1_00 mix_i_c005_1 win_1_00 0) relay vt1=-1m vt2=1m ropen=ropen_mix rclosed=rclosed_mix
EMIXQ_c005_1_00 (mix_q_src_c005_1_00 0 bpf_c005_1 0) vcvs gain=1.950903220161e-01
SMIXQ_c005_1_00 (mix_q_src_c005_1_00 mix_q_c005_1 win_1_00 0) relay vt1=-1m vt2=1m ropen=ropen_mix rclosed=rclosed_mix
EMIXI_c005_1_01 (mix_i_src_c005_1_01 0 bpf_c005_1 0) vcvs gain=8.314696123025e-01
SMIXI_c005_1_01 (mix_i_src_c005_1_01 mix_i_c005_1 win_1_01 0) relay vt1=-1m vt2=1m ropen=ropen_mix rclosed=rclosed_mix
EMIXQ_c005_1_01 (mix_q_src_c005_1_01 0 bpf_c005_1 0) vcvs gain=5.555702330196e-01
SMIXQ_c005_1_01 (mix_q_src_c005_1_01 mix_q_c005_1 win_1_01 0) relay vt1=-1m vt2=1m ropen=ropen_mix rclosed=rclosed_mix
EMIXI_c005_1_02 (mix_i_src_c005_1_02 0 bpf_c005_1 0) vcvs gain=5.555702330196e-01
SMIXI_c005_1_02 (mix_i_src_c005_1_02 mix_i_c005_1 win_1_02 0) relay vt1=-1m vt2=1m ropen=ropen_mix rclosed=rclosed_mix
EMIXQ_c005_1_02 (mix_q_src_c005_1_02 0 bpf_c005_1 0) vcvs gain=8.314696123025e-01
SMIXQ_c005_1_02 (mix_q_src_c005_1_02 mix_q_c005_1 win_1_02 0) relay vt1=-1m vt2=1m ropen=ropen_mix rclosed=rclosed_mix
EMIXI_c005_1_03 (mix_i_src_c005_1_03 0 bpf_c005_1 0) vcvs gain=1.950903220161e-01
SMIXI_c005_1_03 (mix_i_src_c005_1_03 mix_i_c005_1 win_1_03 0) relay vt1=-1m vt2=1m ropen=ropen_mix rclosed=rclosed_mix
EMIXQ_c005_1_03 (mix_q_src_c005_1_03 0 bpf_c005_1 0) vcvs gain=9.807852804032e-01
SMIXQ_c005_1_03 (mix_q_src_c005_1_03 mix_q_c005_1 win_1_03 0) relay vt1=-1m vt2=1m ropen=ropen_mix rclosed=rclosed_mix
EMIXI_c005_1_04 (mix_i_src_c005_1_04 0 bpf_c005_1 0) vcvs gain=-1.950903220161e-01
SMIXI_c005_1_04 (mix_i_src_c005_1_04 mix_i_c005_1 win_1_04 0) relay vt1=-1m vt2=1m ropen=ropen_mix rclosed=rclosed_mix
EMIXQ_c005_1_04 (mix_q_src_c005_1_04 0 bpf_c005_1 0) vcvs gain=9.807852804032e-01
SMIXQ_c005_1_04 (mix_q_src_c005_1_04 mix_q_c005_1 win_1_04 0) relay vt1=-1m vt2=1m ropen=ropen_mix rclosed=rclosed_mix
EMIXI_c005_1_05 (mix_i_src_c005_1_05 0 bpf_c005_1 0) vcvs gain=-5.555702330196e-01
SMIXI_c005_1_05 (mix_i_src_c005_1_05 mix_i_c005_1 win_1_05 0) relay vt1=-1m vt2=1m ropen=ropen_mix rclosed=rclosed_mix
EMIXQ_c005_1_05 (mix_q_src_c005_1_05 0 bpf_c005_1 0) vcvs gain=8.314696123025e-01
SMIXQ_c005_1_05 (mix_q_src_c005_1_05 mix_q_c005_1 win_1_05 0) relay vt1=-1m vt2=1m ropen=ropen_mix rclosed=rclosed_mix
EMIXI_c005_1_06 (mix_i_src_c005_1_06 0 bpf_c005_1 0) vcvs gain=-8.314696123025e-01
SMIXI_c005_1_06 (mix_i_src_c005_1_06 mix_i_c005_1 win_1_06 0) relay vt1=-1m vt2=1m ropen=ropen_mix rclosed=rclosed_mix
EMIXQ_c005_1_06 (mix_q_src_c005_1_06 0 bpf_c005_1 0) vcvs gain=5.555702330196e-01
SMIXQ_c005_1_06 (mix_q_src_c005_1_06 mix_q_c005_1 win_1_06 0) relay vt1=-1m vt2=1m ropen=ropen_mix rclosed=rclosed_mix
EMIXI_c005_1_07 (mix_i_src_c005_1_07 0 bpf_c005_1 0) vcvs gain=-9.807852804032e-01
SMIXI_c005_1_07 (mix_i_src_c005_1_07 mix_i_c005_1 win_1_07 0) relay vt1=-1m vt2=1m ropen=ropen_mix rclosed=rclosed_mix
EMIXQ_c005_1_07 (mix_q_src_c005_1_07 0 bpf_c005_1 0) vcvs gain=1.950903220161e-01
SMIXQ_c005_1_07 (mix_q_src_c005_1_07 mix_q_c005_1 win_1_07 0) relay vt1=-1m vt2=1m ropen=ropen_mix rclosed=rclosed_mix
EMIXI_c005_1_08 (mix_i_src_c005_1_08 0 bpf_c005_1 0) vcvs gain=-9.807852804032e-01
SMIXI_c005_1_08 (mix_i_src_c005_1_08 mix_i_c005_1 win_1_08 0) relay vt1=-1m vt2=1m ropen=ropen_mix rclosed=rclosed_mix
EMIXQ_c005_1_08 (mix_q_src_c005_1_08 0 bpf_c005_1 0) vcvs gain=-1.950903220161e-01
SMIXQ_c005_1_08 (mix_q_src_c005_1_08 mix_q_c005_1 win_1_08 0) relay vt1=-1m vt2=1m ropen=ropen_mix rclosed=rclosed_mix
EMIXI_c005_1_09 (mix_i_src_c005_1_09 0 bpf_c005_1 0) vcvs gain=-8.314696123025e-01
SMIXI_c005_1_09 (mix_i_src_c005_1_09 mix_i_c005_1 win_1_09 0) relay vt1=-1m vt2=1m ropen=ropen_mix rclosed=rclosed_mix
EMIXQ_c005_1_09 (mix_q_src_c005_1_09 0 bpf_c005_1 0) vcvs gain=-5.555702330196e-01
SMIXQ_c005_1_09 (mix_q_src_c005_1_09 mix_q_c005_1 win_1_09 0) relay vt1=-1m vt2=1m ropen=ropen_mix rclosed=rclosed_mix
EMIXI_c005_1_10 (mix_i_src_c005_1_10 0 bpf_c005_1 0) vcvs gain=-5.555702330196e-01
SMIXI_c005_1_10 (mix_i_src_c005_1_10 mix_i_c005_1 win_1_10 0) relay vt1=-1m vt2=1m ropen=ropen_mix rclosed=rclosed_mix
EMIXQ_c005_1_10 (mix_q_src_c005_1_10 0 bpf_c005_1 0) vcvs gain=-8.314696123025e-01
SMIXQ_c005_1_10 (mix_q_src_c005_1_10 mix_q_c005_1 win_1_10 0) relay vt1=-1m vt2=1m ropen=ropen_mix rclosed=rclosed_mix
EMIXI_c005_1_11 (mix_i_src_c005_1_11 0 bpf_c005_1 0) vcvs gain=-1.950903220161e-01
SMIXI_c005_1_11 (mix_i_src_c005_1_11 mix_i_c005_1 win_1_11 0) relay vt1=-1m vt2=1m ropen=ropen_mix rclosed=rclosed_mix
EMIXQ_c005_1_11 (mix_q_src_c005_1_11 0 bpf_c005_1 0) vcvs gain=-9.807852804032e-01
SMIXQ_c005_1_11 (mix_q_src_c005_1_11 mix_q_c005_1 win_1_11 0) relay vt1=-1m vt2=1m ropen=ropen_mix rclosed=rclosed_mix
EMIXI_c005_1_12 (mix_i_src_c005_1_12 0 bpf_c005_1 0) vcvs gain=1.950903220161e-01
SMIXI_c005_1_12 (mix_i_src_c005_1_12 mix_i_c005_1 win_1_12 0) relay vt1=-1m vt2=1m ropen=ropen_mix rclosed=rclosed_mix
EMIXQ_c005_1_12 (mix_q_src_c005_1_12 0 bpf_c005_1 0) vcvs gain=-9.807852804032e-01
SMIXQ_c005_1_12 (mix_q_src_c005_1_12 mix_q_c005_1 win_1_12 0) relay vt1=-1m vt2=1m ropen=ropen_mix rclosed=rclosed_mix
EMIXI_c005_1_13 (mix_i_src_c005_1_13 0 bpf_c005_1 0) vcvs gain=5.555702330196e-01
SMIXI_c005_1_13 (mix_i_src_c005_1_13 mix_i_c005_1 win_1_13 0) relay vt1=-1m vt2=1m ropen=ropen_mix rclosed=rclosed_mix
EMIXQ_c005_1_13 (mix_q_src_c005_1_13 0 bpf_c005_1 0) vcvs gain=-8.314696123025e-01
SMIXQ_c005_1_13 (mix_q_src_c005_1_13 mix_q_c005_1 win_1_13 0) relay vt1=-1m vt2=1m ropen=ropen_mix rclosed=rclosed_mix
EMIXI_c005_1_14 (mix_i_src_c005_1_14 0 bpf_c005_1 0) vcvs gain=8.314696123025e-01
SMIXI_c005_1_14 (mix_i_src_c005_1_14 mix_i_c005_1 win_1_14 0) relay vt1=-1m vt2=1m ropen=ropen_mix rclosed=rclosed_mix
EMIXQ_c005_1_14 (mix_q_src_c005_1_14 0 bpf_c005_1 0) vcvs gain=-5.555702330196e-01
SMIXQ_c005_1_14 (mix_q_src_c005_1_14 mix_q_c005_1 win_1_14 0) relay vt1=-1m vt2=1m ropen=ropen_mix rclosed=rclosed_mix
EMIXI_c005_1_15 (mix_i_src_c005_1_15 0 bpf_c005_1 0) vcvs gain=9.807852804032e-01
SMIXI_c005_1_15 (mix_i_src_c005_1_15 mix_i_c005_1 win_1_15 0) relay vt1=-1m vt2=1m ropen=ropen_mix rclosed=rclosed_mix
EMIXQ_c005_1_15 (mix_q_src_c005_1_15 0 bpf_c005_1 0) vcvs gain=-1.950903220161e-01
SMIXQ_c005_1_15 (mix_q_src_c005_1_15 mix_q_c005_1 win_1_15 0) relay vt1=-1m vt2=1m ropen=ropen_mix rclosed=rclosed_mix
RMIXI_c005_1 (mix_i_c005_1 0) resistor r=1G
RMIXQ_c005_1 (mix_q_c005_1 0) resistor r=1G
RINTI_c005_1 (mix_i_c005_1 Icar_c005_1) resistor r=1k
CINTI_c005_1 (Icar_c005_1 0) capacitor c=80p
RINTQ_c005_1 (mix_q_c005_1 Qcar_c005_1) resistor r=1k
CINTQ_c005_1 (Qcar_c005_1 0) capacitor c=80p
save bpf_c005_1 Icar_c005_1 Qcar_c005_1

// bl005, carrier_2: 750000000 Hz coherent I/Q phase-window verification-demod path
CBPF_c005_2 (bl005 n_cbpf_c005_2) capacitor c=4.503163717437e-14
LBPF_c005_2 (n_cbpf_c005_2 bpf_c005_2) inductor l=1.000000000000e-06
RBPF_c005_2 (bpf_c005_2 0) resistor r=2.356194490192e+02
EMIXI_c005_2_00 (mix_i_src_c005_2_00 0 bpf_c005_2 0) vcvs gain=9.807852804032e-01
SMIXI_c005_2_00 (mix_i_src_c005_2_00 mix_i_c005_2 win_2_00 0) relay vt1=-1m vt2=1m ropen=ropen_mix rclosed=rclosed_mix
EMIXQ_c005_2_00 (mix_q_src_c005_2_00 0 bpf_c005_2 0) vcvs gain=1.950903220161e-01
SMIXQ_c005_2_00 (mix_q_src_c005_2_00 mix_q_c005_2 win_2_00 0) relay vt1=-1m vt2=1m ropen=ropen_mix rclosed=rclosed_mix
EMIXI_c005_2_01 (mix_i_src_c005_2_01 0 bpf_c005_2 0) vcvs gain=8.314696123025e-01
SMIXI_c005_2_01 (mix_i_src_c005_2_01 mix_i_c005_2 win_2_01 0) relay vt1=-1m vt2=1m ropen=ropen_mix rclosed=rclosed_mix
EMIXQ_c005_2_01 (mix_q_src_c005_2_01 0 bpf_c005_2 0) vcvs gain=5.555702330196e-01
SMIXQ_c005_2_01 (mix_q_src_c005_2_01 mix_q_c005_2 win_2_01 0) relay vt1=-1m vt2=1m ropen=ropen_mix rclosed=rclosed_mix
EMIXI_c005_2_02 (mix_i_src_c005_2_02 0 bpf_c005_2 0) vcvs gain=5.555702330196e-01
SMIXI_c005_2_02 (mix_i_src_c005_2_02 mix_i_c005_2 win_2_02 0) relay vt1=-1m vt2=1m ropen=ropen_mix rclosed=rclosed_mix
EMIXQ_c005_2_02 (mix_q_src_c005_2_02 0 bpf_c005_2 0) vcvs gain=8.314696123025e-01
SMIXQ_c005_2_02 (mix_q_src_c005_2_02 mix_q_c005_2 win_2_02 0) relay vt1=-1m vt2=1m ropen=ropen_mix rclosed=rclosed_mix
EMIXI_c005_2_03 (mix_i_src_c005_2_03 0 bpf_c005_2 0) vcvs gain=1.950903220161e-01
SMIXI_c005_2_03 (mix_i_src_c005_2_03 mix_i_c005_2 win_2_03 0) relay vt1=-1m vt2=1m ropen=ropen_mix rclosed=rclosed_mix
EMIXQ_c005_2_03 (mix_q_src_c005_2_03 0 bpf_c005_2 0) vcvs gain=9.807852804032e-01
SMIXQ_c005_2_03 (mix_q_src_c005_2_03 mix_q_c005_2 win_2_03 0) relay vt1=-1m vt2=1m ropen=ropen_mix rclosed=rclosed_mix
EMIXI_c005_2_04 (mix_i_src_c005_2_04 0 bpf_c005_2 0) vcvs gain=-1.950903220161e-01
SMIXI_c005_2_04 (mix_i_src_c005_2_04 mix_i_c005_2 win_2_04 0) relay vt1=-1m vt2=1m ropen=ropen_mix rclosed=rclosed_mix
EMIXQ_c005_2_04 (mix_q_src_c005_2_04 0 bpf_c005_2 0) vcvs gain=9.807852804032e-01
SMIXQ_c005_2_04 (mix_q_src_c005_2_04 mix_q_c005_2 win_2_04 0) relay vt1=-1m vt2=1m ropen=ropen_mix rclosed=rclosed_mix
EMIXI_c005_2_05 (mix_i_src_c005_2_05 0 bpf_c005_2 0) vcvs gain=-5.555702330196e-01
SMIXI_c005_2_05 (mix_i_src_c005_2_05 mix_i_c005_2 win_2_05 0) relay vt1=-1m vt2=1m ropen=ropen_mix rclosed=rclosed_mix
EMIXQ_c005_2_05 (mix_q_src_c005_2_05 0 bpf_c005_2 0) vcvs gain=8.314696123025e-01
SMIXQ_c005_2_05 (mix_q_src_c005_2_05 mix_q_c005_2 win_2_05 0) relay vt1=-1m vt2=1m ropen=ropen_mix rclosed=rclosed_mix
EMIXI_c005_2_06 (mix_i_src_c005_2_06 0 bpf_c005_2 0) vcvs gain=-8.314696123025e-01
SMIXI_c005_2_06 (mix_i_src_c005_2_06 mix_i_c005_2 win_2_06 0) relay vt1=-1m vt2=1m ropen=ropen_mix rclosed=rclosed_mix
EMIXQ_c005_2_06 (mix_q_src_c005_2_06 0 bpf_c005_2 0) vcvs gain=5.555702330196e-01
SMIXQ_c005_2_06 (mix_q_src_c005_2_06 mix_q_c005_2 win_2_06 0) relay vt1=-1m vt2=1m ropen=ropen_mix rclosed=rclosed_mix
EMIXI_c005_2_07 (mix_i_src_c005_2_07 0 bpf_c005_2 0) vcvs gain=-9.807852804032e-01
SMIXI_c005_2_07 (mix_i_src_c005_2_07 mix_i_c005_2 win_2_07 0) relay vt1=-1m vt2=1m ropen=ropen_mix rclosed=rclosed_mix
EMIXQ_c005_2_07 (mix_q_src_c005_2_07 0 bpf_c005_2 0) vcvs gain=1.950903220161e-01
SMIXQ_c005_2_07 (mix_q_src_c005_2_07 mix_q_c005_2 win_2_07 0) relay vt1=-1m vt2=1m ropen=ropen_mix rclosed=rclosed_mix
EMIXI_c005_2_08 (mix_i_src_c005_2_08 0 bpf_c005_2 0) vcvs gain=-9.807852804032e-01
SMIXI_c005_2_08 (mix_i_src_c005_2_08 mix_i_c005_2 win_2_08 0) relay vt1=-1m vt2=1m ropen=ropen_mix rclosed=rclosed_mix
EMIXQ_c005_2_08 (mix_q_src_c005_2_08 0 bpf_c005_2 0) vcvs gain=-1.950903220161e-01
SMIXQ_c005_2_08 (mix_q_src_c005_2_08 mix_q_c005_2 win_2_08 0) relay vt1=-1m vt2=1m ropen=ropen_mix rclosed=rclosed_mix
EMIXI_c005_2_09 (mix_i_src_c005_2_09 0 bpf_c005_2 0) vcvs gain=-8.314696123025e-01
SMIXI_c005_2_09 (mix_i_src_c005_2_09 mix_i_c005_2 win_2_09 0) relay vt1=-1m vt2=1m ropen=ropen_mix rclosed=rclosed_mix
EMIXQ_c005_2_09 (mix_q_src_c005_2_09 0 bpf_c005_2 0) vcvs gain=-5.555702330196e-01
SMIXQ_c005_2_09 (mix_q_src_c005_2_09 mix_q_c005_2 win_2_09 0) relay vt1=-1m vt2=1m ropen=ropen_mix rclosed=rclosed_mix
EMIXI_c005_2_10 (mix_i_src_c005_2_10 0 bpf_c005_2 0) vcvs gain=-5.555702330196e-01
SMIXI_c005_2_10 (mix_i_src_c005_2_10 mix_i_c005_2 win_2_10 0) relay vt1=-1m vt2=1m ropen=ropen_mix rclosed=rclosed_mix
EMIXQ_c005_2_10 (mix_q_src_c005_2_10 0 bpf_c005_2 0) vcvs gain=-8.314696123025e-01
SMIXQ_c005_2_10 (mix_q_src_c005_2_10 mix_q_c005_2 win_2_10 0) relay vt1=-1m vt2=1m ropen=ropen_mix rclosed=rclosed_mix
EMIXI_c005_2_11 (mix_i_src_c005_2_11 0 bpf_c005_2 0) vcvs gain=-1.950903220161e-01
SMIXI_c005_2_11 (mix_i_src_c005_2_11 mix_i_c005_2 win_2_11 0) relay vt1=-1m vt2=1m ropen=ropen_mix rclosed=rclosed_mix
EMIXQ_c005_2_11 (mix_q_src_c005_2_11 0 bpf_c005_2 0) vcvs gain=-9.807852804032e-01
SMIXQ_c005_2_11 (mix_q_src_c005_2_11 mix_q_c005_2 win_2_11 0) relay vt1=-1m vt2=1m ropen=ropen_mix rclosed=rclosed_mix
EMIXI_c005_2_12 (mix_i_src_c005_2_12 0 bpf_c005_2 0) vcvs gain=1.950903220161e-01
SMIXI_c005_2_12 (mix_i_src_c005_2_12 mix_i_c005_2 win_2_12 0) relay vt1=-1m vt2=1m ropen=ropen_mix rclosed=rclosed_mix
EMIXQ_c005_2_12 (mix_q_src_c005_2_12 0 bpf_c005_2 0) vcvs gain=-9.807852804032e-01
SMIXQ_c005_2_12 (mix_q_src_c005_2_12 mix_q_c005_2 win_2_12 0) relay vt1=-1m vt2=1m ropen=ropen_mix rclosed=rclosed_mix
EMIXI_c005_2_13 (mix_i_src_c005_2_13 0 bpf_c005_2 0) vcvs gain=5.555702330196e-01
SMIXI_c005_2_13 (mix_i_src_c005_2_13 mix_i_c005_2 win_2_13 0) relay vt1=-1m vt2=1m ropen=ropen_mix rclosed=rclosed_mix
EMIXQ_c005_2_13 (mix_q_src_c005_2_13 0 bpf_c005_2 0) vcvs gain=-8.314696123025e-01
SMIXQ_c005_2_13 (mix_q_src_c005_2_13 mix_q_c005_2 win_2_13 0) relay vt1=-1m vt2=1m ropen=ropen_mix rclosed=rclosed_mix
EMIXI_c005_2_14 (mix_i_src_c005_2_14 0 bpf_c005_2 0) vcvs gain=8.314696123025e-01
SMIXI_c005_2_14 (mix_i_src_c005_2_14 mix_i_c005_2 win_2_14 0) relay vt1=-1m vt2=1m ropen=ropen_mix rclosed=rclosed_mix
EMIXQ_c005_2_14 (mix_q_src_c005_2_14 0 bpf_c005_2 0) vcvs gain=-5.555702330196e-01
SMIXQ_c005_2_14 (mix_q_src_c005_2_14 mix_q_c005_2 win_2_14 0) relay vt1=-1m vt2=1m ropen=ropen_mix rclosed=rclosed_mix
EMIXI_c005_2_15 (mix_i_src_c005_2_15 0 bpf_c005_2 0) vcvs gain=9.807852804032e-01
SMIXI_c005_2_15 (mix_i_src_c005_2_15 mix_i_c005_2 win_2_15 0) relay vt1=-1m vt2=1m ropen=ropen_mix rclosed=rclosed_mix
EMIXQ_c005_2_15 (mix_q_src_c005_2_15 0 bpf_c005_2 0) vcvs gain=-1.950903220161e-01
SMIXQ_c005_2_15 (mix_q_src_c005_2_15 mix_q_c005_2 win_2_15 0) relay vt1=-1m vt2=1m ropen=ropen_mix rclosed=rclosed_mix
RMIXI_c005_2 (mix_i_c005_2 0) resistor r=1G
RMIXQ_c005_2 (mix_q_c005_2 0) resistor r=1G
RINTI_c005_2 (mix_i_c005_2 Icar_c005_2) resistor r=1k
CINTI_c005_2 (Icar_c005_2 0) capacitor c=80p
RINTQ_c005_2 (mix_q_c005_2 Qcar_c005_2) resistor r=1k
CINTQ_c005_2 (Qcar_c005_2 0) capacitor c=80p
save bpf_c005_2 Icar_c005_2 Qcar_c005_2

// bl005, carrier_3: 1000000000 Hz coherent I/Q phase-window verification-demod path
CBPF_c005_3 (bl005 n_cbpf_c005_3) capacitor c=2.533029591058e-14
LBPF_c005_3 (n_cbpf_c005_3 bpf_c005_3) inductor l=1.000000000000e-06
RBPF_c005_3 (bpf_c005_3 0) resistor r=3.141592653590e+02
EMIXI_c005_3_00 (mix_i_src_c005_3_00 0 bpf_c005_3 0) vcvs gain=9.807852804032e-01
SMIXI_c005_3_00 (mix_i_src_c005_3_00 mix_i_c005_3 win_3_00 0) relay vt1=-1m vt2=1m ropen=ropen_mix rclosed=rclosed_mix
EMIXQ_c005_3_00 (mix_q_src_c005_3_00 0 bpf_c005_3 0) vcvs gain=1.950903220161e-01
SMIXQ_c005_3_00 (mix_q_src_c005_3_00 mix_q_c005_3 win_3_00 0) relay vt1=-1m vt2=1m ropen=ropen_mix rclosed=rclosed_mix
EMIXI_c005_3_01 (mix_i_src_c005_3_01 0 bpf_c005_3 0) vcvs gain=8.314696123025e-01
SMIXI_c005_3_01 (mix_i_src_c005_3_01 mix_i_c005_3 win_3_01 0) relay vt1=-1m vt2=1m ropen=ropen_mix rclosed=rclosed_mix
EMIXQ_c005_3_01 (mix_q_src_c005_3_01 0 bpf_c005_3 0) vcvs gain=5.555702330196e-01
SMIXQ_c005_3_01 (mix_q_src_c005_3_01 mix_q_c005_3 win_3_01 0) relay vt1=-1m vt2=1m ropen=ropen_mix rclosed=rclosed_mix
EMIXI_c005_3_02 (mix_i_src_c005_3_02 0 bpf_c005_3 0) vcvs gain=5.555702330196e-01
SMIXI_c005_3_02 (mix_i_src_c005_3_02 mix_i_c005_3 win_3_02 0) relay vt1=-1m vt2=1m ropen=ropen_mix rclosed=rclosed_mix
EMIXQ_c005_3_02 (mix_q_src_c005_3_02 0 bpf_c005_3 0) vcvs gain=8.314696123025e-01
SMIXQ_c005_3_02 (mix_q_src_c005_3_02 mix_q_c005_3 win_3_02 0) relay vt1=-1m vt2=1m ropen=ropen_mix rclosed=rclosed_mix
EMIXI_c005_3_03 (mix_i_src_c005_3_03 0 bpf_c005_3 0) vcvs gain=1.950903220161e-01
SMIXI_c005_3_03 (mix_i_src_c005_3_03 mix_i_c005_3 win_3_03 0) relay vt1=-1m vt2=1m ropen=ropen_mix rclosed=rclosed_mix
EMIXQ_c005_3_03 (mix_q_src_c005_3_03 0 bpf_c005_3 0) vcvs gain=9.807852804032e-01
SMIXQ_c005_3_03 (mix_q_src_c005_3_03 mix_q_c005_3 win_3_03 0) relay vt1=-1m vt2=1m ropen=ropen_mix rclosed=rclosed_mix
EMIXI_c005_3_04 (mix_i_src_c005_3_04 0 bpf_c005_3 0) vcvs gain=-1.950903220161e-01
SMIXI_c005_3_04 (mix_i_src_c005_3_04 mix_i_c005_3 win_3_04 0) relay vt1=-1m vt2=1m ropen=ropen_mix rclosed=rclosed_mix
EMIXQ_c005_3_04 (mix_q_src_c005_3_04 0 bpf_c005_3 0) vcvs gain=9.807852804032e-01
SMIXQ_c005_3_04 (mix_q_src_c005_3_04 mix_q_c005_3 win_3_04 0) relay vt1=-1m vt2=1m ropen=ropen_mix rclosed=rclosed_mix
EMIXI_c005_3_05 (mix_i_src_c005_3_05 0 bpf_c005_3 0) vcvs gain=-5.555702330196e-01
SMIXI_c005_3_05 (mix_i_src_c005_3_05 mix_i_c005_3 win_3_05 0) relay vt1=-1m vt2=1m ropen=ropen_mix rclosed=rclosed_mix
EMIXQ_c005_3_05 (mix_q_src_c005_3_05 0 bpf_c005_3 0) vcvs gain=8.314696123025e-01
SMIXQ_c005_3_05 (mix_q_src_c005_3_05 mix_q_c005_3 win_3_05 0) relay vt1=-1m vt2=1m ropen=ropen_mix rclosed=rclosed_mix
EMIXI_c005_3_06 (mix_i_src_c005_3_06 0 bpf_c005_3 0) vcvs gain=-8.314696123025e-01
SMIXI_c005_3_06 (mix_i_src_c005_3_06 mix_i_c005_3 win_3_06 0) relay vt1=-1m vt2=1m ropen=ropen_mix rclosed=rclosed_mix
EMIXQ_c005_3_06 (mix_q_src_c005_3_06 0 bpf_c005_3 0) vcvs gain=5.555702330196e-01
SMIXQ_c005_3_06 (mix_q_src_c005_3_06 mix_q_c005_3 win_3_06 0) relay vt1=-1m vt2=1m ropen=ropen_mix rclosed=rclosed_mix
EMIXI_c005_3_07 (mix_i_src_c005_3_07 0 bpf_c005_3 0) vcvs gain=-9.807852804032e-01
SMIXI_c005_3_07 (mix_i_src_c005_3_07 mix_i_c005_3 win_3_07 0) relay vt1=-1m vt2=1m ropen=ropen_mix rclosed=rclosed_mix
EMIXQ_c005_3_07 (mix_q_src_c005_3_07 0 bpf_c005_3 0) vcvs gain=1.950903220161e-01
SMIXQ_c005_3_07 (mix_q_src_c005_3_07 mix_q_c005_3 win_3_07 0) relay vt1=-1m vt2=1m ropen=ropen_mix rclosed=rclosed_mix
EMIXI_c005_3_08 (mix_i_src_c005_3_08 0 bpf_c005_3 0) vcvs gain=-9.807852804032e-01
SMIXI_c005_3_08 (mix_i_src_c005_3_08 mix_i_c005_3 win_3_08 0) relay vt1=-1m vt2=1m ropen=ropen_mix rclosed=rclosed_mix
EMIXQ_c005_3_08 (mix_q_src_c005_3_08 0 bpf_c005_3 0) vcvs gain=-1.950903220161e-01
SMIXQ_c005_3_08 (mix_q_src_c005_3_08 mix_q_c005_3 win_3_08 0) relay vt1=-1m vt2=1m ropen=ropen_mix rclosed=rclosed_mix
EMIXI_c005_3_09 (mix_i_src_c005_3_09 0 bpf_c005_3 0) vcvs gain=-8.314696123025e-01
SMIXI_c005_3_09 (mix_i_src_c005_3_09 mix_i_c005_3 win_3_09 0) relay vt1=-1m vt2=1m ropen=ropen_mix rclosed=rclosed_mix
EMIXQ_c005_3_09 (mix_q_src_c005_3_09 0 bpf_c005_3 0) vcvs gain=-5.555702330196e-01
SMIXQ_c005_3_09 (mix_q_src_c005_3_09 mix_q_c005_3 win_3_09 0) relay vt1=-1m vt2=1m ropen=ropen_mix rclosed=rclosed_mix
EMIXI_c005_3_10 (mix_i_src_c005_3_10 0 bpf_c005_3 0) vcvs gain=-5.555702330196e-01
SMIXI_c005_3_10 (mix_i_src_c005_3_10 mix_i_c005_3 win_3_10 0) relay vt1=-1m vt2=1m ropen=ropen_mix rclosed=rclosed_mix
EMIXQ_c005_3_10 (mix_q_src_c005_3_10 0 bpf_c005_3 0) vcvs gain=-8.314696123025e-01
SMIXQ_c005_3_10 (mix_q_src_c005_3_10 mix_q_c005_3 win_3_10 0) relay vt1=-1m vt2=1m ropen=ropen_mix rclosed=rclosed_mix
EMIXI_c005_3_11 (mix_i_src_c005_3_11 0 bpf_c005_3 0) vcvs gain=-1.950903220161e-01
SMIXI_c005_3_11 (mix_i_src_c005_3_11 mix_i_c005_3 win_3_11 0) relay vt1=-1m vt2=1m ropen=ropen_mix rclosed=rclosed_mix
EMIXQ_c005_3_11 (mix_q_src_c005_3_11 0 bpf_c005_3 0) vcvs gain=-9.807852804032e-01
SMIXQ_c005_3_11 (mix_q_src_c005_3_11 mix_q_c005_3 win_3_11 0) relay vt1=-1m vt2=1m ropen=ropen_mix rclosed=rclosed_mix
EMIXI_c005_3_12 (mix_i_src_c005_3_12 0 bpf_c005_3 0) vcvs gain=1.950903220161e-01
SMIXI_c005_3_12 (mix_i_src_c005_3_12 mix_i_c005_3 win_3_12 0) relay vt1=-1m vt2=1m ropen=ropen_mix rclosed=rclosed_mix
EMIXQ_c005_3_12 (mix_q_src_c005_3_12 0 bpf_c005_3 0) vcvs gain=-9.807852804032e-01
SMIXQ_c005_3_12 (mix_q_src_c005_3_12 mix_q_c005_3 win_3_12 0) relay vt1=-1m vt2=1m ropen=ropen_mix rclosed=rclosed_mix
EMIXI_c005_3_13 (mix_i_src_c005_3_13 0 bpf_c005_3 0) vcvs gain=5.555702330196e-01
SMIXI_c005_3_13 (mix_i_src_c005_3_13 mix_i_c005_3 win_3_13 0) relay vt1=-1m vt2=1m ropen=ropen_mix rclosed=rclosed_mix
EMIXQ_c005_3_13 (mix_q_src_c005_3_13 0 bpf_c005_3 0) vcvs gain=-8.314696123025e-01
SMIXQ_c005_3_13 (mix_q_src_c005_3_13 mix_q_c005_3 win_3_13 0) relay vt1=-1m vt2=1m ropen=ropen_mix rclosed=rclosed_mix
EMIXI_c005_3_14 (mix_i_src_c005_3_14 0 bpf_c005_3 0) vcvs gain=8.314696123025e-01
SMIXI_c005_3_14 (mix_i_src_c005_3_14 mix_i_c005_3 win_3_14 0) relay vt1=-1m vt2=1m ropen=ropen_mix rclosed=rclosed_mix
EMIXQ_c005_3_14 (mix_q_src_c005_3_14 0 bpf_c005_3 0) vcvs gain=-5.555702330196e-01
SMIXQ_c005_3_14 (mix_q_src_c005_3_14 mix_q_c005_3 win_3_14 0) relay vt1=-1m vt2=1m ropen=ropen_mix rclosed=rclosed_mix
EMIXI_c005_3_15 (mix_i_src_c005_3_15 0 bpf_c005_3 0) vcvs gain=9.807852804032e-01
SMIXI_c005_3_15 (mix_i_src_c005_3_15 mix_i_c005_3 win_3_15 0) relay vt1=-1m vt2=1m ropen=ropen_mix rclosed=rclosed_mix
EMIXQ_c005_3_15 (mix_q_src_c005_3_15 0 bpf_c005_3 0) vcvs gain=-1.950903220161e-01
SMIXQ_c005_3_15 (mix_q_src_c005_3_15 mix_q_c005_3 win_3_15 0) relay vt1=-1m vt2=1m ropen=ropen_mix rclosed=rclosed_mix
RMIXI_c005_3 (mix_i_c005_3 0) resistor r=1G
RMIXQ_c005_3 (mix_q_c005_3 0) resistor r=1G
RINTI_c005_3 (mix_i_c005_3 Icar_c005_3) resistor r=1k
CINTI_c005_3 (Icar_c005_3 0) capacitor c=80p
RINTQ_c005_3 (mix_q_c005_3 Qcar_c005_3) resistor r=1k
CINTQ_c005_3 (Qcar_c005_3 0) capacitor c=80p
save bpf_c005_3 Icar_c005_3 Qcar_c005_3

// bl006, carrier_0: 250000000 Hz coherent I/Q phase-window verification-demod path
CBPF_c006_0 (bl006 n_cbpf_c006_0) capacitor c=4.052847345694e-13
LBPF_c006_0 (n_cbpf_c006_0 bpf_c006_0) inductor l=1.000000000000e-06
RBPF_c006_0 (bpf_c006_0 0) resistor r=7.853981633974e+01
EMIXI_c006_0_00 (mix_i_src_c006_0_00 0 bpf_c006_0 0) vcvs gain=9.807852804032e-01
SMIXI_c006_0_00 (mix_i_src_c006_0_00 mix_i_c006_0 win_0_00 0) relay vt1=-1m vt2=1m ropen=ropen_mix rclosed=rclosed_mix
EMIXQ_c006_0_00 (mix_q_src_c006_0_00 0 bpf_c006_0 0) vcvs gain=1.950903220161e-01
SMIXQ_c006_0_00 (mix_q_src_c006_0_00 mix_q_c006_0 win_0_00 0) relay vt1=-1m vt2=1m ropen=ropen_mix rclosed=rclosed_mix
EMIXI_c006_0_01 (mix_i_src_c006_0_01 0 bpf_c006_0 0) vcvs gain=8.314696123025e-01
SMIXI_c006_0_01 (mix_i_src_c006_0_01 mix_i_c006_0 win_0_01 0) relay vt1=-1m vt2=1m ropen=ropen_mix rclosed=rclosed_mix
EMIXQ_c006_0_01 (mix_q_src_c006_0_01 0 bpf_c006_0 0) vcvs gain=5.555702330196e-01
SMIXQ_c006_0_01 (mix_q_src_c006_0_01 mix_q_c006_0 win_0_01 0) relay vt1=-1m vt2=1m ropen=ropen_mix rclosed=rclosed_mix
EMIXI_c006_0_02 (mix_i_src_c006_0_02 0 bpf_c006_0 0) vcvs gain=5.555702330196e-01
SMIXI_c006_0_02 (mix_i_src_c006_0_02 mix_i_c006_0 win_0_02 0) relay vt1=-1m vt2=1m ropen=ropen_mix rclosed=rclosed_mix
EMIXQ_c006_0_02 (mix_q_src_c006_0_02 0 bpf_c006_0 0) vcvs gain=8.314696123025e-01
SMIXQ_c006_0_02 (mix_q_src_c006_0_02 mix_q_c006_0 win_0_02 0) relay vt1=-1m vt2=1m ropen=ropen_mix rclosed=rclosed_mix
EMIXI_c006_0_03 (mix_i_src_c006_0_03 0 bpf_c006_0 0) vcvs gain=1.950903220161e-01
SMIXI_c006_0_03 (mix_i_src_c006_0_03 mix_i_c006_0 win_0_03 0) relay vt1=-1m vt2=1m ropen=ropen_mix rclosed=rclosed_mix
EMIXQ_c006_0_03 (mix_q_src_c006_0_03 0 bpf_c006_0 0) vcvs gain=9.807852804032e-01
SMIXQ_c006_0_03 (mix_q_src_c006_0_03 mix_q_c006_0 win_0_03 0) relay vt1=-1m vt2=1m ropen=ropen_mix rclosed=rclosed_mix
EMIXI_c006_0_04 (mix_i_src_c006_0_04 0 bpf_c006_0 0) vcvs gain=-1.950903220161e-01
SMIXI_c006_0_04 (mix_i_src_c006_0_04 mix_i_c006_0 win_0_04 0) relay vt1=-1m vt2=1m ropen=ropen_mix rclosed=rclosed_mix
EMIXQ_c006_0_04 (mix_q_src_c006_0_04 0 bpf_c006_0 0) vcvs gain=9.807852804032e-01
SMIXQ_c006_0_04 (mix_q_src_c006_0_04 mix_q_c006_0 win_0_04 0) relay vt1=-1m vt2=1m ropen=ropen_mix rclosed=rclosed_mix
EMIXI_c006_0_05 (mix_i_src_c006_0_05 0 bpf_c006_0 0) vcvs gain=-5.555702330196e-01
SMIXI_c006_0_05 (mix_i_src_c006_0_05 mix_i_c006_0 win_0_05 0) relay vt1=-1m vt2=1m ropen=ropen_mix rclosed=rclosed_mix
EMIXQ_c006_0_05 (mix_q_src_c006_0_05 0 bpf_c006_0 0) vcvs gain=8.314696123025e-01
SMIXQ_c006_0_05 (mix_q_src_c006_0_05 mix_q_c006_0 win_0_05 0) relay vt1=-1m vt2=1m ropen=ropen_mix rclosed=rclosed_mix
EMIXI_c006_0_06 (mix_i_src_c006_0_06 0 bpf_c006_0 0) vcvs gain=-8.314696123025e-01
SMIXI_c006_0_06 (mix_i_src_c006_0_06 mix_i_c006_0 win_0_06 0) relay vt1=-1m vt2=1m ropen=ropen_mix rclosed=rclosed_mix
EMIXQ_c006_0_06 (mix_q_src_c006_0_06 0 bpf_c006_0 0) vcvs gain=5.555702330196e-01
SMIXQ_c006_0_06 (mix_q_src_c006_0_06 mix_q_c006_0 win_0_06 0) relay vt1=-1m vt2=1m ropen=ropen_mix rclosed=rclosed_mix
EMIXI_c006_0_07 (mix_i_src_c006_0_07 0 bpf_c006_0 0) vcvs gain=-9.807852804032e-01
SMIXI_c006_0_07 (mix_i_src_c006_0_07 mix_i_c006_0 win_0_07 0) relay vt1=-1m vt2=1m ropen=ropen_mix rclosed=rclosed_mix
EMIXQ_c006_0_07 (mix_q_src_c006_0_07 0 bpf_c006_0 0) vcvs gain=1.950903220161e-01
SMIXQ_c006_0_07 (mix_q_src_c006_0_07 mix_q_c006_0 win_0_07 0) relay vt1=-1m vt2=1m ropen=ropen_mix rclosed=rclosed_mix
EMIXI_c006_0_08 (mix_i_src_c006_0_08 0 bpf_c006_0 0) vcvs gain=-9.807852804032e-01
SMIXI_c006_0_08 (mix_i_src_c006_0_08 mix_i_c006_0 win_0_08 0) relay vt1=-1m vt2=1m ropen=ropen_mix rclosed=rclosed_mix
EMIXQ_c006_0_08 (mix_q_src_c006_0_08 0 bpf_c006_0 0) vcvs gain=-1.950903220161e-01
SMIXQ_c006_0_08 (mix_q_src_c006_0_08 mix_q_c006_0 win_0_08 0) relay vt1=-1m vt2=1m ropen=ropen_mix rclosed=rclosed_mix
EMIXI_c006_0_09 (mix_i_src_c006_0_09 0 bpf_c006_0 0) vcvs gain=-8.314696123025e-01
SMIXI_c006_0_09 (mix_i_src_c006_0_09 mix_i_c006_0 win_0_09 0) relay vt1=-1m vt2=1m ropen=ropen_mix rclosed=rclosed_mix
EMIXQ_c006_0_09 (mix_q_src_c006_0_09 0 bpf_c006_0 0) vcvs gain=-5.555702330196e-01
SMIXQ_c006_0_09 (mix_q_src_c006_0_09 mix_q_c006_0 win_0_09 0) relay vt1=-1m vt2=1m ropen=ropen_mix rclosed=rclosed_mix
EMIXI_c006_0_10 (mix_i_src_c006_0_10 0 bpf_c006_0 0) vcvs gain=-5.555702330196e-01
SMIXI_c006_0_10 (mix_i_src_c006_0_10 mix_i_c006_0 win_0_10 0) relay vt1=-1m vt2=1m ropen=ropen_mix rclosed=rclosed_mix
EMIXQ_c006_0_10 (mix_q_src_c006_0_10 0 bpf_c006_0 0) vcvs gain=-8.314696123025e-01
SMIXQ_c006_0_10 (mix_q_src_c006_0_10 mix_q_c006_0 win_0_10 0) relay vt1=-1m vt2=1m ropen=ropen_mix rclosed=rclosed_mix
EMIXI_c006_0_11 (mix_i_src_c006_0_11 0 bpf_c006_0 0) vcvs gain=-1.950903220161e-01
SMIXI_c006_0_11 (mix_i_src_c006_0_11 mix_i_c006_0 win_0_11 0) relay vt1=-1m vt2=1m ropen=ropen_mix rclosed=rclosed_mix
EMIXQ_c006_0_11 (mix_q_src_c006_0_11 0 bpf_c006_0 0) vcvs gain=-9.807852804032e-01
SMIXQ_c006_0_11 (mix_q_src_c006_0_11 mix_q_c006_0 win_0_11 0) relay vt1=-1m vt2=1m ropen=ropen_mix rclosed=rclosed_mix
EMIXI_c006_0_12 (mix_i_src_c006_0_12 0 bpf_c006_0 0) vcvs gain=1.950903220161e-01
SMIXI_c006_0_12 (mix_i_src_c006_0_12 mix_i_c006_0 win_0_12 0) relay vt1=-1m vt2=1m ropen=ropen_mix rclosed=rclosed_mix
EMIXQ_c006_0_12 (mix_q_src_c006_0_12 0 bpf_c006_0 0) vcvs gain=-9.807852804032e-01
SMIXQ_c006_0_12 (mix_q_src_c006_0_12 mix_q_c006_0 win_0_12 0) relay vt1=-1m vt2=1m ropen=ropen_mix rclosed=rclosed_mix
EMIXI_c006_0_13 (mix_i_src_c006_0_13 0 bpf_c006_0 0) vcvs gain=5.555702330196e-01
SMIXI_c006_0_13 (mix_i_src_c006_0_13 mix_i_c006_0 win_0_13 0) relay vt1=-1m vt2=1m ropen=ropen_mix rclosed=rclosed_mix
EMIXQ_c006_0_13 (mix_q_src_c006_0_13 0 bpf_c006_0 0) vcvs gain=-8.314696123025e-01
SMIXQ_c006_0_13 (mix_q_src_c006_0_13 mix_q_c006_0 win_0_13 0) relay vt1=-1m vt2=1m ropen=ropen_mix rclosed=rclosed_mix
EMIXI_c006_0_14 (mix_i_src_c006_0_14 0 bpf_c006_0 0) vcvs gain=8.314696123025e-01
SMIXI_c006_0_14 (mix_i_src_c006_0_14 mix_i_c006_0 win_0_14 0) relay vt1=-1m vt2=1m ropen=ropen_mix rclosed=rclosed_mix
EMIXQ_c006_0_14 (mix_q_src_c006_0_14 0 bpf_c006_0 0) vcvs gain=-5.555702330196e-01
SMIXQ_c006_0_14 (mix_q_src_c006_0_14 mix_q_c006_0 win_0_14 0) relay vt1=-1m vt2=1m ropen=ropen_mix rclosed=rclosed_mix
EMIXI_c006_0_15 (mix_i_src_c006_0_15 0 bpf_c006_0 0) vcvs gain=9.807852804032e-01
SMIXI_c006_0_15 (mix_i_src_c006_0_15 mix_i_c006_0 win_0_15 0) relay vt1=-1m vt2=1m ropen=ropen_mix rclosed=rclosed_mix
EMIXQ_c006_0_15 (mix_q_src_c006_0_15 0 bpf_c006_0 0) vcvs gain=-1.950903220161e-01
SMIXQ_c006_0_15 (mix_q_src_c006_0_15 mix_q_c006_0 win_0_15 0) relay vt1=-1m vt2=1m ropen=ropen_mix rclosed=rclosed_mix
RMIXI_c006_0 (mix_i_c006_0 0) resistor r=1G
RMIXQ_c006_0 (mix_q_c006_0 0) resistor r=1G
RINTI_c006_0 (mix_i_c006_0 Icar_c006_0) resistor r=1k
CINTI_c006_0 (Icar_c006_0 0) capacitor c=80p
RINTQ_c006_0 (mix_q_c006_0 Qcar_c006_0) resistor r=1k
CINTQ_c006_0 (Qcar_c006_0 0) capacitor c=80p
save bpf_c006_0 Icar_c006_0 Qcar_c006_0

// bl006, carrier_1: 500000000 Hz coherent I/Q phase-window verification-demod path
CBPF_c006_1 (bl006 n_cbpf_c006_1) capacitor c=1.013211836423e-13
LBPF_c006_1 (n_cbpf_c006_1 bpf_c006_1) inductor l=1.000000000000e-06
RBPF_c006_1 (bpf_c006_1 0) resistor r=1.570796326795e+02
EMIXI_c006_1_00 (mix_i_src_c006_1_00 0 bpf_c006_1 0) vcvs gain=9.807852804032e-01
SMIXI_c006_1_00 (mix_i_src_c006_1_00 mix_i_c006_1 win_1_00 0) relay vt1=-1m vt2=1m ropen=ropen_mix rclosed=rclosed_mix
EMIXQ_c006_1_00 (mix_q_src_c006_1_00 0 bpf_c006_1 0) vcvs gain=1.950903220161e-01
SMIXQ_c006_1_00 (mix_q_src_c006_1_00 mix_q_c006_1 win_1_00 0) relay vt1=-1m vt2=1m ropen=ropen_mix rclosed=rclosed_mix
EMIXI_c006_1_01 (mix_i_src_c006_1_01 0 bpf_c006_1 0) vcvs gain=8.314696123025e-01
SMIXI_c006_1_01 (mix_i_src_c006_1_01 mix_i_c006_1 win_1_01 0) relay vt1=-1m vt2=1m ropen=ropen_mix rclosed=rclosed_mix
EMIXQ_c006_1_01 (mix_q_src_c006_1_01 0 bpf_c006_1 0) vcvs gain=5.555702330196e-01
SMIXQ_c006_1_01 (mix_q_src_c006_1_01 mix_q_c006_1 win_1_01 0) relay vt1=-1m vt2=1m ropen=ropen_mix rclosed=rclosed_mix
EMIXI_c006_1_02 (mix_i_src_c006_1_02 0 bpf_c006_1 0) vcvs gain=5.555702330196e-01
SMIXI_c006_1_02 (mix_i_src_c006_1_02 mix_i_c006_1 win_1_02 0) relay vt1=-1m vt2=1m ropen=ropen_mix rclosed=rclosed_mix
EMIXQ_c006_1_02 (mix_q_src_c006_1_02 0 bpf_c006_1 0) vcvs gain=8.314696123025e-01
SMIXQ_c006_1_02 (mix_q_src_c006_1_02 mix_q_c006_1 win_1_02 0) relay vt1=-1m vt2=1m ropen=ropen_mix rclosed=rclosed_mix
EMIXI_c006_1_03 (mix_i_src_c006_1_03 0 bpf_c006_1 0) vcvs gain=1.950903220161e-01
SMIXI_c006_1_03 (mix_i_src_c006_1_03 mix_i_c006_1 win_1_03 0) relay vt1=-1m vt2=1m ropen=ropen_mix rclosed=rclosed_mix
EMIXQ_c006_1_03 (mix_q_src_c006_1_03 0 bpf_c006_1 0) vcvs gain=9.807852804032e-01
SMIXQ_c006_1_03 (mix_q_src_c006_1_03 mix_q_c006_1 win_1_03 0) relay vt1=-1m vt2=1m ropen=ropen_mix rclosed=rclosed_mix
EMIXI_c006_1_04 (mix_i_src_c006_1_04 0 bpf_c006_1 0) vcvs gain=-1.950903220161e-01
SMIXI_c006_1_04 (mix_i_src_c006_1_04 mix_i_c006_1 win_1_04 0) relay vt1=-1m vt2=1m ropen=ropen_mix rclosed=rclosed_mix
EMIXQ_c006_1_04 (mix_q_src_c006_1_04 0 bpf_c006_1 0) vcvs gain=9.807852804032e-01
SMIXQ_c006_1_04 (mix_q_src_c006_1_04 mix_q_c006_1 win_1_04 0) relay vt1=-1m vt2=1m ropen=ropen_mix rclosed=rclosed_mix
EMIXI_c006_1_05 (mix_i_src_c006_1_05 0 bpf_c006_1 0) vcvs gain=-5.555702330196e-01
SMIXI_c006_1_05 (mix_i_src_c006_1_05 mix_i_c006_1 win_1_05 0) relay vt1=-1m vt2=1m ropen=ropen_mix rclosed=rclosed_mix
EMIXQ_c006_1_05 (mix_q_src_c006_1_05 0 bpf_c006_1 0) vcvs gain=8.314696123025e-01
SMIXQ_c006_1_05 (mix_q_src_c006_1_05 mix_q_c006_1 win_1_05 0) relay vt1=-1m vt2=1m ropen=ropen_mix rclosed=rclosed_mix
EMIXI_c006_1_06 (mix_i_src_c006_1_06 0 bpf_c006_1 0) vcvs gain=-8.314696123025e-01
SMIXI_c006_1_06 (mix_i_src_c006_1_06 mix_i_c006_1 win_1_06 0) relay vt1=-1m vt2=1m ropen=ropen_mix rclosed=rclosed_mix
EMIXQ_c006_1_06 (mix_q_src_c006_1_06 0 bpf_c006_1 0) vcvs gain=5.555702330196e-01
SMIXQ_c006_1_06 (mix_q_src_c006_1_06 mix_q_c006_1 win_1_06 0) relay vt1=-1m vt2=1m ropen=ropen_mix rclosed=rclosed_mix
EMIXI_c006_1_07 (mix_i_src_c006_1_07 0 bpf_c006_1 0) vcvs gain=-9.807852804032e-01
SMIXI_c006_1_07 (mix_i_src_c006_1_07 mix_i_c006_1 win_1_07 0) relay vt1=-1m vt2=1m ropen=ropen_mix rclosed=rclosed_mix
EMIXQ_c006_1_07 (mix_q_src_c006_1_07 0 bpf_c006_1 0) vcvs gain=1.950903220161e-01
SMIXQ_c006_1_07 (mix_q_src_c006_1_07 mix_q_c006_1 win_1_07 0) relay vt1=-1m vt2=1m ropen=ropen_mix rclosed=rclosed_mix
EMIXI_c006_1_08 (mix_i_src_c006_1_08 0 bpf_c006_1 0) vcvs gain=-9.807852804032e-01
SMIXI_c006_1_08 (mix_i_src_c006_1_08 mix_i_c006_1 win_1_08 0) relay vt1=-1m vt2=1m ropen=ropen_mix rclosed=rclosed_mix
EMIXQ_c006_1_08 (mix_q_src_c006_1_08 0 bpf_c006_1 0) vcvs gain=-1.950903220161e-01
SMIXQ_c006_1_08 (mix_q_src_c006_1_08 mix_q_c006_1 win_1_08 0) relay vt1=-1m vt2=1m ropen=ropen_mix rclosed=rclosed_mix
EMIXI_c006_1_09 (mix_i_src_c006_1_09 0 bpf_c006_1 0) vcvs gain=-8.314696123025e-01
SMIXI_c006_1_09 (mix_i_src_c006_1_09 mix_i_c006_1 win_1_09 0) relay vt1=-1m vt2=1m ropen=ropen_mix rclosed=rclosed_mix
EMIXQ_c006_1_09 (mix_q_src_c006_1_09 0 bpf_c006_1 0) vcvs gain=-5.555702330196e-01
SMIXQ_c006_1_09 (mix_q_src_c006_1_09 mix_q_c006_1 win_1_09 0) relay vt1=-1m vt2=1m ropen=ropen_mix rclosed=rclosed_mix
EMIXI_c006_1_10 (mix_i_src_c006_1_10 0 bpf_c006_1 0) vcvs gain=-5.555702330196e-01
SMIXI_c006_1_10 (mix_i_src_c006_1_10 mix_i_c006_1 win_1_10 0) relay vt1=-1m vt2=1m ropen=ropen_mix rclosed=rclosed_mix
EMIXQ_c006_1_10 (mix_q_src_c006_1_10 0 bpf_c006_1 0) vcvs gain=-8.314696123025e-01
SMIXQ_c006_1_10 (mix_q_src_c006_1_10 mix_q_c006_1 win_1_10 0) relay vt1=-1m vt2=1m ropen=ropen_mix rclosed=rclosed_mix
EMIXI_c006_1_11 (mix_i_src_c006_1_11 0 bpf_c006_1 0) vcvs gain=-1.950903220161e-01
SMIXI_c006_1_11 (mix_i_src_c006_1_11 mix_i_c006_1 win_1_11 0) relay vt1=-1m vt2=1m ropen=ropen_mix rclosed=rclosed_mix
EMIXQ_c006_1_11 (mix_q_src_c006_1_11 0 bpf_c006_1 0) vcvs gain=-9.807852804032e-01
SMIXQ_c006_1_11 (mix_q_src_c006_1_11 mix_q_c006_1 win_1_11 0) relay vt1=-1m vt2=1m ropen=ropen_mix rclosed=rclosed_mix
EMIXI_c006_1_12 (mix_i_src_c006_1_12 0 bpf_c006_1 0) vcvs gain=1.950903220161e-01
SMIXI_c006_1_12 (mix_i_src_c006_1_12 mix_i_c006_1 win_1_12 0) relay vt1=-1m vt2=1m ropen=ropen_mix rclosed=rclosed_mix
EMIXQ_c006_1_12 (mix_q_src_c006_1_12 0 bpf_c006_1 0) vcvs gain=-9.807852804032e-01
SMIXQ_c006_1_12 (mix_q_src_c006_1_12 mix_q_c006_1 win_1_12 0) relay vt1=-1m vt2=1m ropen=ropen_mix rclosed=rclosed_mix
EMIXI_c006_1_13 (mix_i_src_c006_1_13 0 bpf_c006_1 0) vcvs gain=5.555702330196e-01
SMIXI_c006_1_13 (mix_i_src_c006_1_13 mix_i_c006_1 win_1_13 0) relay vt1=-1m vt2=1m ropen=ropen_mix rclosed=rclosed_mix
EMIXQ_c006_1_13 (mix_q_src_c006_1_13 0 bpf_c006_1 0) vcvs gain=-8.314696123025e-01
SMIXQ_c006_1_13 (mix_q_src_c006_1_13 mix_q_c006_1 win_1_13 0) relay vt1=-1m vt2=1m ropen=ropen_mix rclosed=rclosed_mix
EMIXI_c006_1_14 (mix_i_src_c006_1_14 0 bpf_c006_1 0) vcvs gain=8.314696123025e-01
SMIXI_c006_1_14 (mix_i_src_c006_1_14 mix_i_c006_1 win_1_14 0) relay vt1=-1m vt2=1m ropen=ropen_mix rclosed=rclosed_mix
EMIXQ_c006_1_14 (mix_q_src_c006_1_14 0 bpf_c006_1 0) vcvs gain=-5.555702330196e-01
SMIXQ_c006_1_14 (mix_q_src_c006_1_14 mix_q_c006_1 win_1_14 0) relay vt1=-1m vt2=1m ropen=ropen_mix rclosed=rclosed_mix
EMIXI_c006_1_15 (mix_i_src_c006_1_15 0 bpf_c006_1 0) vcvs gain=9.807852804032e-01
SMIXI_c006_1_15 (mix_i_src_c006_1_15 mix_i_c006_1 win_1_15 0) relay vt1=-1m vt2=1m ropen=ropen_mix rclosed=rclosed_mix
EMIXQ_c006_1_15 (mix_q_src_c006_1_15 0 bpf_c006_1 0) vcvs gain=-1.950903220161e-01
SMIXQ_c006_1_15 (mix_q_src_c006_1_15 mix_q_c006_1 win_1_15 0) relay vt1=-1m vt2=1m ropen=ropen_mix rclosed=rclosed_mix
RMIXI_c006_1 (mix_i_c006_1 0) resistor r=1G
RMIXQ_c006_1 (mix_q_c006_1 0) resistor r=1G
RINTI_c006_1 (mix_i_c006_1 Icar_c006_1) resistor r=1k
CINTI_c006_1 (Icar_c006_1 0) capacitor c=80p
RINTQ_c006_1 (mix_q_c006_1 Qcar_c006_1) resistor r=1k
CINTQ_c006_1 (Qcar_c006_1 0) capacitor c=80p
save bpf_c006_1 Icar_c006_1 Qcar_c006_1

// bl006, carrier_2: 750000000 Hz coherent I/Q phase-window verification-demod path
CBPF_c006_2 (bl006 n_cbpf_c006_2) capacitor c=4.503163717437e-14
LBPF_c006_2 (n_cbpf_c006_2 bpf_c006_2) inductor l=1.000000000000e-06
RBPF_c006_2 (bpf_c006_2 0) resistor r=2.356194490192e+02
EMIXI_c006_2_00 (mix_i_src_c006_2_00 0 bpf_c006_2 0) vcvs gain=9.807852804032e-01
SMIXI_c006_2_00 (mix_i_src_c006_2_00 mix_i_c006_2 win_2_00 0) relay vt1=-1m vt2=1m ropen=ropen_mix rclosed=rclosed_mix
EMIXQ_c006_2_00 (mix_q_src_c006_2_00 0 bpf_c006_2 0) vcvs gain=1.950903220161e-01
SMIXQ_c006_2_00 (mix_q_src_c006_2_00 mix_q_c006_2 win_2_00 0) relay vt1=-1m vt2=1m ropen=ropen_mix rclosed=rclosed_mix
EMIXI_c006_2_01 (mix_i_src_c006_2_01 0 bpf_c006_2 0) vcvs gain=8.314696123025e-01
SMIXI_c006_2_01 (mix_i_src_c006_2_01 mix_i_c006_2 win_2_01 0) relay vt1=-1m vt2=1m ropen=ropen_mix rclosed=rclosed_mix
EMIXQ_c006_2_01 (mix_q_src_c006_2_01 0 bpf_c006_2 0) vcvs gain=5.555702330196e-01
SMIXQ_c006_2_01 (mix_q_src_c006_2_01 mix_q_c006_2 win_2_01 0) relay vt1=-1m vt2=1m ropen=ropen_mix rclosed=rclosed_mix
EMIXI_c006_2_02 (mix_i_src_c006_2_02 0 bpf_c006_2 0) vcvs gain=5.555702330196e-01
SMIXI_c006_2_02 (mix_i_src_c006_2_02 mix_i_c006_2 win_2_02 0) relay vt1=-1m vt2=1m ropen=ropen_mix rclosed=rclosed_mix
EMIXQ_c006_2_02 (mix_q_src_c006_2_02 0 bpf_c006_2 0) vcvs gain=8.314696123025e-01
SMIXQ_c006_2_02 (mix_q_src_c006_2_02 mix_q_c006_2 win_2_02 0) relay vt1=-1m vt2=1m ropen=ropen_mix rclosed=rclosed_mix
EMIXI_c006_2_03 (mix_i_src_c006_2_03 0 bpf_c006_2 0) vcvs gain=1.950903220161e-01
SMIXI_c006_2_03 (mix_i_src_c006_2_03 mix_i_c006_2 win_2_03 0) relay vt1=-1m vt2=1m ropen=ropen_mix rclosed=rclosed_mix
EMIXQ_c006_2_03 (mix_q_src_c006_2_03 0 bpf_c006_2 0) vcvs gain=9.807852804032e-01
SMIXQ_c006_2_03 (mix_q_src_c006_2_03 mix_q_c006_2 win_2_03 0) relay vt1=-1m vt2=1m ropen=ropen_mix rclosed=rclosed_mix
EMIXI_c006_2_04 (mix_i_src_c006_2_04 0 bpf_c006_2 0) vcvs gain=-1.950903220161e-01
SMIXI_c006_2_04 (mix_i_src_c006_2_04 mix_i_c006_2 win_2_04 0) relay vt1=-1m vt2=1m ropen=ropen_mix rclosed=rclosed_mix
EMIXQ_c006_2_04 (mix_q_src_c006_2_04 0 bpf_c006_2 0) vcvs gain=9.807852804032e-01
SMIXQ_c006_2_04 (mix_q_src_c006_2_04 mix_q_c006_2 win_2_04 0) relay vt1=-1m vt2=1m ropen=ropen_mix rclosed=rclosed_mix
EMIXI_c006_2_05 (mix_i_src_c006_2_05 0 bpf_c006_2 0) vcvs gain=-5.555702330196e-01
SMIXI_c006_2_05 (mix_i_src_c006_2_05 mix_i_c006_2 win_2_05 0) relay vt1=-1m vt2=1m ropen=ropen_mix rclosed=rclosed_mix
EMIXQ_c006_2_05 (mix_q_src_c006_2_05 0 bpf_c006_2 0) vcvs gain=8.314696123025e-01
SMIXQ_c006_2_05 (mix_q_src_c006_2_05 mix_q_c006_2 win_2_05 0) relay vt1=-1m vt2=1m ropen=ropen_mix rclosed=rclosed_mix
EMIXI_c006_2_06 (mix_i_src_c006_2_06 0 bpf_c006_2 0) vcvs gain=-8.314696123025e-01
SMIXI_c006_2_06 (mix_i_src_c006_2_06 mix_i_c006_2 win_2_06 0) relay vt1=-1m vt2=1m ropen=ropen_mix rclosed=rclosed_mix
EMIXQ_c006_2_06 (mix_q_src_c006_2_06 0 bpf_c006_2 0) vcvs gain=5.555702330196e-01
SMIXQ_c006_2_06 (mix_q_src_c006_2_06 mix_q_c006_2 win_2_06 0) relay vt1=-1m vt2=1m ropen=ropen_mix rclosed=rclosed_mix
EMIXI_c006_2_07 (mix_i_src_c006_2_07 0 bpf_c006_2 0) vcvs gain=-9.807852804032e-01
SMIXI_c006_2_07 (mix_i_src_c006_2_07 mix_i_c006_2 win_2_07 0) relay vt1=-1m vt2=1m ropen=ropen_mix rclosed=rclosed_mix
EMIXQ_c006_2_07 (mix_q_src_c006_2_07 0 bpf_c006_2 0) vcvs gain=1.950903220161e-01
SMIXQ_c006_2_07 (mix_q_src_c006_2_07 mix_q_c006_2 win_2_07 0) relay vt1=-1m vt2=1m ropen=ropen_mix rclosed=rclosed_mix
EMIXI_c006_2_08 (mix_i_src_c006_2_08 0 bpf_c006_2 0) vcvs gain=-9.807852804032e-01
SMIXI_c006_2_08 (mix_i_src_c006_2_08 mix_i_c006_2 win_2_08 0) relay vt1=-1m vt2=1m ropen=ropen_mix rclosed=rclosed_mix
EMIXQ_c006_2_08 (mix_q_src_c006_2_08 0 bpf_c006_2 0) vcvs gain=-1.950903220161e-01
SMIXQ_c006_2_08 (mix_q_src_c006_2_08 mix_q_c006_2 win_2_08 0) relay vt1=-1m vt2=1m ropen=ropen_mix rclosed=rclosed_mix
EMIXI_c006_2_09 (mix_i_src_c006_2_09 0 bpf_c006_2 0) vcvs gain=-8.314696123025e-01
SMIXI_c006_2_09 (mix_i_src_c006_2_09 mix_i_c006_2 win_2_09 0) relay vt1=-1m vt2=1m ropen=ropen_mix rclosed=rclosed_mix
EMIXQ_c006_2_09 (mix_q_src_c006_2_09 0 bpf_c006_2 0) vcvs gain=-5.555702330196e-01
SMIXQ_c006_2_09 (mix_q_src_c006_2_09 mix_q_c006_2 win_2_09 0) relay vt1=-1m vt2=1m ropen=ropen_mix rclosed=rclosed_mix
EMIXI_c006_2_10 (mix_i_src_c006_2_10 0 bpf_c006_2 0) vcvs gain=-5.555702330196e-01
SMIXI_c006_2_10 (mix_i_src_c006_2_10 mix_i_c006_2 win_2_10 0) relay vt1=-1m vt2=1m ropen=ropen_mix rclosed=rclosed_mix
EMIXQ_c006_2_10 (mix_q_src_c006_2_10 0 bpf_c006_2 0) vcvs gain=-8.314696123025e-01
SMIXQ_c006_2_10 (mix_q_src_c006_2_10 mix_q_c006_2 win_2_10 0) relay vt1=-1m vt2=1m ropen=ropen_mix rclosed=rclosed_mix
EMIXI_c006_2_11 (mix_i_src_c006_2_11 0 bpf_c006_2 0) vcvs gain=-1.950903220161e-01
SMIXI_c006_2_11 (mix_i_src_c006_2_11 mix_i_c006_2 win_2_11 0) relay vt1=-1m vt2=1m ropen=ropen_mix rclosed=rclosed_mix
EMIXQ_c006_2_11 (mix_q_src_c006_2_11 0 bpf_c006_2 0) vcvs gain=-9.807852804032e-01
SMIXQ_c006_2_11 (mix_q_src_c006_2_11 mix_q_c006_2 win_2_11 0) relay vt1=-1m vt2=1m ropen=ropen_mix rclosed=rclosed_mix
EMIXI_c006_2_12 (mix_i_src_c006_2_12 0 bpf_c006_2 0) vcvs gain=1.950903220161e-01
SMIXI_c006_2_12 (mix_i_src_c006_2_12 mix_i_c006_2 win_2_12 0) relay vt1=-1m vt2=1m ropen=ropen_mix rclosed=rclosed_mix
EMIXQ_c006_2_12 (mix_q_src_c006_2_12 0 bpf_c006_2 0) vcvs gain=-9.807852804032e-01
SMIXQ_c006_2_12 (mix_q_src_c006_2_12 mix_q_c006_2 win_2_12 0) relay vt1=-1m vt2=1m ropen=ropen_mix rclosed=rclosed_mix
EMIXI_c006_2_13 (mix_i_src_c006_2_13 0 bpf_c006_2 0) vcvs gain=5.555702330196e-01
SMIXI_c006_2_13 (mix_i_src_c006_2_13 mix_i_c006_2 win_2_13 0) relay vt1=-1m vt2=1m ropen=ropen_mix rclosed=rclosed_mix
EMIXQ_c006_2_13 (mix_q_src_c006_2_13 0 bpf_c006_2 0) vcvs gain=-8.314696123025e-01
SMIXQ_c006_2_13 (mix_q_src_c006_2_13 mix_q_c006_2 win_2_13 0) relay vt1=-1m vt2=1m ropen=ropen_mix rclosed=rclosed_mix
EMIXI_c006_2_14 (mix_i_src_c006_2_14 0 bpf_c006_2 0) vcvs gain=8.314696123025e-01
SMIXI_c006_2_14 (mix_i_src_c006_2_14 mix_i_c006_2 win_2_14 0) relay vt1=-1m vt2=1m ropen=ropen_mix rclosed=rclosed_mix
EMIXQ_c006_2_14 (mix_q_src_c006_2_14 0 bpf_c006_2 0) vcvs gain=-5.555702330196e-01
SMIXQ_c006_2_14 (mix_q_src_c006_2_14 mix_q_c006_2 win_2_14 0) relay vt1=-1m vt2=1m ropen=ropen_mix rclosed=rclosed_mix
EMIXI_c006_2_15 (mix_i_src_c006_2_15 0 bpf_c006_2 0) vcvs gain=9.807852804032e-01
SMIXI_c006_2_15 (mix_i_src_c006_2_15 mix_i_c006_2 win_2_15 0) relay vt1=-1m vt2=1m ropen=ropen_mix rclosed=rclosed_mix
EMIXQ_c006_2_15 (mix_q_src_c006_2_15 0 bpf_c006_2 0) vcvs gain=-1.950903220161e-01
SMIXQ_c006_2_15 (mix_q_src_c006_2_15 mix_q_c006_2 win_2_15 0) relay vt1=-1m vt2=1m ropen=ropen_mix rclosed=rclosed_mix
RMIXI_c006_2 (mix_i_c006_2 0) resistor r=1G
RMIXQ_c006_2 (mix_q_c006_2 0) resistor r=1G
RINTI_c006_2 (mix_i_c006_2 Icar_c006_2) resistor r=1k
CINTI_c006_2 (Icar_c006_2 0) capacitor c=80p
RINTQ_c006_2 (mix_q_c006_2 Qcar_c006_2) resistor r=1k
CINTQ_c006_2 (Qcar_c006_2 0) capacitor c=80p
save bpf_c006_2 Icar_c006_2 Qcar_c006_2

// bl006, carrier_3: 1000000000 Hz coherent I/Q phase-window verification-demod path
CBPF_c006_3 (bl006 n_cbpf_c006_3) capacitor c=2.533029591058e-14
LBPF_c006_3 (n_cbpf_c006_3 bpf_c006_3) inductor l=1.000000000000e-06
RBPF_c006_3 (bpf_c006_3 0) resistor r=3.141592653590e+02
EMIXI_c006_3_00 (mix_i_src_c006_3_00 0 bpf_c006_3 0) vcvs gain=9.807852804032e-01
SMIXI_c006_3_00 (mix_i_src_c006_3_00 mix_i_c006_3 win_3_00 0) relay vt1=-1m vt2=1m ropen=ropen_mix rclosed=rclosed_mix
EMIXQ_c006_3_00 (mix_q_src_c006_3_00 0 bpf_c006_3 0) vcvs gain=1.950903220161e-01
SMIXQ_c006_3_00 (mix_q_src_c006_3_00 mix_q_c006_3 win_3_00 0) relay vt1=-1m vt2=1m ropen=ropen_mix rclosed=rclosed_mix
EMIXI_c006_3_01 (mix_i_src_c006_3_01 0 bpf_c006_3 0) vcvs gain=8.314696123025e-01
SMIXI_c006_3_01 (mix_i_src_c006_3_01 mix_i_c006_3 win_3_01 0) relay vt1=-1m vt2=1m ropen=ropen_mix rclosed=rclosed_mix
EMIXQ_c006_3_01 (mix_q_src_c006_3_01 0 bpf_c006_3 0) vcvs gain=5.555702330196e-01
SMIXQ_c006_3_01 (mix_q_src_c006_3_01 mix_q_c006_3 win_3_01 0) relay vt1=-1m vt2=1m ropen=ropen_mix rclosed=rclosed_mix
EMIXI_c006_3_02 (mix_i_src_c006_3_02 0 bpf_c006_3 0) vcvs gain=5.555702330196e-01
SMIXI_c006_3_02 (mix_i_src_c006_3_02 mix_i_c006_3 win_3_02 0) relay vt1=-1m vt2=1m ropen=ropen_mix rclosed=rclosed_mix
EMIXQ_c006_3_02 (mix_q_src_c006_3_02 0 bpf_c006_3 0) vcvs gain=8.314696123025e-01
SMIXQ_c006_3_02 (mix_q_src_c006_3_02 mix_q_c006_3 win_3_02 0) relay vt1=-1m vt2=1m ropen=ropen_mix rclosed=rclosed_mix
EMIXI_c006_3_03 (mix_i_src_c006_3_03 0 bpf_c006_3 0) vcvs gain=1.950903220161e-01
SMIXI_c006_3_03 (mix_i_src_c006_3_03 mix_i_c006_3 win_3_03 0) relay vt1=-1m vt2=1m ropen=ropen_mix rclosed=rclosed_mix
EMIXQ_c006_3_03 (mix_q_src_c006_3_03 0 bpf_c006_3 0) vcvs gain=9.807852804032e-01
SMIXQ_c006_3_03 (mix_q_src_c006_3_03 mix_q_c006_3 win_3_03 0) relay vt1=-1m vt2=1m ropen=ropen_mix rclosed=rclosed_mix
EMIXI_c006_3_04 (mix_i_src_c006_3_04 0 bpf_c006_3 0) vcvs gain=-1.950903220161e-01
SMIXI_c006_3_04 (mix_i_src_c006_3_04 mix_i_c006_3 win_3_04 0) relay vt1=-1m vt2=1m ropen=ropen_mix rclosed=rclosed_mix
EMIXQ_c006_3_04 (mix_q_src_c006_3_04 0 bpf_c006_3 0) vcvs gain=9.807852804032e-01
SMIXQ_c006_3_04 (mix_q_src_c006_3_04 mix_q_c006_3 win_3_04 0) relay vt1=-1m vt2=1m ropen=ropen_mix rclosed=rclosed_mix
EMIXI_c006_3_05 (mix_i_src_c006_3_05 0 bpf_c006_3 0) vcvs gain=-5.555702330196e-01
SMIXI_c006_3_05 (mix_i_src_c006_3_05 mix_i_c006_3 win_3_05 0) relay vt1=-1m vt2=1m ropen=ropen_mix rclosed=rclosed_mix
EMIXQ_c006_3_05 (mix_q_src_c006_3_05 0 bpf_c006_3 0) vcvs gain=8.314696123025e-01
SMIXQ_c006_3_05 (mix_q_src_c006_3_05 mix_q_c006_3 win_3_05 0) relay vt1=-1m vt2=1m ropen=ropen_mix rclosed=rclosed_mix
EMIXI_c006_3_06 (mix_i_src_c006_3_06 0 bpf_c006_3 0) vcvs gain=-8.314696123025e-01
SMIXI_c006_3_06 (mix_i_src_c006_3_06 mix_i_c006_3 win_3_06 0) relay vt1=-1m vt2=1m ropen=ropen_mix rclosed=rclosed_mix
EMIXQ_c006_3_06 (mix_q_src_c006_3_06 0 bpf_c006_3 0) vcvs gain=5.555702330196e-01
SMIXQ_c006_3_06 (mix_q_src_c006_3_06 mix_q_c006_3 win_3_06 0) relay vt1=-1m vt2=1m ropen=ropen_mix rclosed=rclosed_mix
EMIXI_c006_3_07 (mix_i_src_c006_3_07 0 bpf_c006_3 0) vcvs gain=-9.807852804032e-01
SMIXI_c006_3_07 (mix_i_src_c006_3_07 mix_i_c006_3 win_3_07 0) relay vt1=-1m vt2=1m ropen=ropen_mix rclosed=rclosed_mix
EMIXQ_c006_3_07 (mix_q_src_c006_3_07 0 bpf_c006_3 0) vcvs gain=1.950903220161e-01
SMIXQ_c006_3_07 (mix_q_src_c006_3_07 mix_q_c006_3 win_3_07 0) relay vt1=-1m vt2=1m ropen=ropen_mix rclosed=rclosed_mix
EMIXI_c006_3_08 (mix_i_src_c006_3_08 0 bpf_c006_3 0) vcvs gain=-9.807852804032e-01
SMIXI_c006_3_08 (mix_i_src_c006_3_08 mix_i_c006_3 win_3_08 0) relay vt1=-1m vt2=1m ropen=ropen_mix rclosed=rclosed_mix
EMIXQ_c006_3_08 (mix_q_src_c006_3_08 0 bpf_c006_3 0) vcvs gain=-1.950903220161e-01
SMIXQ_c006_3_08 (mix_q_src_c006_3_08 mix_q_c006_3 win_3_08 0) relay vt1=-1m vt2=1m ropen=ropen_mix rclosed=rclosed_mix
EMIXI_c006_3_09 (mix_i_src_c006_3_09 0 bpf_c006_3 0) vcvs gain=-8.314696123025e-01
SMIXI_c006_3_09 (mix_i_src_c006_3_09 mix_i_c006_3 win_3_09 0) relay vt1=-1m vt2=1m ropen=ropen_mix rclosed=rclosed_mix
EMIXQ_c006_3_09 (mix_q_src_c006_3_09 0 bpf_c006_3 0) vcvs gain=-5.555702330196e-01
SMIXQ_c006_3_09 (mix_q_src_c006_3_09 mix_q_c006_3 win_3_09 0) relay vt1=-1m vt2=1m ropen=ropen_mix rclosed=rclosed_mix
EMIXI_c006_3_10 (mix_i_src_c006_3_10 0 bpf_c006_3 0) vcvs gain=-5.555702330196e-01
SMIXI_c006_3_10 (mix_i_src_c006_3_10 mix_i_c006_3 win_3_10 0) relay vt1=-1m vt2=1m ropen=ropen_mix rclosed=rclosed_mix
EMIXQ_c006_3_10 (mix_q_src_c006_3_10 0 bpf_c006_3 0) vcvs gain=-8.314696123025e-01
SMIXQ_c006_3_10 (mix_q_src_c006_3_10 mix_q_c006_3 win_3_10 0) relay vt1=-1m vt2=1m ropen=ropen_mix rclosed=rclosed_mix
EMIXI_c006_3_11 (mix_i_src_c006_3_11 0 bpf_c006_3 0) vcvs gain=-1.950903220161e-01
SMIXI_c006_3_11 (mix_i_src_c006_3_11 mix_i_c006_3 win_3_11 0) relay vt1=-1m vt2=1m ropen=ropen_mix rclosed=rclosed_mix
EMIXQ_c006_3_11 (mix_q_src_c006_3_11 0 bpf_c006_3 0) vcvs gain=-9.807852804032e-01
SMIXQ_c006_3_11 (mix_q_src_c006_3_11 mix_q_c006_3 win_3_11 0) relay vt1=-1m vt2=1m ropen=ropen_mix rclosed=rclosed_mix
EMIXI_c006_3_12 (mix_i_src_c006_3_12 0 bpf_c006_3 0) vcvs gain=1.950903220161e-01
SMIXI_c006_3_12 (mix_i_src_c006_3_12 mix_i_c006_3 win_3_12 0) relay vt1=-1m vt2=1m ropen=ropen_mix rclosed=rclosed_mix
EMIXQ_c006_3_12 (mix_q_src_c006_3_12 0 bpf_c006_3 0) vcvs gain=-9.807852804032e-01
SMIXQ_c006_3_12 (mix_q_src_c006_3_12 mix_q_c006_3 win_3_12 0) relay vt1=-1m vt2=1m ropen=ropen_mix rclosed=rclosed_mix
EMIXI_c006_3_13 (mix_i_src_c006_3_13 0 bpf_c006_3 0) vcvs gain=5.555702330196e-01
SMIXI_c006_3_13 (mix_i_src_c006_3_13 mix_i_c006_3 win_3_13 0) relay vt1=-1m vt2=1m ropen=ropen_mix rclosed=rclosed_mix
EMIXQ_c006_3_13 (mix_q_src_c006_3_13 0 bpf_c006_3 0) vcvs gain=-8.314696123025e-01
SMIXQ_c006_3_13 (mix_q_src_c006_3_13 mix_q_c006_3 win_3_13 0) relay vt1=-1m vt2=1m ropen=ropen_mix rclosed=rclosed_mix
EMIXI_c006_3_14 (mix_i_src_c006_3_14 0 bpf_c006_3 0) vcvs gain=8.314696123025e-01
SMIXI_c006_3_14 (mix_i_src_c006_3_14 mix_i_c006_3 win_3_14 0) relay vt1=-1m vt2=1m ropen=ropen_mix rclosed=rclosed_mix
EMIXQ_c006_3_14 (mix_q_src_c006_3_14 0 bpf_c006_3 0) vcvs gain=-5.555702330196e-01
SMIXQ_c006_3_14 (mix_q_src_c006_3_14 mix_q_c006_3 win_3_14 0) relay vt1=-1m vt2=1m ropen=ropen_mix rclosed=rclosed_mix
EMIXI_c006_3_15 (mix_i_src_c006_3_15 0 bpf_c006_3 0) vcvs gain=9.807852804032e-01
SMIXI_c006_3_15 (mix_i_src_c006_3_15 mix_i_c006_3 win_3_15 0) relay vt1=-1m vt2=1m ropen=ropen_mix rclosed=rclosed_mix
EMIXQ_c006_3_15 (mix_q_src_c006_3_15 0 bpf_c006_3 0) vcvs gain=-1.950903220161e-01
SMIXQ_c006_3_15 (mix_q_src_c006_3_15 mix_q_c006_3 win_3_15 0) relay vt1=-1m vt2=1m ropen=ropen_mix rclosed=rclosed_mix
RMIXI_c006_3 (mix_i_c006_3 0) resistor r=1G
RMIXQ_c006_3 (mix_q_c006_3 0) resistor r=1G
RINTI_c006_3 (mix_i_c006_3 Icar_c006_3) resistor r=1k
CINTI_c006_3 (Icar_c006_3 0) capacitor c=80p
RINTQ_c006_3 (mix_q_c006_3 Qcar_c006_3) resistor r=1k
CINTQ_c006_3 (Qcar_c006_3 0) capacitor c=80p
save bpf_c006_3 Icar_c006_3 Qcar_c006_3

// bl007, carrier_0: 250000000 Hz coherent I/Q phase-window verification-demod path
CBPF_c007_0 (bl007 n_cbpf_c007_0) capacitor c=4.052847345694e-13
LBPF_c007_0 (n_cbpf_c007_0 bpf_c007_0) inductor l=1.000000000000e-06
RBPF_c007_0 (bpf_c007_0 0) resistor r=7.853981633974e+01
EMIXI_c007_0_00 (mix_i_src_c007_0_00 0 bpf_c007_0 0) vcvs gain=9.807852804032e-01
SMIXI_c007_0_00 (mix_i_src_c007_0_00 mix_i_c007_0 win_0_00 0) relay vt1=-1m vt2=1m ropen=ropen_mix rclosed=rclosed_mix
EMIXQ_c007_0_00 (mix_q_src_c007_0_00 0 bpf_c007_0 0) vcvs gain=1.950903220161e-01
SMIXQ_c007_0_00 (mix_q_src_c007_0_00 mix_q_c007_0 win_0_00 0) relay vt1=-1m vt2=1m ropen=ropen_mix rclosed=rclosed_mix
EMIXI_c007_0_01 (mix_i_src_c007_0_01 0 bpf_c007_0 0) vcvs gain=8.314696123025e-01
SMIXI_c007_0_01 (mix_i_src_c007_0_01 mix_i_c007_0 win_0_01 0) relay vt1=-1m vt2=1m ropen=ropen_mix rclosed=rclosed_mix
EMIXQ_c007_0_01 (mix_q_src_c007_0_01 0 bpf_c007_0 0) vcvs gain=5.555702330196e-01
SMIXQ_c007_0_01 (mix_q_src_c007_0_01 mix_q_c007_0 win_0_01 0) relay vt1=-1m vt2=1m ropen=ropen_mix rclosed=rclosed_mix
EMIXI_c007_0_02 (mix_i_src_c007_0_02 0 bpf_c007_0 0) vcvs gain=5.555702330196e-01
SMIXI_c007_0_02 (mix_i_src_c007_0_02 mix_i_c007_0 win_0_02 0) relay vt1=-1m vt2=1m ropen=ropen_mix rclosed=rclosed_mix
EMIXQ_c007_0_02 (mix_q_src_c007_0_02 0 bpf_c007_0 0) vcvs gain=8.314696123025e-01
SMIXQ_c007_0_02 (mix_q_src_c007_0_02 mix_q_c007_0 win_0_02 0) relay vt1=-1m vt2=1m ropen=ropen_mix rclosed=rclosed_mix
EMIXI_c007_0_03 (mix_i_src_c007_0_03 0 bpf_c007_0 0) vcvs gain=1.950903220161e-01
SMIXI_c007_0_03 (mix_i_src_c007_0_03 mix_i_c007_0 win_0_03 0) relay vt1=-1m vt2=1m ropen=ropen_mix rclosed=rclosed_mix
EMIXQ_c007_0_03 (mix_q_src_c007_0_03 0 bpf_c007_0 0) vcvs gain=9.807852804032e-01
SMIXQ_c007_0_03 (mix_q_src_c007_0_03 mix_q_c007_0 win_0_03 0) relay vt1=-1m vt2=1m ropen=ropen_mix rclosed=rclosed_mix
EMIXI_c007_0_04 (mix_i_src_c007_0_04 0 bpf_c007_0 0) vcvs gain=-1.950903220161e-01
SMIXI_c007_0_04 (mix_i_src_c007_0_04 mix_i_c007_0 win_0_04 0) relay vt1=-1m vt2=1m ropen=ropen_mix rclosed=rclosed_mix
EMIXQ_c007_0_04 (mix_q_src_c007_0_04 0 bpf_c007_0 0) vcvs gain=9.807852804032e-01
SMIXQ_c007_0_04 (mix_q_src_c007_0_04 mix_q_c007_0 win_0_04 0) relay vt1=-1m vt2=1m ropen=ropen_mix rclosed=rclosed_mix
EMIXI_c007_0_05 (mix_i_src_c007_0_05 0 bpf_c007_0 0) vcvs gain=-5.555702330196e-01
SMIXI_c007_0_05 (mix_i_src_c007_0_05 mix_i_c007_0 win_0_05 0) relay vt1=-1m vt2=1m ropen=ropen_mix rclosed=rclosed_mix
EMIXQ_c007_0_05 (mix_q_src_c007_0_05 0 bpf_c007_0 0) vcvs gain=8.314696123025e-01
SMIXQ_c007_0_05 (mix_q_src_c007_0_05 mix_q_c007_0 win_0_05 0) relay vt1=-1m vt2=1m ropen=ropen_mix rclosed=rclosed_mix
EMIXI_c007_0_06 (mix_i_src_c007_0_06 0 bpf_c007_0 0) vcvs gain=-8.314696123025e-01
SMIXI_c007_0_06 (mix_i_src_c007_0_06 mix_i_c007_0 win_0_06 0) relay vt1=-1m vt2=1m ropen=ropen_mix rclosed=rclosed_mix
EMIXQ_c007_0_06 (mix_q_src_c007_0_06 0 bpf_c007_0 0) vcvs gain=5.555702330196e-01
SMIXQ_c007_0_06 (mix_q_src_c007_0_06 mix_q_c007_0 win_0_06 0) relay vt1=-1m vt2=1m ropen=ropen_mix rclosed=rclosed_mix
EMIXI_c007_0_07 (mix_i_src_c007_0_07 0 bpf_c007_0 0) vcvs gain=-9.807852804032e-01
SMIXI_c007_0_07 (mix_i_src_c007_0_07 mix_i_c007_0 win_0_07 0) relay vt1=-1m vt2=1m ropen=ropen_mix rclosed=rclosed_mix
EMIXQ_c007_0_07 (mix_q_src_c007_0_07 0 bpf_c007_0 0) vcvs gain=1.950903220161e-01
SMIXQ_c007_0_07 (mix_q_src_c007_0_07 mix_q_c007_0 win_0_07 0) relay vt1=-1m vt2=1m ropen=ropen_mix rclosed=rclosed_mix
EMIXI_c007_0_08 (mix_i_src_c007_0_08 0 bpf_c007_0 0) vcvs gain=-9.807852804032e-01
SMIXI_c007_0_08 (mix_i_src_c007_0_08 mix_i_c007_0 win_0_08 0) relay vt1=-1m vt2=1m ropen=ropen_mix rclosed=rclosed_mix
EMIXQ_c007_0_08 (mix_q_src_c007_0_08 0 bpf_c007_0 0) vcvs gain=-1.950903220161e-01
SMIXQ_c007_0_08 (mix_q_src_c007_0_08 mix_q_c007_0 win_0_08 0) relay vt1=-1m vt2=1m ropen=ropen_mix rclosed=rclosed_mix
EMIXI_c007_0_09 (mix_i_src_c007_0_09 0 bpf_c007_0 0) vcvs gain=-8.314696123025e-01
SMIXI_c007_0_09 (mix_i_src_c007_0_09 mix_i_c007_0 win_0_09 0) relay vt1=-1m vt2=1m ropen=ropen_mix rclosed=rclosed_mix
EMIXQ_c007_0_09 (mix_q_src_c007_0_09 0 bpf_c007_0 0) vcvs gain=-5.555702330196e-01
SMIXQ_c007_0_09 (mix_q_src_c007_0_09 mix_q_c007_0 win_0_09 0) relay vt1=-1m vt2=1m ropen=ropen_mix rclosed=rclosed_mix
EMIXI_c007_0_10 (mix_i_src_c007_0_10 0 bpf_c007_0 0) vcvs gain=-5.555702330196e-01
SMIXI_c007_0_10 (mix_i_src_c007_0_10 mix_i_c007_0 win_0_10 0) relay vt1=-1m vt2=1m ropen=ropen_mix rclosed=rclosed_mix
EMIXQ_c007_0_10 (mix_q_src_c007_0_10 0 bpf_c007_0 0) vcvs gain=-8.314696123025e-01
SMIXQ_c007_0_10 (mix_q_src_c007_0_10 mix_q_c007_0 win_0_10 0) relay vt1=-1m vt2=1m ropen=ropen_mix rclosed=rclosed_mix
EMIXI_c007_0_11 (mix_i_src_c007_0_11 0 bpf_c007_0 0) vcvs gain=-1.950903220161e-01
SMIXI_c007_0_11 (mix_i_src_c007_0_11 mix_i_c007_0 win_0_11 0) relay vt1=-1m vt2=1m ropen=ropen_mix rclosed=rclosed_mix
EMIXQ_c007_0_11 (mix_q_src_c007_0_11 0 bpf_c007_0 0) vcvs gain=-9.807852804032e-01
SMIXQ_c007_0_11 (mix_q_src_c007_0_11 mix_q_c007_0 win_0_11 0) relay vt1=-1m vt2=1m ropen=ropen_mix rclosed=rclosed_mix
EMIXI_c007_0_12 (mix_i_src_c007_0_12 0 bpf_c007_0 0) vcvs gain=1.950903220161e-01
SMIXI_c007_0_12 (mix_i_src_c007_0_12 mix_i_c007_0 win_0_12 0) relay vt1=-1m vt2=1m ropen=ropen_mix rclosed=rclosed_mix
EMIXQ_c007_0_12 (mix_q_src_c007_0_12 0 bpf_c007_0 0) vcvs gain=-9.807852804032e-01
SMIXQ_c007_0_12 (mix_q_src_c007_0_12 mix_q_c007_0 win_0_12 0) relay vt1=-1m vt2=1m ropen=ropen_mix rclosed=rclosed_mix
EMIXI_c007_0_13 (mix_i_src_c007_0_13 0 bpf_c007_0 0) vcvs gain=5.555702330196e-01
SMIXI_c007_0_13 (mix_i_src_c007_0_13 mix_i_c007_0 win_0_13 0) relay vt1=-1m vt2=1m ropen=ropen_mix rclosed=rclosed_mix
EMIXQ_c007_0_13 (mix_q_src_c007_0_13 0 bpf_c007_0 0) vcvs gain=-8.314696123025e-01
SMIXQ_c007_0_13 (mix_q_src_c007_0_13 mix_q_c007_0 win_0_13 0) relay vt1=-1m vt2=1m ropen=ropen_mix rclosed=rclosed_mix
EMIXI_c007_0_14 (mix_i_src_c007_0_14 0 bpf_c007_0 0) vcvs gain=8.314696123025e-01
SMIXI_c007_0_14 (mix_i_src_c007_0_14 mix_i_c007_0 win_0_14 0) relay vt1=-1m vt2=1m ropen=ropen_mix rclosed=rclosed_mix
EMIXQ_c007_0_14 (mix_q_src_c007_0_14 0 bpf_c007_0 0) vcvs gain=-5.555702330196e-01
SMIXQ_c007_0_14 (mix_q_src_c007_0_14 mix_q_c007_0 win_0_14 0) relay vt1=-1m vt2=1m ropen=ropen_mix rclosed=rclosed_mix
EMIXI_c007_0_15 (mix_i_src_c007_0_15 0 bpf_c007_0 0) vcvs gain=9.807852804032e-01
SMIXI_c007_0_15 (mix_i_src_c007_0_15 mix_i_c007_0 win_0_15 0) relay vt1=-1m vt2=1m ropen=ropen_mix rclosed=rclosed_mix
EMIXQ_c007_0_15 (mix_q_src_c007_0_15 0 bpf_c007_0 0) vcvs gain=-1.950903220161e-01
SMIXQ_c007_0_15 (mix_q_src_c007_0_15 mix_q_c007_0 win_0_15 0) relay vt1=-1m vt2=1m ropen=ropen_mix rclosed=rclosed_mix
RMIXI_c007_0 (mix_i_c007_0 0) resistor r=1G
RMIXQ_c007_0 (mix_q_c007_0 0) resistor r=1G
RINTI_c007_0 (mix_i_c007_0 Icar_c007_0) resistor r=1k
CINTI_c007_0 (Icar_c007_0 0) capacitor c=80p
RINTQ_c007_0 (mix_q_c007_0 Qcar_c007_0) resistor r=1k
CINTQ_c007_0 (Qcar_c007_0 0) capacitor c=80p
save bpf_c007_0 Icar_c007_0 Qcar_c007_0

// bl007, carrier_1: 500000000 Hz coherent I/Q phase-window verification-demod path
CBPF_c007_1 (bl007 n_cbpf_c007_1) capacitor c=1.013211836423e-13
LBPF_c007_1 (n_cbpf_c007_1 bpf_c007_1) inductor l=1.000000000000e-06
RBPF_c007_1 (bpf_c007_1 0) resistor r=1.570796326795e+02
EMIXI_c007_1_00 (mix_i_src_c007_1_00 0 bpf_c007_1 0) vcvs gain=9.807852804032e-01
SMIXI_c007_1_00 (mix_i_src_c007_1_00 mix_i_c007_1 win_1_00 0) relay vt1=-1m vt2=1m ropen=ropen_mix rclosed=rclosed_mix
EMIXQ_c007_1_00 (mix_q_src_c007_1_00 0 bpf_c007_1 0) vcvs gain=1.950903220161e-01
SMIXQ_c007_1_00 (mix_q_src_c007_1_00 mix_q_c007_1 win_1_00 0) relay vt1=-1m vt2=1m ropen=ropen_mix rclosed=rclosed_mix
EMIXI_c007_1_01 (mix_i_src_c007_1_01 0 bpf_c007_1 0) vcvs gain=8.314696123025e-01
SMIXI_c007_1_01 (mix_i_src_c007_1_01 mix_i_c007_1 win_1_01 0) relay vt1=-1m vt2=1m ropen=ropen_mix rclosed=rclosed_mix
EMIXQ_c007_1_01 (mix_q_src_c007_1_01 0 bpf_c007_1 0) vcvs gain=5.555702330196e-01
SMIXQ_c007_1_01 (mix_q_src_c007_1_01 mix_q_c007_1 win_1_01 0) relay vt1=-1m vt2=1m ropen=ropen_mix rclosed=rclosed_mix
EMIXI_c007_1_02 (mix_i_src_c007_1_02 0 bpf_c007_1 0) vcvs gain=5.555702330196e-01
SMIXI_c007_1_02 (mix_i_src_c007_1_02 mix_i_c007_1 win_1_02 0) relay vt1=-1m vt2=1m ropen=ropen_mix rclosed=rclosed_mix
EMIXQ_c007_1_02 (mix_q_src_c007_1_02 0 bpf_c007_1 0) vcvs gain=8.314696123025e-01
SMIXQ_c007_1_02 (mix_q_src_c007_1_02 mix_q_c007_1 win_1_02 0) relay vt1=-1m vt2=1m ropen=ropen_mix rclosed=rclosed_mix
EMIXI_c007_1_03 (mix_i_src_c007_1_03 0 bpf_c007_1 0) vcvs gain=1.950903220161e-01
SMIXI_c007_1_03 (mix_i_src_c007_1_03 mix_i_c007_1 win_1_03 0) relay vt1=-1m vt2=1m ropen=ropen_mix rclosed=rclosed_mix
EMIXQ_c007_1_03 (mix_q_src_c007_1_03 0 bpf_c007_1 0) vcvs gain=9.807852804032e-01
SMIXQ_c007_1_03 (mix_q_src_c007_1_03 mix_q_c007_1 win_1_03 0) relay vt1=-1m vt2=1m ropen=ropen_mix rclosed=rclosed_mix
EMIXI_c007_1_04 (mix_i_src_c007_1_04 0 bpf_c007_1 0) vcvs gain=-1.950903220161e-01
SMIXI_c007_1_04 (mix_i_src_c007_1_04 mix_i_c007_1 win_1_04 0) relay vt1=-1m vt2=1m ropen=ropen_mix rclosed=rclosed_mix
EMIXQ_c007_1_04 (mix_q_src_c007_1_04 0 bpf_c007_1 0) vcvs gain=9.807852804032e-01
SMIXQ_c007_1_04 (mix_q_src_c007_1_04 mix_q_c007_1 win_1_04 0) relay vt1=-1m vt2=1m ropen=ropen_mix rclosed=rclosed_mix
EMIXI_c007_1_05 (mix_i_src_c007_1_05 0 bpf_c007_1 0) vcvs gain=-5.555702330196e-01
SMIXI_c007_1_05 (mix_i_src_c007_1_05 mix_i_c007_1 win_1_05 0) relay vt1=-1m vt2=1m ropen=ropen_mix rclosed=rclosed_mix
EMIXQ_c007_1_05 (mix_q_src_c007_1_05 0 bpf_c007_1 0) vcvs gain=8.314696123025e-01
SMIXQ_c007_1_05 (mix_q_src_c007_1_05 mix_q_c007_1 win_1_05 0) relay vt1=-1m vt2=1m ropen=ropen_mix rclosed=rclosed_mix
EMIXI_c007_1_06 (mix_i_src_c007_1_06 0 bpf_c007_1 0) vcvs gain=-8.314696123025e-01
SMIXI_c007_1_06 (mix_i_src_c007_1_06 mix_i_c007_1 win_1_06 0) relay vt1=-1m vt2=1m ropen=ropen_mix rclosed=rclosed_mix
EMIXQ_c007_1_06 (mix_q_src_c007_1_06 0 bpf_c007_1 0) vcvs gain=5.555702330196e-01
SMIXQ_c007_1_06 (mix_q_src_c007_1_06 mix_q_c007_1 win_1_06 0) relay vt1=-1m vt2=1m ropen=ropen_mix rclosed=rclosed_mix
EMIXI_c007_1_07 (mix_i_src_c007_1_07 0 bpf_c007_1 0) vcvs gain=-9.807852804032e-01
SMIXI_c007_1_07 (mix_i_src_c007_1_07 mix_i_c007_1 win_1_07 0) relay vt1=-1m vt2=1m ropen=ropen_mix rclosed=rclosed_mix
EMIXQ_c007_1_07 (mix_q_src_c007_1_07 0 bpf_c007_1 0) vcvs gain=1.950903220161e-01
SMIXQ_c007_1_07 (mix_q_src_c007_1_07 mix_q_c007_1 win_1_07 0) relay vt1=-1m vt2=1m ropen=ropen_mix rclosed=rclosed_mix
EMIXI_c007_1_08 (mix_i_src_c007_1_08 0 bpf_c007_1 0) vcvs gain=-9.807852804032e-01
SMIXI_c007_1_08 (mix_i_src_c007_1_08 mix_i_c007_1 win_1_08 0) relay vt1=-1m vt2=1m ropen=ropen_mix rclosed=rclosed_mix
EMIXQ_c007_1_08 (mix_q_src_c007_1_08 0 bpf_c007_1 0) vcvs gain=-1.950903220161e-01
SMIXQ_c007_1_08 (mix_q_src_c007_1_08 mix_q_c007_1 win_1_08 0) relay vt1=-1m vt2=1m ropen=ropen_mix rclosed=rclosed_mix
EMIXI_c007_1_09 (mix_i_src_c007_1_09 0 bpf_c007_1 0) vcvs gain=-8.314696123025e-01
SMIXI_c007_1_09 (mix_i_src_c007_1_09 mix_i_c007_1 win_1_09 0) relay vt1=-1m vt2=1m ropen=ropen_mix rclosed=rclosed_mix
EMIXQ_c007_1_09 (mix_q_src_c007_1_09 0 bpf_c007_1 0) vcvs gain=-5.555702330196e-01
SMIXQ_c007_1_09 (mix_q_src_c007_1_09 mix_q_c007_1 win_1_09 0) relay vt1=-1m vt2=1m ropen=ropen_mix rclosed=rclosed_mix
EMIXI_c007_1_10 (mix_i_src_c007_1_10 0 bpf_c007_1 0) vcvs gain=-5.555702330196e-01
SMIXI_c007_1_10 (mix_i_src_c007_1_10 mix_i_c007_1 win_1_10 0) relay vt1=-1m vt2=1m ropen=ropen_mix rclosed=rclosed_mix
EMIXQ_c007_1_10 (mix_q_src_c007_1_10 0 bpf_c007_1 0) vcvs gain=-8.314696123025e-01
SMIXQ_c007_1_10 (mix_q_src_c007_1_10 mix_q_c007_1 win_1_10 0) relay vt1=-1m vt2=1m ropen=ropen_mix rclosed=rclosed_mix
EMIXI_c007_1_11 (mix_i_src_c007_1_11 0 bpf_c007_1 0) vcvs gain=-1.950903220161e-01
SMIXI_c007_1_11 (mix_i_src_c007_1_11 mix_i_c007_1 win_1_11 0) relay vt1=-1m vt2=1m ropen=ropen_mix rclosed=rclosed_mix
EMIXQ_c007_1_11 (mix_q_src_c007_1_11 0 bpf_c007_1 0) vcvs gain=-9.807852804032e-01
SMIXQ_c007_1_11 (mix_q_src_c007_1_11 mix_q_c007_1 win_1_11 0) relay vt1=-1m vt2=1m ropen=ropen_mix rclosed=rclosed_mix
EMIXI_c007_1_12 (mix_i_src_c007_1_12 0 bpf_c007_1 0) vcvs gain=1.950903220161e-01
SMIXI_c007_1_12 (mix_i_src_c007_1_12 mix_i_c007_1 win_1_12 0) relay vt1=-1m vt2=1m ropen=ropen_mix rclosed=rclosed_mix
EMIXQ_c007_1_12 (mix_q_src_c007_1_12 0 bpf_c007_1 0) vcvs gain=-9.807852804032e-01
SMIXQ_c007_1_12 (mix_q_src_c007_1_12 mix_q_c007_1 win_1_12 0) relay vt1=-1m vt2=1m ropen=ropen_mix rclosed=rclosed_mix
EMIXI_c007_1_13 (mix_i_src_c007_1_13 0 bpf_c007_1 0) vcvs gain=5.555702330196e-01
SMIXI_c007_1_13 (mix_i_src_c007_1_13 mix_i_c007_1 win_1_13 0) relay vt1=-1m vt2=1m ropen=ropen_mix rclosed=rclosed_mix
EMIXQ_c007_1_13 (mix_q_src_c007_1_13 0 bpf_c007_1 0) vcvs gain=-8.314696123025e-01
SMIXQ_c007_1_13 (mix_q_src_c007_1_13 mix_q_c007_1 win_1_13 0) relay vt1=-1m vt2=1m ropen=ropen_mix rclosed=rclosed_mix
EMIXI_c007_1_14 (mix_i_src_c007_1_14 0 bpf_c007_1 0) vcvs gain=8.314696123025e-01
SMIXI_c007_1_14 (mix_i_src_c007_1_14 mix_i_c007_1 win_1_14 0) relay vt1=-1m vt2=1m ropen=ropen_mix rclosed=rclosed_mix
EMIXQ_c007_1_14 (mix_q_src_c007_1_14 0 bpf_c007_1 0) vcvs gain=-5.555702330196e-01
SMIXQ_c007_1_14 (mix_q_src_c007_1_14 mix_q_c007_1 win_1_14 0) relay vt1=-1m vt2=1m ropen=ropen_mix rclosed=rclosed_mix
EMIXI_c007_1_15 (mix_i_src_c007_1_15 0 bpf_c007_1 0) vcvs gain=9.807852804032e-01
SMIXI_c007_1_15 (mix_i_src_c007_1_15 mix_i_c007_1 win_1_15 0) relay vt1=-1m vt2=1m ropen=ropen_mix rclosed=rclosed_mix
EMIXQ_c007_1_15 (mix_q_src_c007_1_15 0 bpf_c007_1 0) vcvs gain=-1.950903220161e-01
SMIXQ_c007_1_15 (mix_q_src_c007_1_15 mix_q_c007_1 win_1_15 0) relay vt1=-1m vt2=1m ropen=ropen_mix rclosed=rclosed_mix
RMIXI_c007_1 (mix_i_c007_1 0) resistor r=1G
RMIXQ_c007_1 (mix_q_c007_1 0) resistor r=1G
RINTI_c007_1 (mix_i_c007_1 Icar_c007_1) resistor r=1k
CINTI_c007_1 (Icar_c007_1 0) capacitor c=80p
RINTQ_c007_1 (mix_q_c007_1 Qcar_c007_1) resistor r=1k
CINTQ_c007_1 (Qcar_c007_1 0) capacitor c=80p
save bpf_c007_1 Icar_c007_1 Qcar_c007_1

// bl007, carrier_2: 750000000 Hz coherent I/Q phase-window verification-demod path
CBPF_c007_2 (bl007 n_cbpf_c007_2) capacitor c=4.503163717437e-14
LBPF_c007_2 (n_cbpf_c007_2 bpf_c007_2) inductor l=1.000000000000e-06
RBPF_c007_2 (bpf_c007_2 0) resistor r=2.356194490192e+02
EMIXI_c007_2_00 (mix_i_src_c007_2_00 0 bpf_c007_2 0) vcvs gain=9.807852804032e-01
SMIXI_c007_2_00 (mix_i_src_c007_2_00 mix_i_c007_2 win_2_00 0) relay vt1=-1m vt2=1m ropen=ropen_mix rclosed=rclosed_mix
EMIXQ_c007_2_00 (mix_q_src_c007_2_00 0 bpf_c007_2 0) vcvs gain=1.950903220161e-01
SMIXQ_c007_2_00 (mix_q_src_c007_2_00 mix_q_c007_2 win_2_00 0) relay vt1=-1m vt2=1m ropen=ropen_mix rclosed=rclosed_mix
EMIXI_c007_2_01 (mix_i_src_c007_2_01 0 bpf_c007_2 0) vcvs gain=8.314696123025e-01
SMIXI_c007_2_01 (mix_i_src_c007_2_01 mix_i_c007_2 win_2_01 0) relay vt1=-1m vt2=1m ropen=ropen_mix rclosed=rclosed_mix
EMIXQ_c007_2_01 (mix_q_src_c007_2_01 0 bpf_c007_2 0) vcvs gain=5.555702330196e-01
SMIXQ_c007_2_01 (mix_q_src_c007_2_01 mix_q_c007_2 win_2_01 0) relay vt1=-1m vt2=1m ropen=ropen_mix rclosed=rclosed_mix
EMIXI_c007_2_02 (mix_i_src_c007_2_02 0 bpf_c007_2 0) vcvs gain=5.555702330196e-01
SMIXI_c007_2_02 (mix_i_src_c007_2_02 mix_i_c007_2 win_2_02 0) relay vt1=-1m vt2=1m ropen=ropen_mix rclosed=rclosed_mix
EMIXQ_c007_2_02 (mix_q_src_c007_2_02 0 bpf_c007_2 0) vcvs gain=8.314696123025e-01
SMIXQ_c007_2_02 (mix_q_src_c007_2_02 mix_q_c007_2 win_2_02 0) relay vt1=-1m vt2=1m ropen=ropen_mix rclosed=rclosed_mix
EMIXI_c007_2_03 (mix_i_src_c007_2_03 0 bpf_c007_2 0) vcvs gain=1.950903220161e-01
SMIXI_c007_2_03 (mix_i_src_c007_2_03 mix_i_c007_2 win_2_03 0) relay vt1=-1m vt2=1m ropen=ropen_mix rclosed=rclosed_mix
EMIXQ_c007_2_03 (mix_q_src_c007_2_03 0 bpf_c007_2 0) vcvs gain=9.807852804032e-01
SMIXQ_c007_2_03 (mix_q_src_c007_2_03 mix_q_c007_2 win_2_03 0) relay vt1=-1m vt2=1m ropen=ropen_mix rclosed=rclosed_mix
EMIXI_c007_2_04 (mix_i_src_c007_2_04 0 bpf_c007_2 0) vcvs gain=-1.950903220161e-01
SMIXI_c007_2_04 (mix_i_src_c007_2_04 mix_i_c007_2 win_2_04 0) relay vt1=-1m vt2=1m ropen=ropen_mix rclosed=rclosed_mix
EMIXQ_c007_2_04 (mix_q_src_c007_2_04 0 bpf_c007_2 0) vcvs gain=9.807852804032e-01
SMIXQ_c007_2_04 (mix_q_src_c007_2_04 mix_q_c007_2 win_2_04 0) relay vt1=-1m vt2=1m ropen=ropen_mix rclosed=rclosed_mix
EMIXI_c007_2_05 (mix_i_src_c007_2_05 0 bpf_c007_2 0) vcvs gain=-5.555702330196e-01
SMIXI_c007_2_05 (mix_i_src_c007_2_05 mix_i_c007_2 win_2_05 0) relay vt1=-1m vt2=1m ropen=ropen_mix rclosed=rclosed_mix
EMIXQ_c007_2_05 (mix_q_src_c007_2_05 0 bpf_c007_2 0) vcvs gain=8.314696123025e-01
SMIXQ_c007_2_05 (mix_q_src_c007_2_05 mix_q_c007_2 win_2_05 0) relay vt1=-1m vt2=1m ropen=ropen_mix rclosed=rclosed_mix
EMIXI_c007_2_06 (mix_i_src_c007_2_06 0 bpf_c007_2 0) vcvs gain=-8.314696123025e-01
SMIXI_c007_2_06 (mix_i_src_c007_2_06 mix_i_c007_2 win_2_06 0) relay vt1=-1m vt2=1m ropen=ropen_mix rclosed=rclosed_mix
EMIXQ_c007_2_06 (mix_q_src_c007_2_06 0 bpf_c007_2 0) vcvs gain=5.555702330196e-01
SMIXQ_c007_2_06 (mix_q_src_c007_2_06 mix_q_c007_2 win_2_06 0) relay vt1=-1m vt2=1m ropen=ropen_mix rclosed=rclosed_mix
EMIXI_c007_2_07 (mix_i_src_c007_2_07 0 bpf_c007_2 0) vcvs gain=-9.807852804032e-01
SMIXI_c007_2_07 (mix_i_src_c007_2_07 mix_i_c007_2 win_2_07 0) relay vt1=-1m vt2=1m ropen=ropen_mix rclosed=rclosed_mix
EMIXQ_c007_2_07 (mix_q_src_c007_2_07 0 bpf_c007_2 0) vcvs gain=1.950903220161e-01
SMIXQ_c007_2_07 (mix_q_src_c007_2_07 mix_q_c007_2 win_2_07 0) relay vt1=-1m vt2=1m ropen=ropen_mix rclosed=rclosed_mix
EMIXI_c007_2_08 (mix_i_src_c007_2_08 0 bpf_c007_2 0) vcvs gain=-9.807852804032e-01
SMIXI_c007_2_08 (mix_i_src_c007_2_08 mix_i_c007_2 win_2_08 0) relay vt1=-1m vt2=1m ropen=ropen_mix rclosed=rclosed_mix
EMIXQ_c007_2_08 (mix_q_src_c007_2_08 0 bpf_c007_2 0) vcvs gain=-1.950903220161e-01
SMIXQ_c007_2_08 (mix_q_src_c007_2_08 mix_q_c007_2 win_2_08 0) relay vt1=-1m vt2=1m ropen=ropen_mix rclosed=rclosed_mix
EMIXI_c007_2_09 (mix_i_src_c007_2_09 0 bpf_c007_2 0) vcvs gain=-8.314696123025e-01
SMIXI_c007_2_09 (mix_i_src_c007_2_09 mix_i_c007_2 win_2_09 0) relay vt1=-1m vt2=1m ropen=ropen_mix rclosed=rclosed_mix
EMIXQ_c007_2_09 (mix_q_src_c007_2_09 0 bpf_c007_2 0) vcvs gain=-5.555702330196e-01
SMIXQ_c007_2_09 (mix_q_src_c007_2_09 mix_q_c007_2 win_2_09 0) relay vt1=-1m vt2=1m ropen=ropen_mix rclosed=rclosed_mix
EMIXI_c007_2_10 (mix_i_src_c007_2_10 0 bpf_c007_2 0) vcvs gain=-5.555702330196e-01
SMIXI_c007_2_10 (mix_i_src_c007_2_10 mix_i_c007_2 win_2_10 0) relay vt1=-1m vt2=1m ropen=ropen_mix rclosed=rclosed_mix
EMIXQ_c007_2_10 (mix_q_src_c007_2_10 0 bpf_c007_2 0) vcvs gain=-8.314696123025e-01
SMIXQ_c007_2_10 (mix_q_src_c007_2_10 mix_q_c007_2 win_2_10 0) relay vt1=-1m vt2=1m ropen=ropen_mix rclosed=rclosed_mix
EMIXI_c007_2_11 (mix_i_src_c007_2_11 0 bpf_c007_2 0) vcvs gain=-1.950903220161e-01
SMIXI_c007_2_11 (mix_i_src_c007_2_11 mix_i_c007_2 win_2_11 0) relay vt1=-1m vt2=1m ropen=ropen_mix rclosed=rclosed_mix
EMIXQ_c007_2_11 (mix_q_src_c007_2_11 0 bpf_c007_2 0) vcvs gain=-9.807852804032e-01
SMIXQ_c007_2_11 (mix_q_src_c007_2_11 mix_q_c007_2 win_2_11 0) relay vt1=-1m vt2=1m ropen=ropen_mix rclosed=rclosed_mix
EMIXI_c007_2_12 (mix_i_src_c007_2_12 0 bpf_c007_2 0) vcvs gain=1.950903220161e-01
SMIXI_c007_2_12 (mix_i_src_c007_2_12 mix_i_c007_2 win_2_12 0) relay vt1=-1m vt2=1m ropen=ropen_mix rclosed=rclosed_mix
EMIXQ_c007_2_12 (mix_q_src_c007_2_12 0 bpf_c007_2 0) vcvs gain=-9.807852804032e-01
SMIXQ_c007_2_12 (mix_q_src_c007_2_12 mix_q_c007_2 win_2_12 0) relay vt1=-1m vt2=1m ropen=ropen_mix rclosed=rclosed_mix
EMIXI_c007_2_13 (mix_i_src_c007_2_13 0 bpf_c007_2 0) vcvs gain=5.555702330196e-01
SMIXI_c007_2_13 (mix_i_src_c007_2_13 mix_i_c007_2 win_2_13 0) relay vt1=-1m vt2=1m ropen=ropen_mix rclosed=rclosed_mix
EMIXQ_c007_2_13 (mix_q_src_c007_2_13 0 bpf_c007_2 0) vcvs gain=-8.314696123025e-01
SMIXQ_c007_2_13 (mix_q_src_c007_2_13 mix_q_c007_2 win_2_13 0) relay vt1=-1m vt2=1m ropen=ropen_mix rclosed=rclosed_mix
EMIXI_c007_2_14 (mix_i_src_c007_2_14 0 bpf_c007_2 0) vcvs gain=8.314696123025e-01
SMIXI_c007_2_14 (mix_i_src_c007_2_14 mix_i_c007_2 win_2_14 0) relay vt1=-1m vt2=1m ropen=ropen_mix rclosed=rclosed_mix
EMIXQ_c007_2_14 (mix_q_src_c007_2_14 0 bpf_c007_2 0) vcvs gain=-5.555702330196e-01
SMIXQ_c007_2_14 (mix_q_src_c007_2_14 mix_q_c007_2 win_2_14 0) relay vt1=-1m vt2=1m ropen=ropen_mix rclosed=rclosed_mix
EMIXI_c007_2_15 (mix_i_src_c007_2_15 0 bpf_c007_2 0) vcvs gain=9.807852804032e-01
SMIXI_c007_2_15 (mix_i_src_c007_2_15 mix_i_c007_2 win_2_15 0) relay vt1=-1m vt2=1m ropen=ropen_mix rclosed=rclosed_mix
EMIXQ_c007_2_15 (mix_q_src_c007_2_15 0 bpf_c007_2 0) vcvs gain=-1.950903220161e-01
SMIXQ_c007_2_15 (mix_q_src_c007_2_15 mix_q_c007_2 win_2_15 0) relay vt1=-1m vt2=1m ropen=ropen_mix rclosed=rclosed_mix
RMIXI_c007_2 (mix_i_c007_2 0) resistor r=1G
RMIXQ_c007_2 (mix_q_c007_2 0) resistor r=1G
RINTI_c007_2 (mix_i_c007_2 Icar_c007_2) resistor r=1k
CINTI_c007_2 (Icar_c007_2 0) capacitor c=80p
RINTQ_c007_2 (mix_q_c007_2 Qcar_c007_2) resistor r=1k
CINTQ_c007_2 (Qcar_c007_2 0) capacitor c=80p
save bpf_c007_2 Icar_c007_2 Qcar_c007_2

// bl007, carrier_3: 1000000000 Hz coherent I/Q phase-window verification-demod path
CBPF_c007_3 (bl007 n_cbpf_c007_3) capacitor c=2.533029591058e-14
LBPF_c007_3 (n_cbpf_c007_3 bpf_c007_3) inductor l=1.000000000000e-06
RBPF_c007_3 (bpf_c007_3 0) resistor r=3.141592653590e+02
EMIXI_c007_3_00 (mix_i_src_c007_3_00 0 bpf_c007_3 0) vcvs gain=9.807852804032e-01
SMIXI_c007_3_00 (mix_i_src_c007_3_00 mix_i_c007_3 win_3_00 0) relay vt1=-1m vt2=1m ropen=ropen_mix rclosed=rclosed_mix
EMIXQ_c007_3_00 (mix_q_src_c007_3_00 0 bpf_c007_3 0) vcvs gain=1.950903220161e-01
SMIXQ_c007_3_00 (mix_q_src_c007_3_00 mix_q_c007_3 win_3_00 0) relay vt1=-1m vt2=1m ropen=ropen_mix rclosed=rclosed_mix
EMIXI_c007_3_01 (mix_i_src_c007_3_01 0 bpf_c007_3 0) vcvs gain=8.314696123025e-01
SMIXI_c007_3_01 (mix_i_src_c007_3_01 mix_i_c007_3 win_3_01 0) relay vt1=-1m vt2=1m ropen=ropen_mix rclosed=rclosed_mix
EMIXQ_c007_3_01 (mix_q_src_c007_3_01 0 bpf_c007_3 0) vcvs gain=5.555702330196e-01
SMIXQ_c007_3_01 (mix_q_src_c007_3_01 mix_q_c007_3 win_3_01 0) relay vt1=-1m vt2=1m ropen=ropen_mix rclosed=rclosed_mix
EMIXI_c007_3_02 (mix_i_src_c007_3_02 0 bpf_c007_3 0) vcvs gain=5.555702330196e-01
SMIXI_c007_3_02 (mix_i_src_c007_3_02 mix_i_c007_3 win_3_02 0) relay vt1=-1m vt2=1m ropen=ropen_mix rclosed=rclosed_mix
EMIXQ_c007_3_02 (mix_q_src_c007_3_02 0 bpf_c007_3 0) vcvs gain=8.314696123025e-01
SMIXQ_c007_3_02 (mix_q_src_c007_3_02 mix_q_c007_3 win_3_02 0) relay vt1=-1m vt2=1m ropen=ropen_mix rclosed=rclosed_mix
EMIXI_c007_3_03 (mix_i_src_c007_3_03 0 bpf_c007_3 0) vcvs gain=1.950903220161e-01
SMIXI_c007_3_03 (mix_i_src_c007_3_03 mix_i_c007_3 win_3_03 0) relay vt1=-1m vt2=1m ropen=ropen_mix rclosed=rclosed_mix
EMIXQ_c007_3_03 (mix_q_src_c007_3_03 0 bpf_c007_3 0) vcvs gain=9.807852804032e-01
SMIXQ_c007_3_03 (mix_q_src_c007_3_03 mix_q_c007_3 win_3_03 0) relay vt1=-1m vt2=1m ropen=ropen_mix rclosed=rclosed_mix
EMIXI_c007_3_04 (mix_i_src_c007_3_04 0 bpf_c007_3 0) vcvs gain=-1.950903220161e-01
SMIXI_c007_3_04 (mix_i_src_c007_3_04 mix_i_c007_3 win_3_04 0) relay vt1=-1m vt2=1m ropen=ropen_mix rclosed=rclosed_mix
EMIXQ_c007_3_04 (mix_q_src_c007_3_04 0 bpf_c007_3 0) vcvs gain=9.807852804032e-01
SMIXQ_c007_3_04 (mix_q_src_c007_3_04 mix_q_c007_3 win_3_04 0) relay vt1=-1m vt2=1m ropen=ropen_mix rclosed=rclosed_mix
EMIXI_c007_3_05 (mix_i_src_c007_3_05 0 bpf_c007_3 0) vcvs gain=-5.555702330196e-01
SMIXI_c007_3_05 (mix_i_src_c007_3_05 mix_i_c007_3 win_3_05 0) relay vt1=-1m vt2=1m ropen=ropen_mix rclosed=rclosed_mix
EMIXQ_c007_3_05 (mix_q_src_c007_3_05 0 bpf_c007_3 0) vcvs gain=8.314696123025e-01
SMIXQ_c007_3_05 (mix_q_src_c007_3_05 mix_q_c007_3 win_3_05 0) relay vt1=-1m vt2=1m ropen=ropen_mix rclosed=rclosed_mix
EMIXI_c007_3_06 (mix_i_src_c007_3_06 0 bpf_c007_3 0) vcvs gain=-8.314696123025e-01
SMIXI_c007_3_06 (mix_i_src_c007_3_06 mix_i_c007_3 win_3_06 0) relay vt1=-1m vt2=1m ropen=ropen_mix rclosed=rclosed_mix
EMIXQ_c007_3_06 (mix_q_src_c007_3_06 0 bpf_c007_3 0) vcvs gain=5.555702330196e-01
SMIXQ_c007_3_06 (mix_q_src_c007_3_06 mix_q_c007_3 win_3_06 0) relay vt1=-1m vt2=1m ropen=ropen_mix rclosed=rclosed_mix
EMIXI_c007_3_07 (mix_i_src_c007_3_07 0 bpf_c007_3 0) vcvs gain=-9.807852804032e-01
SMIXI_c007_3_07 (mix_i_src_c007_3_07 mix_i_c007_3 win_3_07 0) relay vt1=-1m vt2=1m ropen=ropen_mix rclosed=rclosed_mix
EMIXQ_c007_3_07 (mix_q_src_c007_3_07 0 bpf_c007_3 0) vcvs gain=1.950903220161e-01
SMIXQ_c007_3_07 (mix_q_src_c007_3_07 mix_q_c007_3 win_3_07 0) relay vt1=-1m vt2=1m ropen=ropen_mix rclosed=rclosed_mix
EMIXI_c007_3_08 (mix_i_src_c007_3_08 0 bpf_c007_3 0) vcvs gain=-9.807852804032e-01
SMIXI_c007_3_08 (mix_i_src_c007_3_08 mix_i_c007_3 win_3_08 0) relay vt1=-1m vt2=1m ropen=ropen_mix rclosed=rclosed_mix
EMIXQ_c007_3_08 (mix_q_src_c007_3_08 0 bpf_c007_3 0) vcvs gain=-1.950903220161e-01
SMIXQ_c007_3_08 (mix_q_src_c007_3_08 mix_q_c007_3 win_3_08 0) relay vt1=-1m vt2=1m ropen=ropen_mix rclosed=rclosed_mix
EMIXI_c007_3_09 (mix_i_src_c007_3_09 0 bpf_c007_3 0) vcvs gain=-8.314696123025e-01
SMIXI_c007_3_09 (mix_i_src_c007_3_09 mix_i_c007_3 win_3_09 0) relay vt1=-1m vt2=1m ropen=ropen_mix rclosed=rclosed_mix
EMIXQ_c007_3_09 (mix_q_src_c007_3_09 0 bpf_c007_3 0) vcvs gain=-5.555702330196e-01
SMIXQ_c007_3_09 (mix_q_src_c007_3_09 mix_q_c007_3 win_3_09 0) relay vt1=-1m vt2=1m ropen=ropen_mix rclosed=rclosed_mix
EMIXI_c007_3_10 (mix_i_src_c007_3_10 0 bpf_c007_3 0) vcvs gain=-5.555702330196e-01
SMIXI_c007_3_10 (mix_i_src_c007_3_10 mix_i_c007_3 win_3_10 0) relay vt1=-1m vt2=1m ropen=ropen_mix rclosed=rclosed_mix
EMIXQ_c007_3_10 (mix_q_src_c007_3_10 0 bpf_c007_3 0) vcvs gain=-8.314696123025e-01
SMIXQ_c007_3_10 (mix_q_src_c007_3_10 mix_q_c007_3 win_3_10 0) relay vt1=-1m vt2=1m ropen=ropen_mix rclosed=rclosed_mix
EMIXI_c007_3_11 (mix_i_src_c007_3_11 0 bpf_c007_3 0) vcvs gain=-1.950903220161e-01
SMIXI_c007_3_11 (mix_i_src_c007_3_11 mix_i_c007_3 win_3_11 0) relay vt1=-1m vt2=1m ropen=ropen_mix rclosed=rclosed_mix
EMIXQ_c007_3_11 (mix_q_src_c007_3_11 0 bpf_c007_3 0) vcvs gain=-9.807852804032e-01
SMIXQ_c007_3_11 (mix_q_src_c007_3_11 mix_q_c007_3 win_3_11 0) relay vt1=-1m vt2=1m ropen=ropen_mix rclosed=rclosed_mix
EMIXI_c007_3_12 (mix_i_src_c007_3_12 0 bpf_c007_3 0) vcvs gain=1.950903220161e-01
SMIXI_c007_3_12 (mix_i_src_c007_3_12 mix_i_c007_3 win_3_12 0) relay vt1=-1m vt2=1m ropen=ropen_mix rclosed=rclosed_mix
EMIXQ_c007_3_12 (mix_q_src_c007_3_12 0 bpf_c007_3 0) vcvs gain=-9.807852804032e-01
SMIXQ_c007_3_12 (mix_q_src_c007_3_12 mix_q_c007_3 win_3_12 0) relay vt1=-1m vt2=1m ropen=ropen_mix rclosed=rclosed_mix
EMIXI_c007_3_13 (mix_i_src_c007_3_13 0 bpf_c007_3 0) vcvs gain=5.555702330196e-01
SMIXI_c007_3_13 (mix_i_src_c007_3_13 mix_i_c007_3 win_3_13 0) relay vt1=-1m vt2=1m ropen=ropen_mix rclosed=rclosed_mix
EMIXQ_c007_3_13 (mix_q_src_c007_3_13 0 bpf_c007_3 0) vcvs gain=-8.314696123025e-01
SMIXQ_c007_3_13 (mix_q_src_c007_3_13 mix_q_c007_3 win_3_13 0) relay vt1=-1m vt2=1m ropen=ropen_mix rclosed=rclosed_mix
EMIXI_c007_3_14 (mix_i_src_c007_3_14 0 bpf_c007_3 0) vcvs gain=8.314696123025e-01
SMIXI_c007_3_14 (mix_i_src_c007_3_14 mix_i_c007_3 win_3_14 0) relay vt1=-1m vt2=1m ropen=ropen_mix rclosed=rclosed_mix
EMIXQ_c007_3_14 (mix_q_src_c007_3_14 0 bpf_c007_3 0) vcvs gain=-5.555702330196e-01
SMIXQ_c007_3_14 (mix_q_src_c007_3_14 mix_q_c007_3 win_3_14 0) relay vt1=-1m vt2=1m ropen=ropen_mix rclosed=rclosed_mix
EMIXI_c007_3_15 (mix_i_src_c007_3_15 0 bpf_c007_3 0) vcvs gain=9.807852804032e-01
SMIXI_c007_3_15 (mix_i_src_c007_3_15 mix_i_c007_3 win_3_15 0) relay vt1=-1m vt2=1m ropen=ropen_mix rclosed=rclosed_mix
EMIXQ_c007_3_15 (mix_q_src_c007_3_15 0 bpf_c007_3 0) vcvs gain=-1.950903220161e-01
SMIXQ_c007_3_15 (mix_q_src_c007_3_15 mix_q_c007_3 win_3_15 0) relay vt1=-1m vt2=1m ropen=ropen_mix rclosed=rclosed_mix
RMIXI_c007_3 (mix_i_c007_3 0) resistor r=1G
RMIXQ_c007_3 (mix_q_c007_3 0) resistor r=1G
RINTI_c007_3 (mix_i_c007_3 Icar_c007_3) resistor r=1k
CINTI_c007_3 (Icar_c007_3 0) capacitor c=80p
RINTQ_c007_3 (mix_q_c007_3 Qcar_c007_3) resistor r=1k
CINTQ_c007_3 (Qcar_c007_3 0) capacitor c=80p
save bpf_c007_3 Icar_c007_3 Qcar_c007_3

tbtran tran stop=80n maxstep=10p
