// Coherent-demodulation testbench for 32x32 OFDM/QAM-RRAM MVM
// Every BL/carrier path uses BPF, phase-window verification demodulator, and RC integration.
simulator lang=spectre
include "../netlist/clean_32x32_crossbar_sanity.scs"

parameters rclosed_mix=1 ropen_mix=1G

VREFI_0 (ref_i_0 0) vsource type=sine freq=250000000 ampl=1 phase=90
VREFQ_0 (ref_q_0 0) vsource type=sine freq=250000000 ampl=1 phase=0
RREFI_0 (ref_i_0 0) resistor r=1G
RREFQ_0 (ref_q_0 0) resistor r=1G
VWIN_0_00 (win_0_00 0) vsource type=pulse val0=-1 val1=1 period=4.000000000000e-09 width=2.500000000000e-10 delay=0.000000000000e+00 rise=1p fall=1p
VWIN_0_01 (win_0_01 0) vsource type=pulse val0=-1 val1=1 period=4.000000000000e-09 width=2.500000000000e-10 delay=2.500000000000e-10 rise=1p fall=1p
VWIN_0_02 (win_0_02 0) vsource type=pulse val0=-1 val1=1 period=4.000000000000e-09 width=2.500000000000e-10 delay=5.000000000000e-10 rise=1p fall=1p
VWIN_0_03 (win_0_03 0) vsource type=pulse val0=-1 val1=1 period=4.000000000000e-09 width=2.500000000000e-10 delay=7.500000000000e-10 rise=1p fall=1p
VWIN_0_04 (win_0_04 0) vsource type=pulse val0=-1 val1=1 period=4.000000000000e-09 width=2.500000000000e-10 delay=1.000000000000e-09 rise=1p fall=1p
VWIN_0_05 (win_0_05 0) vsource type=pulse val0=-1 val1=1 period=4.000000000000e-09 width=2.500000000000e-10 delay=1.250000000000e-09 rise=1p fall=1p
VWIN_0_06 (win_0_06 0) vsource type=pulse val0=-1 val1=1 period=4.000000000000e-09 width=2.500000000000e-10 delay=1.500000000000e-09 rise=1p fall=1p
VWIN_0_07 (win_0_07 0) vsource type=pulse val0=-1 val1=1 period=4.000000000000e-09 width=2.500000000000e-10 delay=1.750000000000e-09 rise=1p fall=1p
VWIN_0_08 (win_0_08 0) vsource type=pulse val0=-1 val1=1 period=4.000000000000e-09 width=2.500000000000e-10 delay=2.000000000000e-09 rise=1p fall=1p
VWIN_0_09 (win_0_09 0) vsource type=pulse val0=-1 val1=1 period=4.000000000000e-09 width=2.500000000000e-10 delay=2.250000000000e-09 rise=1p fall=1p
VWIN_0_10 (win_0_10 0) vsource type=pulse val0=-1 val1=1 period=4.000000000000e-09 width=2.500000000000e-10 delay=2.500000000000e-09 rise=1p fall=1p
VWIN_0_11 (win_0_11 0) vsource type=pulse val0=-1 val1=1 period=4.000000000000e-09 width=2.500000000000e-10 delay=2.750000000000e-09 rise=1p fall=1p
VWIN_0_12 (win_0_12 0) vsource type=pulse val0=-1 val1=1 period=4.000000000000e-09 width=2.500000000000e-10 delay=3.000000000000e-09 rise=1p fall=1p
VWIN_0_13 (win_0_13 0) vsource type=pulse val0=-1 val1=1 period=4.000000000000e-09 width=2.500000000000e-10 delay=3.250000000000e-09 rise=1p fall=1p
VWIN_0_14 (win_0_14 0) vsource type=pulse val0=-1 val1=1 period=4.000000000000e-09 width=2.500000000000e-10 delay=3.500000000000e-09 rise=1p fall=1p
VWIN_0_15 (win_0_15 0) vsource type=pulse val0=-1 val1=1 period=4.000000000000e-09 width=2.500000000000e-10 delay=3.750000000000e-09 rise=1p fall=1p

VREFI_1 (ref_i_1 0) vsource type=sine freq=500000000 ampl=1 phase=90
VREFQ_1 (ref_q_1 0) vsource type=sine freq=500000000 ampl=1 phase=0
RREFI_1 (ref_i_1 0) resistor r=1G
RREFQ_1 (ref_q_1 0) resistor r=1G
VWIN_1_00 (win_1_00 0) vsource type=pulse val0=-1 val1=1 period=2.000000000000e-09 width=1.250000000000e-10 delay=0.000000000000e+00 rise=1p fall=1p
VWIN_1_01 (win_1_01 0) vsource type=pulse val0=-1 val1=1 period=2.000000000000e-09 width=1.250000000000e-10 delay=1.250000000000e-10 rise=1p fall=1p
VWIN_1_02 (win_1_02 0) vsource type=pulse val0=-1 val1=1 period=2.000000000000e-09 width=1.250000000000e-10 delay=2.500000000000e-10 rise=1p fall=1p
VWIN_1_03 (win_1_03 0) vsource type=pulse val0=-1 val1=1 period=2.000000000000e-09 width=1.250000000000e-10 delay=3.750000000000e-10 rise=1p fall=1p
VWIN_1_04 (win_1_04 0) vsource type=pulse val0=-1 val1=1 period=2.000000000000e-09 width=1.250000000000e-10 delay=5.000000000000e-10 rise=1p fall=1p
VWIN_1_05 (win_1_05 0) vsource type=pulse val0=-1 val1=1 period=2.000000000000e-09 width=1.250000000000e-10 delay=6.250000000000e-10 rise=1p fall=1p
VWIN_1_06 (win_1_06 0) vsource type=pulse val0=-1 val1=1 period=2.000000000000e-09 width=1.250000000000e-10 delay=7.500000000000e-10 rise=1p fall=1p
VWIN_1_07 (win_1_07 0) vsource type=pulse val0=-1 val1=1 period=2.000000000000e-09 width=1.250000000000e-10 delay=8.750000000000e-10 rise=1p fall=1p
VWIN_1_08 (win_1_08 0) vsource type=pulse val0=-1 val1=1 period=2.000000000000e-09 width=1.250000000000e-10 delay=1.000000000000e-09 rise=1p fall=1p
VWIN_1_09 (win_1_09 0) vsource type=pulse val0=-1 val1=1 period=2.000000000000e-09 width=1.250000000000e-10 delay=1.125000000000e-09 rise=1p fall=1p
VWIN_1_10 (win_1_10 0) vsource type=pulse val0=-1 val1=1 period=2.000000000000e-09 width=1.250000000000e-10 delay=1.250000000000e-09 rise=1p fall=1p
VWIN_1_11 (win_1_11 0) vsource type=pulse val0=-1 val1=1 period=2.000000000000e-09 width=1.250000000000e-10 delay=1.375000000000e-09 rise=1p fall=1p
VWIN_1_12 (win_1_12 0) vsource type=pulse val0=-1 val1=1 period=2.000000000000e-09 width=1.250000000000e-10 delay=1.500000000000e-09 rise=1p fall=1p
VWIN_1_13 (win_1_13 0) vsource type=pulse val0=-1 val1=1 period=2.000000000000e-09 width=1.250000000000e-10 delay=1.625000000000e-09 rise=1p fall=1p
VWIN_1_14 (win_1_14 0) vsource type=pulse val0=-1 val1=1 period=2.000000000000e-09 width=1.250000000000e-10 delay=1.750000000000e-09 rise=1p fall=1p
VWIN_1_15 (win_1_15 0) vsource type=pulse val0=-1 val1=1 period=2.000000000000e-09 width=1.250000000000e-10 delay=1.875000000000e-09 rise=1p fall=1p

VREFI_2 (ref_i_2 0) vsource type=sine freq=750000000 ampl=1 phase=90
VREFQ_2 (ref_q_2 0) vsource type=sine freq=750000000 ampl=1 phase=0
RREFI_2 (ref_i_2 0) resistor r=1G
RREFQ_2 (ref_q_2 0) resistor r=1G
VWIN_2_00 (win_2_00 0) vsource type=pulse val0=-1 val1=1 period=1.333333333333e-09 width=8.333333333333e-11 delay=0.000000000000e+00 rise=1p fall=1p
VWIN_2_01 (win_2_01 0) vsource type=pulse val0=-1 val1=1 period=1.333333333333e-09 width=8.333333333333e-11 delay=8.333333333333e-11 rise=1p fall=1p
VWIN_2_02 (win_2_02 0) vsource type=pulse val0=-1 val1=1 period=1.333333333333e-09 width=8.333333333333e-11 delay=1.666666666667e-10 rise=1p fall=1p
VWIN_2_03 (win_2_03 0) vsource type=pulse val0=-1 val1=1 period=1.333333333333e-09 width=8.333333333333e-11 delay=2.500000000000e-10 rise=1p fall=1p
VWIN_2_04 (win_2_04 0) vsource type=pulse val0=-1 val1=1 period=1.333333333333e-09 width=8.333333333333e-11 delay=3.333333333333e-10 rise=1p fall=1p
VWIN_2_05 (win_2_05 0) vsource type=pulse val0=-1 val1=1 period=1.333333333333e-09 width=8.333333333333e-11 delay=4.166666666667e-10 rise=1p fall=1p
VWIN_2_06 (win_2_06 0) vsource type=pulse val0=-1 val1=1 period=1.333333333333e-09 width=8.333333333333e-11 delay=5.000000000000e-10 rise=1p fall=1p
VWIN_2_07 (win_2_07 0) vsource type=pulse val0=-1 val1=1 period=1.333333333333e-09 width=8.333333333333e-11 delay=5.833333333333e-10 rise=1p fall=1p
VWIN_2_08 (win_2_08 0) vsource type=pulse val0=-1 val1=1 period=1.333333333333e-09 width=8.333333333333e-11 delay=6.666666666667e-10 rise=1p fall=1p
VWIN_2_09 (win_2_09 0) vsource type=pulse val0=-1 val1=1 period=1.333333333333e-09 width=8.333333333333e-11 delay=7.500000000000e-10 rise=1p fall=1p
VWIN_2_10 (win_2_10 0) vsource type=pulse val0=-1 val1=1 period=1.333333333333e-09 width=8.333333333333e-11 delay=8.333333333333e-10 rise=1p fall=1p
VWIN_2_11 (win_2_11 0) vsource type=pulse val0=-1 val1=1 period=1.333333333333e-09 width=8.333333333333e-11 delay=9.166666666667e-10 rise=1p fall=1p
VWIN_2_12 (win_2_12 0) vsource type=pulse val0=-1 val1=1 period=1.333333333333e-09 width=8.333333333333e-11 delay=1.000000000000e-09 rise=1p fall=1p
VWIN_2_13 (win_2_13 0) vsource type=pulse val0=-1 val1=1 period=1.333333333333e-09 width=8.333333333333e-11 delay=1.083333333333e-09 rise=1p fall=1p
VWIN_2_14 (win_2_14 0) vsource type=pulse val0=-1 val1=1 period=1.333333333333e-09 width=8.333333333333e-11 delay=1.166666666667e-09 rise=1p fall=1p
VWIN_2_15 (win_2_15 0) vsource type=pulse val0=-1 val1=1 period=1.333333333333e-09 width=8.333333333333e-11 delay=1.250000000000e-09 rise=1p fall=1p

VREFI_3 (ref_i_3 0) vsource type=sine freq=1000000000 ampl=1 phase=90
VREFQ_3 (ref_q_3 0) vsource type=sine freq=1000000000 ampl=1 phase=0
RREFI_3 (ref_i_3 0) resistor r=1G
RREFQ_3 (ref_q_3 0) resistor r=1G
VWIN_3_00 (win_3_00 0) vsource type=pulse val0=-1 val1=1 period=1.000000000000e-09 width=6.250000000000e-11 delay=0.000000000000e+00 rise=1p fall=1p
VWIN_3_01 (win_3_01 0) vsource type=pulse val0=-1 val1=1 period=1.000000000000e-09 width=6.250000000000e-11 delay=6.250000000000e-11 rise=1p fall=1p
VWIN_3_02 (win_3_02 0) vsource type=pulse val0=-1 val1=1 period=1.000000000000e-09 width=6.250000000000e-11 delay=1.250000000000e-10 rise=1p fall=1p
VWIN_3_03 (win_3_03 0) vsource type=pulse val0=-1 val1=1 period=1.000000000000e-09 width=6.250000000000e-11 delay=1.875000000000e-10 rise=1p fall=1p
VWIN_3_04 (win_3_04 0) vsource type=pulse val0=-1 val1=1 period=1.000000000000e-09 width=6.250000000000e-11 delay=2.500000000000e-10 rise=1p fall=1p
VWIN_3_05 (win_3_05 0) vsource type=pulse val0=-1 val1=1 period=1.000000000000e-09 width=6.250000000000e-11 delay=3.125000000000e-10 rise=1p fall=1p
VWIN_3_06 (win_3_06 0) vsource type=pulse val0=-1 val1=1 period=1.000000000000e-09 width=6.250000000000e-11 delay=3.750000000000e-10 rise=1p fall=1p
VWIN_3_07 (win_3_07 0) vsource type=pulse val0=-1 val1=1 period=1.000000000000e-09 width=6.250000000000e-11 delay=4.375000000000e-10 rise=1p fall=1p
VWIN_3_08 (win_3_08 0) vsource type=pulse val0=-1 val1=1 period=1.000000000000e-09 width=6.250000000000e-11 delay=5.000000000000e-10 rise=1p fall=1p
VWIN_3_09 (win_3_09 0) vsource type=pulse val0=-1 val1=1 period=1.000000000000e-09 width=6.250000000000e-11 delay=5.625000000000e-10 rise=1p fall=1p
VWIN_3_10 (win_3_10 0) vsource type=pulse val0=-1 val1=1 period=1.000000000000e-09 width=6.250000000000e-11 delay=6.250000000000e-10 rise=1p fall=1p
VWIN_3_11 (win_3_11 0) vsource type=pulse val0=-1 val1=1 period=1.000000000000e-09 width=6.250000000000e-11 delay=6.875000000000e-10 rise=1p fall=1p
VWIN_3_12 (win_3_12 0) vsource type=pulse val0=-1 val1=1 period=1.000000000000e-09 width=6.250000000000e-11 delay=7.500000000000e-10 rise=1p fall=1p
VWIN_3_13 (win_3_13 0) vsource type=pulse val0=-1 val1=1 period=1.000000000000e-09 width=6.250000000000e-11 delay=8.125000000000e-10 rise=1p fall=1p
VWIN_3_14 (win_3_14 0) vsource type=pulse val0=-1 val1=1 period=1.000000000000e-09 width=6.250000000000e-11 delay=8.750000000000e-10 rise=1p fall=1p
VWIN_3_15 (win_3_15 0) vsource type=pulse val0=-1 val1=1 period=1.000000000000e-09 width=6.250000000000e-11 delay=9.375000000000e-10 rise=1p fall=1p

// bl000, carrier_0: 250000000 Hz coherent I/Q phase-window verification-demod path
CBPF_c000_0 (bl000 n_cbpf_c000_0) capacitor c=4.052847345694e-13
LBPF_c000_0 (n_cbpf_c000_0 bpf_c000_0) inductor l=1.000000000000e-06
RBPF_c000_0 (bpf_c000_0 0) resistor r=7.853981633974e+01
EMIXI_c000_0_00 (mix_i_src_c000_0_00 0 bpf_c000_0 0) vcvs gain=9.807852804032e-01
SMIXI_c000_0_00 (mix_i_src_c000_0_00 mix_i_c000_0 win_0_00 0) relay vt1=-1m vt2=1m ropen=ropen_mix rclosed=rclosed_mix
EMIXQ_c000_0_00 (mix_q_src_c000_0_00 0 bpf_c000_0 0) vcvs gain=1.950903220161e-01
SMIXQ_c000_0_00 (mix_q_src_c000_0_00 mix_q_c000_0 win_0_00 0) relay vt1=-1m vt2=1m ropen=ropen_mix rclosed=rclosed_mix
EMIXI_c000_0_01 (mix_i_src_c000_0_01 0 bpf_c000_0 0) vcvs gain=8.314696123025e-01
SMIXI_c000_0_01 (mix_i_src_c000_0_01 mix_i_c000_0 win_0_01 0) relay vt1=-1m vt2=1m ropen=ropen_mix rclosed=rclosed_mix
EMIXQ_c000_0_01 (mix_q_src_c000_0_01 0 bpf_c000_0 0) vcvs gain=5.555702330196e-01
SMIXQ_c000_0_01 (mix_q_src_c000_0_01 mix_q_c000_0 win_0_01 0) relay vt1=-1m vt2=1m ropen=ropen_mix rclosed=rclosed_mix
EMIXI_c000_0_02 (mix_i_src_c000_0_02 0 bpf_c000_0 0) vcvs gain=5.555702330196e-01
SMIXI_c000_0_02 (mix_i_src_c000_0_02 mix_i_c000_0 win_0_02 0) relay vt1=-1m vt2=1m ropen=ropen_mix rclosed=rclosed_mix
EMIXQ_c000_0_02 (mix_q_src_c000_0_02 0 bpf_c000_0 0) vcvs gain=8.314696123025e-01
SMIXQ_c000_0_02 (mix_q_src_c000_0_02 mix_q_c000_0 win_0_02 0) relay vt1=-1m vt2=1m ropen=ropen_mix rclosed=rclosed_mix
EMIXI_c000_0_03 (mix_i_src_c000_0_03 0 bpf_c000_0 0) vcvs gain=1.950903220161e-01
SMIXI_c000_0_03 (mix_i_src_c000_0_03 mix_i_c000_0 win_0_03 0) relay vt1=-1m vt2=1m ropen=ropen_mix rclosed=rclosed_mix
EMIXQ_c000_0_03 (mix_q_src_c000_0_03 0 bpf_c000_0 0) vcvs gain=9.807852804032e-01
SMIXQ_c000_0_03 (mix_q_src_c000_0_03 mix_q_c000_0 win_0_03 0) relay vt1=-1m vt2=1m ropen=ropen_mix rclosed=rclosed_mix
EMIXI_c000_0_04 (mix_i_src_c000_0_04 0 bpf_c000_0 0) vcvs gain=-1.950903220161e-01
SMIXI_c000_0_04 (mix_i_src_c000_0_04 mix_i_c000_0 win_0_04 0) relay vt1=-1m vt2=1m ropen=ropen_mix rclosed=rclosed_mix
EMIXQ_c000_0_04 (mix_q_src_c000_0_04 0 bpf_c000_0 0) vcvs gain=9.807852804032e-01
SMIXQ_c000_0_04 (mix_q_src_c000_0_04 mix_q_c000_0 win_0_04 0) relay vt1=-1m vt2=1m ropen=ropen_mix rclosed=rclosed_mix
EMIXI_c000_0_05 (mix_i_src_c000_0_05 0 bpf_c000_0 0) vcvs gain=-5.555702330196e-01
SMIXI_c000_0_05 (mix_i_src_c000_0_05 mix_i_c000_0 win_0_05 0) relay vt1=-1m vt2=1m ropen=ropen_mix rclosed=rclosed_mix
EMIXQ_c000_0_05 (mix_q_src_c000_0_05 0 bpf_c000_0 0) vcvs gain=8.314696123025e-01
SMIXQ_c000_0_05 (mix_q_src_c000_0_05 mix_q_c000_0 win_0_05 0) relay vt1=-1m vt2=1m ropen=ropen_mix rclosed=rclosed_mix
EMIXI_c000_0_06 (mix_i_src_c000_0_06 0 bpf_c000_0 0) vcvs gain=-8.314696123025e-01
SMIXI_c000_0_06 (mix_i_src_c000_0_06 mix_i_c000_0 win_0_06 0) relay vt1=-1m vt2=1m ropen=ropen_mix rclosed=rclosed_mix
EMIXQ_c000_0_06 (mix_q_src_c000_0_06 0 bpf_c000_0 0) vcvs gain=5.555702330196e-01
SMIXQ_c000_0_06 (mix_q_src_c000_0_06 mix_q_c000_0 win_0_06 0) relay vt1=-1m vt2=1m ropen=ropen_mix rclosed=rclosed_mix
EMIXI_c000_0_07 (mix_i_src_c000_0_07 0 bpf_c000_0 0) vcvs gain=-9.807852804032e-01
SMIXI_c000_0_07 (mix_i_src_c000_0_07 mix_i_c000_0 win_0_07 0) relay vt1=-1m vt2=1m ropen=ropen_mix rclosed=rclosed_mix
EMIXQ_c000_0_07 (mix_q_src_c000_0_07 0 bpf_c000_0 0) vcvs gain=1.950903220161e-01
SMIXQ_c000_0_07 (mix_q_src_c000_0_07 mix_q_c000_0 win_0_07 0) relay vt1=-1m vt2=1m ropen=ropen_mix rclosed=rclosed_mix
EMIXI_c000_0_08 (mix_i_src_c000_0_08 0 bpf_c000_0 0) vcvs gain=-9.807852804032e-01
SMIXI_c000_0_08 (mix_i_src_c000_0_08 mix_i_c000_0 win_0_08 0) relay vt1=-1m vt2=1m ropen=ropen_mix rclosed=rclosed_mix
EMIXQ_c000_0_08 (mix_q_src_c000_0_08 0 bpf_c000_0 0) vcvs gain=-1.950903220161e-01
SMIXQ_c000_0_08 (mix_q_src_c000_0_08 mix_q_c000_0 win_0_08 0) relay vt1=-1m vt2=1m ropen=ropen_mix rclosed=rclosed_mix
EMIXI_c000_0_09 (mix_i_src_c000_0_09 0 bpf_c000_0 0) vcvs gain=-8.314696123025e-01
SMIXI_c000_0_09 (mix_i_src_c000_0_09 mix_i_c000_0 win_0_09 0) relay vt1=-1m vt2=1m ropen=ropen_mix rclosed=rclosed_mix
EMIXQ_c000_0_09 (mix_q_src_c000_0_09 0 bpf_c000_0 0) vcvs gain=-5.555702330196e-01
SMIXQ_c000_0_09 (mix_q_src_c000_0_09 mix_q_c000_0 win_0_09 0) relay vt1=-1m vt2=1m ropen=ropen_mix rclosed=rclosed_mix
EMIXI_c000_0_10 (mix_i_src_c000_0_10 0 bpf_c000_0 0) vcvs gain=-5.555702330196e-01
SMIXI_c000_0_10 (mix_i_src_c000_0_10 mix_i_c000_0 win_0_10 0) relay vt1=-1m vt2=1m ropen=ropen_mix rclosed=rclosed_mix
EMIXQ_c000_0_10 (mix_q_src_c000_0_10 0 bpf_c000_0 0) vcvs gain=-8.314696123025e-01
SMIXQ_c000_0_10 (mix_q_src_c000_0_10 mix_q_c000_0 win_0_10 0) relay vt1=-1m vt2=1m ropen=ropen_mix rclosed=rclosed_mix
EMIXI_c000_0_11 (mix_i_src_c000_0_11 0 bpf_c000_0 0) vcvs gain=-1.950903220161e-01
SMIXI_c000_0_11 (mix_i_src_c000_0_11 mix_i_c000_0 win_0_11 0) relay vt1=-1m vt2=1m ropen=ropen_mix rclosed=rclosed_mix
EMIXQ_c000_0_11 (mix_q_src_c000_0_11 0 bpf_c000_0 0) vcvs gain=-9.807852804032e-01
SMIXQ_c000_0_11 (mix_q_src_c000_0_11 mix_q_c000_0 win_0_11 0) relay vt1=-1m vt2=1m ropen=ropen_mix rclosed=rclosed_mix
EMIXI_c000_0_12 (mix_i_src_c000_0_12 0 bpf_c000_0 0) vcvs gain=1.950903220161e-01
SMIXI_c000_0_12 (mix_i_src_c000_0_12 mix_i_c000_0 win_0_12 0) relay vt1=-1m vt2=1m ropen=ropen_mix rclosed=rclosed_mix
EMIXQ_c000_0_12 (mix_q_src_c000_0_12 0 bpf_c000_0 0) vcvs gain=-9.807852804032e-01
SMIXQ_c000_0_12 (mix_q_src_c000_0_12 mix_q_c000_0 win_0_12 0) relay vt1=-1m vt2=1m ropen=ropen_mix rclosed=rclosed_mix
EMIXI_c000_0_13 (mix_i_src_c000_0_13 0 bpf_c000_0 0) vcvs gain=5.555702330196e-01
SMIXI_c000_0_13 (mix_i_src_c000_0_13 mix_i_c000_0 win_0_13 0) relay vt1=-1m vt2=1m ropen=ropen_mix rclosed=rclosed_mix
EMIXQ_c000_0_13 (mix_q_src_c000_0_13 0 bpf_c000_0 0) vcvs gain=-8.314696123025e-01
SMIXQ_c000_0_13 (mix_q_src_c000_0_13 mix_q_c000_0 win_0_13 0) relay vt1=-1m vt2=1m ropen=ropen_mix rclosed=rclosed_mix
EMIXI_c000_0_14 (mix_i_src_c000_0_14 0 bpf_c000_0 0) vcvs gain=8.314696123025e-01
SMIXI_c000_0_14 (mix_i_src_c000_0_14 mix_i_c000_0 win_0_14 0) relay vt1=-1m vt2=1m ropen=ropen_mix rclosed=rclosed_mix
EMIXQ_c000_0_14 (mix_q_src_c000_0_14 0 bpf_c000_0 0) vcvs gain=-5.555702330196e-01
SMIXQ_c000_0_14 (mix_q_src_c000_0_14 mix_q_c000_0 win_0_14 0) relay vt1=-1m vt2=1m ropen=ropen_mix rclosed=rclosed_mix
EMIXI_c000_0_15 (mix_i_src_c000_0_15 0 bpf_c000_0 0) vcvs gain=9.807852804032e-01
SMIXI_c000_0_15 (mix_i_src_c000_0_15 mix_i_c000_0 win_0_15 0) relay vt1=-1m vt2=1m ropen=ropen_mix rclosed=rclosed_mix
EMIXQ_c000_0_15 (mix_q_src_c000_0_15 0 bpf_c000_0 0) vcvs gain=-1.950903220161e-01
SMIXQ_c000_0_15 (mix_q_src_c000_0_15 mix_q_c000_0 win_0_15 0) relay vt1=-1m vt2=1m ropen=ropen_mix rclosed=rclosed_mix
RMIXI_c000_0 (mix_i_c000_0 0) resistor r=1G
RMIXQ_c000_0 (mix_q_c000_0 0) resistor r=1G
RINTI_c000_0 (mix_i_c000_0 Icar_c000_0) resistor r=1k
CINTI_c000_0 (Icar_c000_0 0) capacitor c=80p
RINTQ_c000_0 (mix_q_c000_0 Qcar_c000_0) resistor r=1k
CINTQ_c000_0 (Qcar_c000_0 0) capacitor c=80p
save bpf_c000_0 Icar_c000_0 Qcar_c000_0

// bl000, carrier_1: 500000000 Hz coherent I/Q phase-window verification-demod path
CBPF_c000_1 (bl000 n_cbpf_c000_1) capacitor c=1.013211836423e-13
LBPF_c000_1 (n_cbpf_c000_1 bpf_c000_1) inductor l=1.000000000000e-06
RBPF_c000_1 (bpf_c000_1 0) resistor r=1.570796326795e+02
EMIXI_c000_1_00 (mix_i_src_c000_1_00 0 bpf_c000_1 0) vcvs gain=9.807852804032e-01
SMIXI_c000_1_00 (mix_i_src_c000_1_00 mix_i_c000_1 win_1_00 0) relay vt1=-1m vt2=1m ropen=ropen_mix rclosed=rclosed_mix
EMIXQ_c000_1_00 (mix_q_src_c000_1_00 0 bpf_c000_1 0) vcvs gain=1.950903220161e-01
SMIXQ_c000_1_00 (mix_q_src_c000_1_00 mix_q_c000_1 win_1_00 0) relay vt1=-1m vt2=1m ropen=ropen_mix rclosed=rclosed_mix
EMIXI_c000_1_01 (mix_i_src_c000_1_01 0 bpf_c000_1 0) vcvs gain=8.314696123025e-01
SMIXI_c000_1_01 (mix_i_src_c000_1_01 mix_i_c000_1 win_1_01 0) relay vt1=-1m vt2=1m ropen=ropen_mix rclosed=rclosed_mix
EMIXQ_c000_1_01 (mix_q_src_c000_1_01 0 bpf_c000_1 0) vcvs gain=5.555702330196e-01
SMIXQ_c000_1_01 (mix_q_src_c000_1_01 mix_q_c000_1 win_1_01 0) relay vt1=-1m vt2=1m ropen=ropen_mix rclosed=rclosed_mix
EMIXI_c000_1_02 (mix_i_src_c000_1_02 0 bpf_c000_1 0) vcvs gain=5.555702330196e-01
SMIXI_c000_1_02 (mix_i_src_c000_1_02 mix_i_c000_1 win_1_02 0) relay vt1=-1m vt2=1m ropen=ropen_mix rclosed=rclosed_mix
EMIXQ_c000_1_02 (mix_q_src_c000_1_02 0 bpf_c000_1 0) vcvs gain=8.314696123025e-01
SMIXQ_c000_1_02 (mix_q_src_c000_1_02 mix_q_c000_1 win_1_02 0) relay vt1=-1m vt2=1m ropen=ropen_mix rclosed=rclosed_mix
EMIXI_c000_1_03 (mix_i_src_c000_1_03 0 bpf_c000_1 0) vcvs gain=1.950903220161e-01
SMIXI_c000_1_03 (mix_i_src_c000_1_03 mix_i_c000_1 win_1_03 0) relay vt1=-1m vt2=1m ropen=ropen_mix rclosed=rclosed_mix
EMIXQ_c000_1_03 (mix_q_src_c000_1_03 0 bpf_c000_1 0) vcvs gain=9.807852804032e-01
SMIXQ_c000_1_03 (mix_q_src_c000_1_03 mix_q_c000_1 win_1_03 0) relay vt1=-1m vt2=1m ropen=ropen_mix rclosed=rclosed_mix
EMIXI_c000_1_04 (mix_i_src_c000_1_04 0 bpf_c000_1 0) vcvs gain=-1.950903220161e-01
SMIXI_c000_1_04 (mix_i_src_c000_1_04 mix_i_c000_1 win_1_04 0) relay vt1=-1m vt2=1m ropen=ropen_mix rclosed=rclosed_mix
EMIXQ_c000_1_04 (mix_q_src_c000_1_04 0 bpf_c000_1 0) vcvs gain=9.807852804032e-01
SMIXQ_c000_1_04 (mix_q_src_c000_1_04 mix_q_c000_1 win_1_04 0) relay vt1=-1m vt2=1m ropen=ropen_mix rclosed=rclosed_mix
EMIXI_c000_1_05 (mix_i_src_c000_1_05 0 bpf_c000_1 0) vcvs gain=-5.555702330196e-01
SMIXI_c000_1_05 (mix_i_src_c000_1_05 mix_i_c000_1 win_1_05 0) relay vt1=-1m vt2=1m ropen=ropen_mix rclosed=rclosed_mix
EMIXQ_c000_1_05 (mix_q_src_c000_1_05 0 bpf_c000_1 0) vcvs gain=8.314696123025e-01
SMIXQ_c000_1_05 (mix_q_src_c000_1_05 mix_q_c000_1 win_1_05 0) relay vt1=-1m vt2=1m ropen=ropen_mix rclosed=rclosed_mix
EMIXI_c000_1_06 (mix_i_src_c000_1_06 0 bpf_c000_1 0) vcvs gain=-8.314696123025e-01
SMIXI_c000_1_06 (mix_i_src_c000_1_06 mix_i_c000_1 win_1_06 0) relay vt1=-1m vt2=1m ropen=ropen_mix rclosed=rclosed_mix
EMIXQ_c000_1_06 (mix_q_src_c000_1_06 0 bpf_c000_1 0) vcvs gain=5.555702330196e-01
SMIXQ_c000_1_06 (mix_q_src_c000_1_06 mix_q_c000_1 win_1_06 0) relay vt1=-1m vt2=1m ropen=ropen_mix rclosed=rclosed_mix
EMIXI_c000_1_07 (mix_i_src_c000_1_07 0 bpf_c000_1 0) vcvs gain=-9.807852804032e-01
SMIXI_c000_1_07 (mix_i_src_c000_1_07 mix_i_c000_1 win_1_07 0) relay vt1=-1m vt2=1m ropen=ropen_mix rclosed=rclosed_mix
EMIXQ_c000_1_07 (mix_q_src_c000_1_07 0 bpf_c000_1 0) vcvs gain=1.950903220161e-01
SMIXQ_c000_1_07 (mix_q_src_c000_1_07 mix_q_c000_1 win_1_07 0) relay vt1=-1m vt2=1m ropen=ropen_mix rclosed=rclosed_mix
EMIXI_c000_1_08 (mix_i_src_c000_1_08 0 bpf_c000_1 0) vcvs gain=-9.807852804032e-01
SMIXI_c000_1_08 (mix_i_src_c000_1_08 mix_i_c000_1 win_1_08 0) relay vt1=-1m vt2=1m ropen=ropen_mix rclosed=rclosed_mix
EMIXQ_c000_1_08 (mix_q_src_c000_1_08 0 bpf_c000_1 0) vcvs gain=-1.950903220161e-01
SMIXQ_c000_1_08 (mix_q_src_c000_1_08 mix_q_c000_1 win_1_08 0) relay vt1=-1m vt2=1m ropen=ropen_mix rclosed=rclosed_mix
EMIXI_c000_1_09 (mix_i_src_c000_1_09 0 bpf_c000_1 0) vcvs gain=-8.314696123025e-01
SMIXI_c000_1_09 (mix_i_src_c000_1_09 mix_i_c000_1 win_1_09 0) relay vt1=-1m vt2=1m ropen=ropen_mix rclosed=rclosed_mix
EMIXQ_c000_1_09 (mix_q_src_c000_1_09 0 bpf_c000_1 0) vcvs gain=-5.555702330196e-01
SMIXQ_c000_1_09 (mix_q_src_c000_1_09 mix_q_c000_1 win_1_09 0) relay vt1=-1m vt2=1m ropen=ropen_mix rclosed=rclosed_mix
EMIXI_c000_1_10 (mix_i_src_c000_1_10 0 bpf_c000_1 0) vcvs gain=-5.555702330196e-01
SMIXI_c000_1_10 (mix_i_src_c000_1_10 mix_i_c000_1 win_1_10 0) relay vt1=-1m vt2=1m ropen=ropen_mix rclosed=rclosed_mix
EMIXQ_c000_1_10 (mix_q_src_c000_1_10 0 bpf_c000_1 0) vcvs gain=-8.314696123025e-01
SMIXQ_c000_1_10 (mix_q_src_c000_1_10 mix_q_c000_1 win_1_10 0) relay vt1=-1m vt2=1m ropen=ropen_mix rclosed=rclosed_mix
EMIXI_c000_1_11 (mix_i_src_c000_1_11 0 bpf_c000_1 0) vcvs gain=-1.950903220161e-01
SMIXI_c000_1_11 (mix_i_src_c000_1_11 mix_i_c000_1 win_1_11 0) relay vt1=-1m vt2=1m ropen=ropen_mix rclosed=rclosed_mix
EMIXQ_c000_1_11 (mix_q_src_c000_1_11 0 bpf_c000_1 0) vcvs gain=-9.807852804032e-01
SMIXQ_c000_1_11 (mix_q_src_c000_1_11 mix_q_c000_1 win_1_11 0) relay vt1=-1m vt2=1m ropen=ropen_mix rclosed=rclosed_mix
EMIXI_c000_1_12 (mix_i_src_c000_1_12 0 bpf_c000_1 0) vcvs gain=1.950903220161e-01
SMIXI_c000_1_12 (mix_i_src_c000_1_12 mix_i_c000_1 win_1_12 0) relay vt1=-1m vt2=1m ropen=ropen_mix rclosed=rclosed_mix
EMIXQ_c000_1_12 (mix_q_src_c000_1_12 0 bpf_c000_1 0) vcvs gain=-9.807852804032e-01
SMIXQ_c000_1_12 (mix_q_src_c000_1_12 mix_q_c000_1 win_1_12 0) relay vt1=-1m vt2=1m ropen=ropen_mix rclosed=rclosed_mix
EMIXI_c000_1_13 (mix_i_src_c000_1_13 0 bpf_c000_1 0) vcvs gain=5.555702330196e-01
SMIXI_c000_1_13 (mix_i_src_c000_1_13 mix_i_c000_1 win_1_13 0) relay vt1=-1m vt2=1m ropen=ropen_mix rclosed=rclosed_mix
EMIXQ_c000_1_13 (mix_q_src_c000_1_13 0 bpf_c000_1 0) vcvs gain=-8.314696123025e-01
SMIXQ_c000_1_13 (mix_q_src_c000_1_13 mix_q_c000_1 win_1_13 0) relay vt1=-1m vt2=1m ropen=ropen_mix rclosed=rclosed_mix
EMIXI_c000_1_14 (mix_i_src_c000_1_14 0 bpf_c000_1 0) vcvs gain=8.314696123025e-01
SMIXI_c000_1_14 (mix_i_src_c000_1_14 mix_i_c000_1 win_1_14 0) relay vt1=-1m vt2=1m ropen=ropen_mix rclosed=rclosed_mix
EMIXQ_c000_1_14 (mix_q_src_c000_1_14 0 bpf_c000_1 0) vcvs gain=-5.555702330196e-01
SMIXQ_c000_1_14 (mix_q_src_c000_1_14 mix_q_c000_1 win_1_14 0) relay vt1=-1m vt2=1m ropen=ropen_mix rclosed=rclosed_mix
EMIXI_c000_1_15 (mix_i_src_c000_1_15 0 bpf_c000_1 0) vcvs gain=9.807852804032e-01
SMIXI_c000_1_15 (mix_i_src_c000_1_15 mix_i_c000_1 win_1_15 0) relay vt1=-1m vt2=1m ropen=ropen_mix rclosed=rclosed_mix
EMIXQ_c000_1_15 (mix_q_src_c000_1_15 0 bpf_c000_1 0) vcvs gain=-1.950903220161e-01
SMIXQ_c000_1_15 (mix_q_src_c000_1_15 mix_q_c000_1 win_1_15 0) relay vt1=-1m vt2=1m ropen=ropen_mix rclosed=rclosed_mix
RMIXI_c000_1 (mix_i_c000_1 0) resistor r=1G
RMIXQ_c000_1 (mix_q_c000_1 0) resistor r=1G
RINTI_c000_1 (mix_i_c000_1 Icar_c000_1) resistor r=1k
CINTI_c000_1 (Icar_c000_1 0) capacitor c=80p
RINTQ_c000_1 (mix_q_c000_1 Qcar_c000_1) resistor r=1k
CINTQ_c000_1 (Qcar_c000_1 0) capacitor c=80p
save bpf_c000_1 Icar_c000_1 Qcar_c000_1

// bl000, carrier_2: 750000000 Hz coherent I/Q phase-window verification-demod path
CBPF_c000_2 (bl000 n_cbpf_c000_2) capacitor c=4.503163717437e-14
LBPF_c000_2 (n_cbpf_c000_2 bpf_c000_2) inductor l=1.000000000000e-06
RBPF_c000_2 (bpf_c000_2 0) resistor r=2.356194490192e+02
EMIXI_c000_2_00 (mix_i_src_c000_2_00 0 bpf_c000_2 0) vcvs gain=9.807852804032e-01
SMIXI_c000_2_00 (mix_i_src_c000_2_00 mix_i_c000_2 win_2_00 0) relay vt1=-1m vt2=1m ropen=ropen_mix rclosed=rclosed_mix
EMIXQ_c000_2_00 (mix_q_src_c000_2_00 0 bpf_c000_2 0) vcvs gain=1.950903220161e-01
SMIXQ_c000_2_00 (mix_q_src_c000_2_00 mix_q_c000_2 win_2_00 0) relay vt1=-1m vt2=1m ropen=ropen_mix rclosed=rclosed_mix
EMIXI_c000_2_01 (mix_i_src_c000_2_01 0 bpf_c000_2 0) vcvs gain=8.314696123025e-01
SMIXI_c000_2_01 (mix_i_src_c000_2_01 mix_i_c000_2 win_2_01 0) relay vt1=-1m vt2=1m ropen=ropen_mix rclosed=rclosed_mix
EMIXQ_c000_2_01 (mix_q_src_c000_2_01 0 bpf_c000_2 0) vcvs gain=5.555702330196e-01
SMIXQ_c000_2_01 (mix_q_src_c000_2_01 mix_q_c000_2 win_2_01 0) relay vt1=-1m vt2=1m ropen=ropen_mix rclosed=rclosed_mix
EMIXI_c000_2_02 (mix_i_src_c000_2_02 0 bpf_c000_2 0) vcvs gain=5.555702330196e-01
SMIXI_c000_2_02 (mix_i_src_c000_2_02 mix_i_c000_2 win_2_02 0) relay vt1=-1m vt2=1m ropen=ropen_mix rclosed=rclosed_mix
EMIXQ_c000_2_02 (mix_q_src_c000_2_02 0 bpf_c000_2 0) vcvs gain=8.314696123025e-01
SMIXQ_c000_2_02 (mix_q_src_c000_2_02 mix_q_c000_2 win_2_02 0) relay vt1=-1m vt2=1m ropen=ropen_mix rclosed=rclosed_mix
EMIXI_c000_2_03 (mix_i_src_c000_2_03 0 bpf_c000_2 0) vcvs gain=1.950903220161e-01
SMIXI_c000_2_03 (mix_i_src_c000_2_03 mix_i_c000_2 win_2_03 0) relay vt1=-1m vt2=1m ropen=ropen_mix rclosed=rclosed_mix
EMIXQ_c000_2_03 (mix_q_src_c000_2_03 0 bpf_c000_2 0) vcvs gain=9.807852804032e-01
SMIXQ_c000_2_03 (mix_q_src_c000_2_03 mix_q_c000_2 win_2_03 0) relay vt1=-1m vt2=1m ropen=ropen_mix rclosed=rclosed_mix
EMIXI_c000_2_04 (mix_i_src_c000_2_04 0 bpf_c000_2 0) vcvs gain=-1.950903220161e-01
SMIXI_c000_2_04 (mix_i_src_c000_2_04 mix_i_c000_2 win_2_04 0) relay vt1=-1m vt2=1m ropen=ropen_mix rclosed=rclosed_mix
EMIXQ_c000_2_04 (mix_q_src_c000_2_04 0 bpf_c000_2 0) vcvs gain=9.807852804032e-01
SMIXQ_c000_2_04 (mix_q_src_c000_2_04 mix_q_c000_2 win_2_04 0) relay vt1=-1m vt2=1m ropen=ropen_mix rclosed=rclosed_mix
EMIXI_c000_2_05 (mix_i_src_c000_2_05 0 bpf_c000_2 0) vcvs gain=-5.555702330196e-01
SMIXI_c000_2_05 (mix_i_src_c000_2_05 mix_i_c000_2 win_2_05 0) relay vt1=-1m vt2=1m ropen=ropen_mix rclosed=rclosed_mix
EMIXQ_c000_2_05 (mix_q_src_c000_2_05 0 bpf_c000_2 0) vcvs gain=8.314696123025e-01
SMIXQ_c000_2_05 (mix_q_src_c000_2_05 mix_q_c000_2 win_2_05 0) relay vt1=-1m vt2=1m ropen=ropen_mix rclosed=rclosed_mix
EMIXI_c000_2_06 (mix_i_src_c000_2_06 0 bpf_c000_2 0) vcvs gain=-8.314696123025e-01
SMIXI_c000_2_06 (mix_i_src_c000_2_06 mix_i_c000_2 win_2_06 0) relay vt1=-1m vt2=1m ropen=ropen_mix rclosed=rclosed_mix
EMIXQ_c000_2_06 (mix_q_src_c000_2_06 0 bpf_c000_2 0) vcvs gain=5.555702330196e-01
SMIXQ_c000_2_06 (mix_q_src_c000_2_06 mix_q_c000_2 win_2_06 0) relay vt1=-1m vt2=1m ropen=ropen_mix rclosed=rclosed_mix
EMIXI_c000_2_07 (mix_i_src_c000_2_07 0 bpf_c000_2 0) vcvs gain=-9.807852804032e-01
SMIXI_c000_2_07 (mix_i_src_c000_2_07 mix_i_c000_2 win_2_07 0) relay vt1=-1m vt2=1m ropen=ropen_mix rclosed=rclosed_mix
EMIXQ_c000_2_07 (mix_q_src_c000_2_07 0 bpf_c000_2 0) vcvs gain=1.950903220161e-01
SMIXQ_c000_2_07 (mix_q_src_c000_2_07 mix_q_c000_2 win_2_07 0) relay vt1=-1m vt2=1m ropen=ropen_mix rclosed=rclosed_mix
EMIXI_c000_2_08 (mix_i_src_c000_2_08 0 bpf_c000_2 0) vcvs gain=-9.807852804032e-01
SMIXI_c000_2_08 (mix_i_src_c000_2_08 mix_i_c000_2 win_2_08 0) relay vt1=-1m vt2=1m ropen=ropen_mix rclosed=rclosed_mix
EMIXQ_c000_2_08 (mix_q_src_c000_2_08 0 bpf_c000_2 0) vcvs gain=-1.950903220161e-01
SMIXQ_c000_2_08 (mix_q_src_c000_2_08 mix_q_c000_2 win_2_08 0) relay vt1=-1m vt2=1m ropen=ropen_mix rclosed=rclosed_mix
EMIXI_c000_2_09 (mix_i_src_c000_2_09 0 bpf_c000_2 0) vcvs gain=-8.314696123025e-01
SMIXI_c000_2_09 (mix_i_src_c000_2_09 mix_i_c000_2 win_2_09 0) relay vt1=-1m vt2=1m ropen=ropen_mix rclosed=rclosed_mix
EMIXQ_c000_2_09 (mix_q_src_c000_2_09 0 bpf_c000_2 0) vcvs gain=-5.555702330196e-01
SMIXQ_c000_2_09 (mix_q_src_c000_2_09 mix_q_c000_2 win_2_09 0) relay vt1=-1m vt2=1m ropen=ropen_mix rclosed=rclosed_mix
EMIXI_c000_2_10 (mix_i_src_c000_2_10 0 bpf_c000_2 0) vcvs gain=-5.555702330196e-01
SMIXI_c000_2_10 (mix_i_src_c000_2_10 mix_i_c000_2 win_2_10 0) relay vt1=-1m vt2=1m ropen=ropen_mix rclosed=rclosed_mix
EMIXQ_c000_2_10 (mix_q_src_c000_2_10 0 bpf_c000_2 0) vcvs gain=-8.314696123025e-01
SMIXQ_c000_2_10 (mix_q_src_c000_2_10 mix_q_c000_2 win_2_10 0) relay vt1=-1m vt2=1m ropen=ropen_mix rclosed=rclosed_mix
EMIXI_c000_2_11 (mix_i_src_c000_2_11 0 bpf_c000_2 0) vcvs gain=-1.950903220161e-01
SMIXI_c000_2_11 (mix_i_src_c000_2_11 mix_i_c000_2 win_2_11 0) relay vt1=-1m vt2=1m ropen=ropen_mix rclosed=rclosed_mix
EMIXQ_c000_2_11 (mix_q_src_c000_2_11 0 bpf_c000_2 0) vcvs gain=-9.807852804032e-01
SMIXQ_c000_2_11 (mix_q_src_c000_2_11 mix_q_c000_2 win_2_11 0) relay vt1=-1m vt2=1m ropen=ropen_mix rclosed=rclosed_mix
EMIXI_c000_2_12 (mix_i_src_c000_2_12 0 bpf_c000_2 0) vcvs gain=1.950903220161e-01
SMIXI_c000_2_12 (mix_i_src_c000_2_12 mix_i_c000_2 win_2_12 0) relay vt1=-1m vt2=1m ropen=ropen_mix rclosed=rclosed_mix
EMIXQ_c000_2_12 (mix_q_src_c000_2_12 0 bpf_c000_2 0) vcvs gain=-9.807852804032e-01
SMIXQ_c000_2_12 (mix_q_src_c000_2_12 mix_q_c000_2 win_2_12 0) relay vt1=-1m vt2=1m ropen=ropen_mix rclosed=rclosed_mix
EMIXI_c000_2_13 (mix_i_src_c000_2_13 0 bpf_c000_2 0) vcvs gain=5.555702330196e-01
SMIXI_c000_2_13 (mix_i_src_c000_2_13 mix_i_c000_2 win_2_13 0) relay vt1=-1m vt2=1m ropen=ropen_mix rclosed=rclosed_mix
EMIXQ_c000_2_13 (mix_q_src_c000_2_13 0 bpf_c000_2 0) vcvs gain=-8.314696123025e-01
SMIXQ_c000_2_13 (mix_q_src_c000_2_13 mix_q_c000_2 win_2_13 0) relay vt1=-1m vt2=1m ropen=ropen_mix rclosed=rclosed_mix
EMIXI_c000_2_14 (mix_i_src_c000_2_14 0 bpf_c000_2 0) vcvs gain=8.314696123025e-01
SMIXI_c000_2_14 (mix_i_src_c000_2_14 mix_i_c000_2 win_2_14 0) relay vt1=-1m vt2=1m ropen=ropen_mix rclosed=rclosed_mix
EMIXQ_c000_2_14 (mix_q_src_c000_2_14 0 bpf_c000_2 0) vcvs gain=-5.555702330196e-01
SMIXQ_c000_2_14 (mix_q_src_c000_2_14 mix_q_c000_2 win_2_14 0) relay vt1=-1m vt2=1m ropen=ropen_mix rclosed=rclosed_mix
EMIXI_c000_2_15 (mix_i_src_c000_2_15 0 bpf_c000_2 0) vcvs gain=9.807852804032e-01
SMIXI_c000_2_15 (mix_i_src_c000_2_15 mix_i_c000_2 win_2_15 0) relay vt1=-1m vt2=1m ropen=ropen_mix rclosed=rclosed_mix
EMIXQ_c000_2_15 (mix_q_src_c000_2_15 0 bpf_c000_2 0) vcvs gain=-1.950903220161e-01
SMIXQ_c000_2_15 (mix_q_src_c000_2_15 mix_q_c000_2 win_2_15 0) relay vt1=-1m vt2=1m ropen=ropen_mix rclosed=rclosed_mix
RMIXI_c000_2 (mix_i_c000_2 0) resistor r=1G
RMIXQ_c000_2 (mix_q_c000_2 0) resistor r=1G
RINTI_c000_2 (mix_i_c000_2 Icar_c000_2) resistor r=1k
CINTI_c000_2 (Icar_c000_2 0) capacitor c=80p
RINTQ_c000_2 (mix_q_c000_2 Qcar_c000_2) resistor r=1k
CINTQ_c000_2 (Qcar_c000_2 0) capacitor c=80p
save bpf_c000_2 Icar_c000_2 Qcar_c000_2

// bl000, carrier_3: 1000000000 Hz coherent I/Q phase-window verification-demod path
CBPF_c000_3 (bl000 n_cbpf_c000_3) capacitor c=2.533029591058e-14
LBPF_c000_3 (n_cbpf_c000_3 bpf_c000_3) inductor l=1.000000000000e-06
RBPF_c000_3 (bpf_c000_3 0) resistor r=3.141592653590e+02
EMIXI_c000_3_00 (mix_i_src_c000_3_00 0 bpf_c000_3 0) vcvs gain=9.807852804032e-01
SMIXI_c000_3_00 (mix_i_src_c000_3_00 mix_i_c000_3 win_3_00 0) relay vt1=-1m vt2=1m ropen=ropen_mix rclosed=rclosed_mix
EMIXQ_c000_3_00 (mix_q_src_c000_3_00 0 bpf_c000_3 0) vcvs gain=1.950903220161e-01
SMIXQ_c000_3_00 (mix_q_src_c000_3_00 mix_q_c000_3 win_3_00 0) relay vt1=-1m vt2=1m ropen=ropen_mix rclosed=rclosed_mix
EMIXI_c000_3_01 (mix_i_src_c000_3_01 0 bpf_c000_3 0) vcvs gain=8.314696123025e-01
SMIXI_c000_3_01 (mix_i_src_c000_3_01 mix_i_c000_3 win_3_01 0) relay vt1=-1m vt2=1m ropen=ropen_mix rclosed=rclosed_mix
EMIXQ_c000_3_01 (mix_q_src_c000_3_01 0 bpf_c000_3 0) vcvs gain=5.555702330196e-01
SMIXQ_c000_3_01 (mix_q_src_c000_3_01 mix_q_c000_3 win_3_01 0) relay vt1=-1m vt2=1m ropen=ropen_mix rclosed=rclosed_mix
EMIXI_c000_3_02 (mix_i_src_c000_3_02 0 bpf_c000_3 0) vcvs gain=5.555702330196e-01
SMIXI_c000_3_02 (mix_i_src_c000_3_02 mix_i_c000_3 win_3_02 0) relay vt1=-1m vt2=1m ropen=ropen_mix rclosed=rclosed_mix
EMIXQ_c000_3_02 (mix_q_src_c000_3_02 0 bpf_c000_3 0) vcvs gain=8.314696123025e-01
SMIXQ_c000_3_02 (mix_q_src_c000_3_02 mix_q_c000_3 win_3_02 0) relay vt1=-1m vt2=1m ropen=ropen_mix rclosed=rclosed_mix
EMIXI_c000_3_03 (mix_i_src_c000_3_03 0 bpf_c000_3 0) vcvs gain=1.950903220161e-01
SMIXI_c000_3_03 (mix_i_src_c000_3_03 mix_i_c000_3 win_3_03 0) relay vt1=-1m vt2=1m ropen=ropen_mix rclosed=rclosed_mix
EMIXQ_c000_3_03 (mix_q_src_c000_3_03 0 bpf_c000_3 0) vcvs gain=9.807852804032e-01
SMIXQ_c000_3_03 (mix_q_src_c000_3_03 mix_q_c000_3 win_3_03 0) relay vt1=-1m vt2=1m ropen=ropen_mix rclosed=rclosed_mix
EMIXI_c000_3_04 (mix_i_src_c000_3_04 0 bpf_c000_3 0) vcvs gain=-1.950903220161e-01
SMIXI_c000_3_04 (mix_i_src_c000_3_04 mix_i_c000_3 win_3_04 0) relay vt1=-1m vt2=1m ropen=ropen_mix rclosed=rclosed_mix
EMIXQ_c000_3_04 (mix_q_src_c000_3_04 0 bpf_c000_3 0) vcvs gain=9.807852804032e-01
SMIXQ_c000_3_04 (mix_q_src_c000_3_04 mix_q_c000_3 win_3_04 0) relay vt1=-1m vt2=1m ropen=ropen_mix rclosed=rclosed_mix
EMIXI_c000_3_05 (mix_i_src_c000_3_05 0 bpf_c000_3 0) vcvs gain=-5.555702330196e-01
SMIXI_c000_3_05 (mix_i_src_c000_3_05 mix_i_c000_3 win_3_05 0) relay vt1=-1m vt2=1m ropen=ropen_mix rclosed=rclosed_mix
EMIXQ_c000_3_05 (mix_q_src_c000_3_05 0 bpf_c000_3 0) vcvs gain=8.314696123025e-01
SMIXQ_c000_3_05 (mix_q_src_c000_3_05 mix_q_c000_3 win_3_05 0) relay vt1=-1m vt2=1m ropen=ropen_mix rclosed=rclosed_mix
EMIXI_c000_3_06 (mix_i_src_c000_3_06 0 bpf_c000_3 0) vcvs gain=-8.314696123025e-01
SMIXI_c000_3_06 (mix_i_src_c000_3_06 mix_i_c000_3 win_3_06 0) relay vt1=-1m vt2=1m ropen=ropen_mix rclosed=rclosed_mix
EMIXQ_c000_3_06 (mix_q_src_c000_3_06 0 bpf_c000_3 0) vcvs gain=5.555702330196e-01
SMIXQ_c000_3_06 (mix_q_src_c000_3_06 mix_q_c000_3 win_3_06 0) relay vt1=-1m vt2=1m ropen=ropen_mix rclosed=rclosed_mix
EMIXI_c000_3_07 (mix_i_src_c000_3_07 0 bpf_c000_3 0) vcvs gain=-9.807852804032e-01
SMIXI_c000_3_07 (mix_i_src_c000_3_07 mix_i_c000_3 win_3_07 0) relay vt1=-1m vt2=1m ropen=ropen_mix rclosed=rclosed_mix
EMIXQ_c000_3_07 (mix_q_src_c000_3_07 0 bpf_c000_3 0) vcvs gain=1.950903220161e-01
SMIXQ_c000_3_07 (mix_q_src_c000_3_07 mix_q_c000_3 win_3_07 0) relay vt1=-1m vt2=1m ropen=ropen_mix rclosed=rclosed_mix
EMIXI_c000_3_08 (mix_i_src_c000_3_08 0 bpf_c000_3 0) vcvs gain=-9.807852804032e-01
SMIXI_c000_3_08 (mix_i_src_c000_3_08 mix_i_c000_3 win_3_08 0) relay vt1=-1m vt2=1m ropen=ropen_mix rclosed=rclosed_mix
EMIXQ_c000_3_08 (mix_q_src_c000_3_08 0 bpf_c000_3 0) vcvs gain=-1.950903220161e-01
SMIXQ_c000_3_08 (mix_q_src_c000_3_08 mix_q_c000_3 win_3_08 0) relay vt1=-1m vt2=1m ropen=ropen_mix rclosed=rclosed_mix
EMIXI_c000_3_09 (mix_i_src_c000_3_09 0 bpf_c000_3 0) vcvs gain=-8.314696123025e-01
SMIXI_c000_3_09 (mix_i_src_c000_3_09 mix_i_c000_3 win_3_09 0) relay vt1=-1m vt2=1m ropen=ropen_mix rclosed=rclosed_mix
EMIXQ_c000_3_09 (mix_q_src_c000_3_09 0 bpf_c000_3 0) vcvs gain=-5.555702330196e-01
SMIXQ_c000_3_09 (mix_q_src_c000_3_09 mix_q_c000_3 win_3_09 0) relay vt1=-1m vt2=1m ropen=ropen_mix rclosed=rclosed_mix
EMIXI_c000_3_10 (mix_i_src_c000_3_10 0 bpf_c000_3 0) vcvs gain=-5.555702330196e-01
SMIXI_c000_3_10 (mix_i_src_c000_3_10 mix_i_c000_3 win_3_10 0) relay vt1=-1m vt2=1m ropen=ropen_mix rclosed=rclosed_mix
EMIXQ_c000_3_10 (mix_q_src_c000_3_10 0 bpf_c000_3 0) vcvs gain=-8.314696123025e-01
SMIXQ_c000_3_10 (mix_q_src_c000_3_10 mix_q_c000_3 win_3_10 0) relay vt1=-1m vt2=1m ropen=ropen_mix rclosed=rclosed_mix
EMIXI_c000_3_11 (mix_i_src_c000_3_11 0 bpf_c000_3 0) vcvs gain=-1.950903220161e-01
SMIXI_c000_3_11 (mix_i_src_c000_3_11 mix_i_c000_3 win_3_11 0) relay vt1=-1m vt2=1m ropen=ropen_mix rclosed=rclosed_mix
EMIXQ_c000_3_11 (mix_q_src_c000_3_11 0 bpf_c000_3 0) vcvs gain=-9.807852804032e-01
SMIXQ_c000_3_11 (mix_q_src_c000_3_11 mix_q_c000_3 win_3_11 0) relay vt1=-1m vt2=1m ropen=ropen_mix rclosed=rclosed_mix
EMIXI_c000_3_12 (mix_i_src_c000_3_12 0 bpf_c000_3 0) vcvs gain=1.950903220161e-01
SMIXI_c000_3_12 (mix_i_src_c000_3_12 mix_i_c000_3 win_3_12 0) relay vt1=-1m vt2=1m ropen=ropen_mix rclosed=rclosed_mix
EMIXQ_c000_3_12 (mix_q_src_c000_3_12 0 bpf_c000_3 0) vcvs gain=-9.807852804032e-01
SMIXQ_c000_3_12 (mix_q_src_c000_3_12 mix_q_c000_3 win_3_12 0) relay vt1=-1m vt2=1m ropen=ropen_mix rclosed=rclosed_mix
EMIXI_c000_3_13 (mix_i_src_c000_3_13 0 bpf_c000_3 0) vcvs gain=5.555702330196e-01
SMIXI_c000_3_13 (mix_i_src_c000_3_13 mix_i_c000_3 win_3_13 0) relay vt1=-1m vt2=1m ropen=ropen_mix rclosed=rclosed_mix
EMIXQ_c000_3_13 (mix_q_src_c000_3_13 0 bpf_c000_3 0) vcvs gain=-8.314696123025e-01
SMIXQ_c000_3_13 (mix_q_src_c000_3_13 mix_q_c000_3 win_3_13 0) relay vt1=-1m vt2=1m ropen=ropen_mix rclosed=rclosed_mix
EMIXI_c000_3_14 (mix_i_src_c000_3_14 0 bpf_c000_3 0) vcvs gain=8.314696123025e-01
SMIXI_c000_3_14 (mix_i_src_c000_3_14 mix_i_c000_3 win_3_14 0) relay vt1=-1m vt2=1m ropen=ropen_mix rclosed=rclosed_mix
EMIXQ_c000_3_14 (mix_q_src_c000_3_14 0 bpf_c000_3 0) vcvs gain=-5.555702330196e-01
SMIXQ_c000_3_14 (mix_q_src_c000_3_14 mix_q_c000_3 win_3_14 0) relay vt1=-1m vt2=1m ropen=ropen_mix rclosed=rclosed_mix
EMIXI_c000_3_15 (mix_i_src_c000_3_15 0 bpf_c000_3 0) vcvs gain=9.807852804032e-01
SMIXI_c000_3_15 (mix_i_src_c000_3_15 mix_i_c000_3 win_3_15 0) relay vt1=-1m vt2=1m ropen=ropen_mix rclosed=rclosed_mix
EMIXQ_c000_3_15 (mix_q_src_c000_3_15 0 bpf_c000_3 0) vcvs gain=-1.950903220161e-01
SMIXQ_c000_3_15 (mix_q_src_c000_3_15 mix_q_c000_3 win_3_15 0) relay vt1=-1m vt2=1m ropen=ropen_mix rclosed=rclosed_mix
RMIXI_c000_3 (mix_i_c000_3 0) resistor r=1G
RMIXQ_c000_3 (mix_q_c000_3 0) resistor r=1G
RINTI_c000_3 (mix_i_c000_3 Icar_c000_3) resistor r=1k
CINTI_c000_3 (Icar_c000_3 0) capacitor c=80p
RINTQ_c000_3 (mix_q_c000_3 Qcar_c000_3) resistor r=1k
CINTQ_c000_3 (Qcar_c000_3 0) capacitor c=80p
save bpf_c000_3 Icar_c000_3 Qcar_c000_3

// bl001, carrier_0: 250000000 Hz coherent I/Q phase-window verification-demod path
CBPF_c001_0 (bl001 n_cbpf_c001_0) capacitor c=4.052847345694e-13
LBPF_c001_0 (n_cbpf_c001_0 bpf_c001_0) inductor l=1.000000000000e-06
RBPF_c001_0 (bpf_c001_0 0) resistor r=7.853981633974e+01
EMIXI_c001_0_00 (mix_i_src_c001_0_00 0 bpf_c001_0 0) vcvs gain=9.807852804032e-01
SMIXI_c001_0_00 (mix_i_src_c001_0_00 mix_i_c001_0 win_0_00 0) relay vt1=-1m vt2=1m ropen=ropen_mix rclosed=rclosed_mix
EMIXQ_c001_0_00 (mix_q_src_c001_0_00 0 bpf_c001_0 0) vcvs gain=1.950903220161e-01
SMIXQ_c001_0_00 (mix_q_src_c001_0_00 mix_q_c001_0 win_0_00 0) relay vt1=-1m vt2=1m ropen=ropen_mix rclosed=rclosed_mix
EMIXI_c001_0_01 (mix_i_src_c001_0_01 0 bpf_c001_0 0) vcvs gain=8.314696123025e-01
SMIXI_c001_0_01 (mix_i_src_c001_0_01 mix_i_c001_0 win_0_01 0) relay vt1=-1m vt2=1m ropen=ropen_mix rclosed=rclosed_mix
EMIXQ_c001_0_01 (mix_q_src_c001_0_01 0 bpf_c001_0 0) vcvs gain=5.555702330196e-01
SMIXQ_c001_0_01 (mix_q_src_c001_0_01 mix_q_c001_0 win_0_01 0) relay vt1=-1m vt2=1m ropen=ropen_mix rclosed=rclosed_mix
EMIXI_c001_0_02 (mix_i_src_c001_0_02 0 bpf_c001_0 0) vcvs gain=5.555702330196e-01
SMIXI_c001_0_02 (mix_i_src_c001_0_02 mix_i_c001_0 win_0_02 0) relay vt1=-1m vt2=1m ropen=ropen_mix rclosed=rclosed_mix
EMIXQ_c001_0_02 (mix_q_src_c001_0_02 0 bpf_c001_0 0) vcvs gain=8.314696123025e-01
SMIXQ_c001_0_02 (mix_q_src_c001_0_02 mix_q_c001_0 win_0_02 0) relay vt1=-1m vt2=1m ropen=ropen_mix rclosed=rclosed_mix
EMIXI_c001_0_03 (mix_i_src_c001_0_03 0 bpf_c001_0 0) vcvs gain=1.950903220161e-01
SMIXI_c001_0_03 (mix_i_src_c001_0_03 mix_i_c001_0 win_0_03 0) relay vt1=-1m vt2=1m ropen=ropen_mix rclosed=rclosed_mix
EMIXQ_c001_0_03 (mix_q_src_c001_0_03 0 bpf_c001_0 0) vcvs gain=9.807852804032e-01
SMIXQ_c001_0_03 (mix_q_src_c001_0_03 mix_q_c001_0 win_0_03 0) relay vt1=-1m vt2=1m ropen=ropen_mix rclosed=rclosed_mix
EMIXI_c001_0_04 (mix_i_src_c001_0_04 0 bpf_c001_0 0) vcvs gain=-1.950903220161e-01
SMIXI_c001_0_04 (mix_i_src_c001_0_04 mix_i_c001_0 win_0_04 0) relay vt1=-1m vt2=1m ropen=ropen_mix rclosed=rclosed_mix
EMIXQ_c001_0_04 (mix_q_src_c001_0_04 0 bpf_c001_0 0) vcvs gain=9.807852804032e-01
SMIXQ_c001_0_04 (mix_q_src_c001_0_04 mix_q_c001_0 win_0_04 0) relay vt1=-1m vt2=1m ropen=ropen_mix rclosed=rclosed_mix
EMIXI_c001_0_05 (mix_i_src_c001_0_05 0 bpf_c001_0 0) vcvs gain=-5.555702330196e-01
SMIXI_c001_0_05 (mix_i_src_c001_0_05 mix_i_c001_0 win_0_05 0) relay vt1=-1m vt2=1m ropen=ropen_mix rclosed=rclosed_mix
EMIXQ_c001_0_05 (mix_q_src_c001_0_05 0 bpf_c001_0 0) vcvs gain=8.314696123025e-01
SMIXQ_c001_0_05 (mix_q_src_c001_0_05 mix_q_c001_0 win_0_05 0) relay vt1=-1m vt2=1m ropen=ropen_mix rclosed=rclosed_mix
EMIXI_c001_0_06 (mix_i_src_c001_0_06 0 bpf_c001_0 0) vcvs gain=-8.314696123025e-01
SMIXI_c001_0_06 (mix_i_src_c001_0_06 mix_i_c001_0 win_0_06 0) relay vt1=-1m vt2=1m ropen=ropen_mix rclosed=rclosed_mix
EMIXQ_c001_0_06 (mix_q_src_c001_0_06 0 bpf_c001_0 0) vcvs gain=5.555702330196e-01
SMIXQ_c001_0_06 (mix_q_src_c001_0_06 mix_q_c001_0 win_0_06 0) relay vt1=-1m vt2=1m ropen=ropen_mix rclosed=rclosed_mix
EMIXI_c001_0_07 (mix_i_src_c001_0_07 0 bpf_c001_0 0) vcvs gain=-9.807852804032e-01
SMIXI_c001_0_07 (mix_i_src_c001_0_07 mix_i_c001_0 win_0_07 0) relay vt1=-1m vt2=1m ropen=ropen_mix rclosed=rclosed_mix
EMIXQ_c001_0_07 (mix_q_src_c001_0_07 0 bpf_c001_0 0) vcvs gain=1.950903220161e-01
SMIXQ_c001_0_07 (mix_q_src_c001_0_07 mix_q_c001_0 win_0_07 0) relay vt1=-1m vt2=1m ropen=ropen_mix rclosed=rclosed_mix
EMIXI_c001_0_08 (mix_i_src_c001_0_08 0 bpf_c001_0 0) vcvs gain=-9.807852804032e-01
SMIXI_c001_0_08 (mix_i_src_c001_0_08 mix_i_c001_0 win_0_08 0) relay vt1=-1m vt2=1m ropen=ropen_mix rclosed=rclosed_mix
EMIXQ_c001_0_08 (mix_q_src_c001_0_08 0 bpf_c001_0 0) vcvs gain=-1.950903220161e-01
SMIXQ_c001_0_08 (mix_q_src_c001_0_08 mix_q_c001_0 win_0_08 0) relay vt1=-1m vt2=1m ropen=ropen_mix rclosed=rclosed_mix
EMIXI_c001_0_09 (mix_i_src_c001_0_09 0 bpf_c001_0 0) vcvs gain=-8.314696123025e-01
SMIXI_c001_0_09 (mix_i_src_c001_0_09 mix_i_c001_0 win_0_09 0) relay vt1=-1m vt2=1m ropen=ropen_mix rclosed=rclosed_mix
EMIXQ_c001_0_09 (mix_q_src_c001_0_09 0 bpf_c001_0 0) vcvs gain=-5.555702330196e-01
SMIXQ_c001_0_09 (mix_q_src_c001_0_09 mix_q_c001_0 win_0_09 0) relay vt1=-1m vt2=1m ropen=ropen_mix rclosed=rclosed_mix
EMIXI_c001_0_10 (mix_i_src_c001_0_10 0 bpf_c001_0 0) vcvs gain=-5.555702330196e-01
SMIXI_c001_0_10 (mix_i_src_c001_0_10 mix_i_c001_0 win_0_10 0) relay vt1=-1m vt2=1m ropen=ropen_mix rclosed=rclosed_mix
EMIXQ_c001_0_10 (mix_q_src_c001_0_10 0 bpf_c001_0 0) vcvs gain=-8.314696123025e-01
SMIXQ_c001_0_10 (mix_q_src_c001_0_10 mix_q_c001_0 win_0_10 0) relay vt1=-1m vt2=1m ropen=ropen_mix rclosed=rclosed_mix
EMIXI_c001_0_11 (mix_i_src_c001_0_11 0 bpf_c001_0 0) vcvs gain=-1.950903220161e-01
SMIXI_c001_0_11 (mix_i_src_c001_0_11 mix_i_c001_0 win_0_11 0) relay vt1=-1m vt2=1m ropen=ropen_mix rclosed=rclosed_mix
EMIXQ_c001_0_11 (mix_q_src_c001_0_11 0 bpf_c001_0 0) vcvs gain=-9.807852804032e-01
SMIXQ_c001_0_11 (mix_q_src_c001_0_11 mix_q_c001_0 win_0_11 0) relay vt1=-1m vt2=1m ropen=ropen_mix rclosed=rclosed_mix
EMIXI_c001_0_12 (mix_i_src_c001_0_12 0 bpf_c001_0 0) vcvs gain=1.950903220161e-01
SMIXI_c001_0_12 (mix_i_src_c001_0_12 mix_i_c001_0 win_0_12 0) relay vt1=-1m vt2=1m ropen=ropen_mix rclosed=rclosed_mix
EMIXQ_c001_0_12 (mix_q_src_c001_0_12 0 bpf_c001_0 0) vcvs gain=-9.807852804032e-01
SMIXQ_c001_0_12 (mix_q_src_c001_0_12 mix_q_c001_0 win_0_12 0) relay vt1=-1m vt2=1m ropen=ropen_mix rclosed=rclosed_mix
EMIXI_c001_0_13 (mix_i_src_c001_0_13 0 bpf_c001_0 0) vcvs gain=5.555702330196e-01
SMIXI_c001_0_13 (mix_i_src_c001_0_13 mix_i_c001_0 win_0_13 0) relay vt1=-1m vt2=1m ropen=ropen_mix rclosed=rclosed_mix
EMIXQ_c001_0_13 (mix_q_src_c001_0_13 0 bpf_c001_0 0) vcvs gain=-8.314696123025e-01
SMIXQ_c001_0_13 (mix_q_src_c001_0_13 mix_q_c001_0 win_0_13 0) relay vt1=-1m vt2=1m ropen=ropen_mix rclosed=rclosed_mix
EMIXI_c001_0_14 (mix_i_src_c001_0_14 0 bpf_c001_0 0) vcvs gain=8.314696123025e-01
SMIXI_c001_0_14 (mix_i_src_c001_0_14 mix_i_c001_0 win_0_14 0) relay vt1=-1m vt2=1m ropen=ropen_mix rclosed=rclosed_mix
EMIXQ_c001_0_14 (mix_q_src_c001_0_14 0 bpf_c001_0 0) vcvs gain=-5.555702330196e-01
SMIXQ_c001_0_14 (mix_q_src_c001_0_14 mix_q_c001_0 win_0_14 0) relay vt1=-1m vt2=1m ropen=ropen_mix rclosed=rclosed_mix
EMIXI_c001_0_15 (mix_i_src_c001_0_15 0 bpf_c001_0 0) vcvs gain=9.807852804032e-01
SMIXI_c001_0_15 (mix_i_src_c001_0_15 mix_i_c001_0 win_0_15 0) relay vt1=-1m vt2=1m ropen=ropen_mix rclosed=rclosed_mix
EMIXQ_c001_0_15 (mix_q_src_c001_0_15 0 bpf_c001_0 0) vcvs gain=-1.950903220161e-01
SMIXQ_c001_0_15 (mix_q_src_c001_0_15 mix_q_c001_0 win_0_15 0) relay vt1=-1m vt2=1m ropen=ropen_mix rclosed=rclosed_mix
RMIXI_c001_0 (mix_i_c001_0 0) resistor r=1G
RMIXQ_c001_0 (mix_q_c001_0 0) resistor r=1G
RINTI_c001_0 (mix_i_c001_0 Icar_c001_0) resistor r=1k
CINTI_c001_0 (Icar_c001_0 0) capacitor c=80p
RINTQ_c001_0 (mix_q_c001_0 Qcar_c001_0) resistor r=1k
CINTQ_c001_0 (Qcar_c001_0 0) capacitor c=80p
save bpf_c001_0 Icar_c001_0 Qcar_c001_0

// bl001, carrier_1: 500000000 Hz coherent I/Q phase-window verification-demod path
CBPF_c001_1 (bl001 n_cbpf_c001_1) capacitor c=1.013211836423e-13
LBPF_c001_1 (n_cbpf_c001_1 bpf_c001_1) inductor l=1.000000000000e-06
RBPF_c001_1 (bpf_c001_1 0) resistor r=1.570796326795e+02
EMIXI_c001_1_00 (mix_i_src_c001_1_00 0 bpf_c001_1 0) vcvs gain=9.807852804032e-01
SMIXI_c001_1_00 (mix_i_src_c001_1_00 mix_i_c001_1 win_1_00 0) relay vt1=-1m vt2=1m ropen=ropen_mix rclosed=rclosed_mix
EMIXQ_c001_1_00 (mix_q_src_c001_1_00 0 bpf_c001_1 0) vcvs gain=1.950903220161e-01
SMIXQ_c001_1_00 (mix_q_src_c001_1_00 mix_q_c001_1 win_1_00 0) relay vt1=-1m vt2=1m ropen=ropen_mix rclosed=rclosed_mix
EMIXI_c001_1_01 (mix_i_src_c001_1_01 0 bpf_c001_1 0) vcvs gain=8.314696123025e-01
SMIXI_c001_1_01 (mix_i_src_c001_1_01 mix_i_c001_1 win_1_01 0) relay vt1=-1m vt2=1m ropen=ropen_mix rclosed=rclosed_mix
EMIXQ_c001_1_01 (mix_q_src_c001_1_01 0 bpf_c001_1 0) vcvs gain=5.555702330196e-01
SMIXQ_c001_1_01 (mix_q_src_c001_1_01 mix_q_c001_1 win_1_01 0) relay vt1=-1m vt2=1m ropen=ropen_mix rclosed=rclosed_mix
EMIXI_c001_1_02 (mix_i_src_c001_1_02 0 bpf_c001_1 0) vcvs gain=5.555702330196e-01
SMIXI_c001_1_02 (mix_i_src_c001_1_02 mix_i_c001_1 win_1_02 0) relay vt1=-1m vt2=1m ropen=ropen_mix rclosed=rclosed_mix
EMIXQ_c001_1_02 (mix_q_src_c001_1_02 0 bpf_c001_1 0) vcvs gain=8.314696123025e-01
SMIXQ_c001_1_02 (mix_q_src_c001_1_02 mix_q_c001_1 win_1_02 0) relay vt1=-1m vt2=1m ropen=ropen_mix rclosed=rclosed_mix
EMIXI_c001_1_03 (mix_i_src_c001_1_03 0 bpf_c001_1 0) vcvs gain=1.950903220161e-01
SMIXI_c001_1_03 (mix_i_src_c001_1_03 mix_i_c001_1 win_1_03 0) relay vt1=-1m vt2=1m ropen=ropen_mix rclosed=rclosed_mix
EMIXQ_c001_1_03 (mix_q_src_c001_1_03 0 bpf_c001_1 0) vcvs gain=9.807852804032e-01
SMIXQ_c001_1_03 (mix_q_src_c001_1_03 mix_q_c001_1 win_1_03 0) relay vt1=-1m vt2=1m ropen=ropen_mix rclosed=rclosed_mix
EMIXI_c001_1_04 (mix_i_src_c001_1_04 0 bpf_c001_1 0) vcvs gain=-1.950903220161e-01
SMIXI_c001_1_04 (mix_i_src_c001_1_04 mix_i_c001_1 win_1_04 0) relay vt1=-1m vt2=1m ropen=ropen_mix rclosed=rclosed_mix
EMIXQ_c001_1_04 (mix_q_src_c001_1_04 0 bpf_c001_1 0) vcvs gain=9.807852804032e-01
SMIXQ_c001_1_04 (mix_q_src_c001_1_04 mix_q_c001_1 win_1_04 0) relay vt1=-1m vt2=1m ropen=ropen_mix rclosed=rclosed_mix
EMIXI_c001_1_05 (mix_i_src_c001_1_05 0 bpf_c001_1 0) vcvs gain=-5.555702330196e-01
SMIXI_c001_1_05 (mix_i_src_c001_1_05 mix_i_c001_1 win_1_05 0) relay vt1=-1m vt2=1m ropen=ropen_mix rclosed=rclosed_mix
EMIXQ_c001_1_05 (mix_q_src_c001_1_05 0 bpf_c001_1 0) vcvs gain=8.314696123025e-01
SMIXQ_c001_1_05 (mix_q_src_c001_1_05 mix_q_c001_1 win_1_05 0) relay vt1=-1m vt2=1m ropen=ropen_mix rclosed=rclosed_mix
EMIXI_c001_1_06 (mix_i_src_c001_1_06 0 bpf_c001_1 0) vcvs gain=-8.314696123025e-01
SMIXI_c001_1_06 (mix_i_src_c001_1_06 mix_i_c001_1 win_1_06 0) relay vt1=-1m vt2=1m ropen=ropen_mix rclosed=rclosed_mix
EMIXQ_c001_1_06 (mix_q_src_c001_1_06 0 bpf_c001_1 0) vcvs gain=5.555702330196e-01
SMIXQ_c001_1_06 (mix_q_src_c001_1_06 mix_q_c001_1 win_1_06 0) relay vt1=-1m vt2=1m ropen=ropen_mix rclosed=rclosed_mix
EMIXI_c001_1_07 (mix_i_src_c001_1_07 0 bpf_c001_1 0) vcvs gain=-9.807852804032e-01
SMIXI_c001_1_07 (mix_i_src_c001_1_07 mix_i_c001_1 win_1_07 0) relay vt1=-1m vt2=1m ropen=ropen_mix rclosed=rclosed_mix
EMIXQ_c001_1_07 (mix_q_src_c001_1_07 0 bpf_c001_1 0) vcvs gain=1.950903220161e-01
SMIXQ_c001_1_07 (mix_q_src_c001_1_07 mix_q_c001_1 win_1_07 0) relay vt1=-1m vt2=1m ropen=ropen_mix rclosed=rclosed_mix
EMIXI_c001_1_08 (mix_i_src_c001_1_08 0 bpf_c001_1 0) vcvs gain=-9.807852804032e-01
SMIXI_c001_1_08 (mix_i_src_c001_1_08 mix_i_c001_1 win_1_08 0) relay vt1=-1m vt2=1m ropen=ropen_mix rclosed=rclosed_mix
EMIXQ_c001_1_08 (mix_q_src_c001_1_08 0 bpf_c001_1 0) vcvs gain=-1.950903220161e-01
SMIXQ_c001_1_08 (mix_q_src_c001_1_08 mix_q_c001_1 win_1_08 0) relay vt1=-1m vt2=1m ropen=ropen_mix rclosed=rclosed_mix
EMIXI_c001_1_09 (mix_i_src_c001_1_09 0 bpf_c001_1 0) vcvs gain=-8.314696123025e-01
SMIXI_c001_1_09 (mix_i_src_c001_1_09 mix_i_c001_1 win_1_09 0) relay vt1=-1m vt2=1m ropen=ropen_mix rclosed=rclosed_mix
EMIXQ_c001_1_09 (mix_q_src_c001_1_09 0 bpf_c001_1 0) vcvs gain=-5.555702330196e-01
SMIXQ_c001_1_09 (mix_q_src_c001_1_09 mix_q_c001_1 win_1_09 0) relay vt1=-1m vt2=1m ropen=ropen_mix rclosed=rclosed_mix
EMIXI_c001_1_10 (mix_i_src_c001_1_10 0 bpf_c001_1 0) vcvs gain=-5.555702330196e-01
SMIXI_c001_1_10 (mix_i_src_c001_1_10 mix_i_c001_1 win_1_10 0) relay vt1=-1m vt2=1m ropen=ropen_mix rclosed=rclosed_mix
EMIXQ_c001_1_10 (mix_q_src_c001_1_10 0 bpf_c001_1 0) vcvs gain=-8.314696123025e-01
SMIXQ_c001_1_10 (mix_q_src_c001_1_10 mix_q_c001_1 win_1_10 0) relay vt1=-1m vt2=1m ropen=ropen_mix rclosed=rclosed_mix
EMIXI_c001_1_11 (mix_i_src_c001_1_11 0 bpf_c001_1 0) vcvs gain=-1.950903220161e-01
SMIXI_c001_1_11 (mix_i_src_c001_1_11 mix_i_c001_1 win_1_11 0) relay vt1=-1m vt2=1m ropen=ropen_mix rclosed=rclosed_mix
EMIXQ_c001_1_11 (mix_q_src_c001_1_11 0 bpf_c001_1 0) vcvs gain=-9.807852804032e-01
SMIXQ_c001_1_11 (mix_q_src_c001_1_11 mix_q_c001_1 win_1_11 0) relay vt1=-1m vt2=1m ropen=ropen_mix rclosed=rclosed_mix
EMIXI_c001_1_12 (mix_i_src_c001_1_12 0 bpf_c001_1 0) vcvs gain=1.950903220161e-01
SMIXI_c001_1_12 (mix_i_src_c001_1_12 mix_i_c001_1 win_1_12 0) relay vt1=-1m vt2=1m ropen=ropen_mix rclosed=rclosed_mix
EMIXQ_c001_1_12 (mix_q_src_c001_1_12 0 bpf_c001_1 0) vcvs gain=-9.807852804032e-01
SMIXQ_c001_1_12 (mix_q_src_c001_1_12 mix_q_c001_1 win_1_12 0) relay vt1=-1m vt2=1m ropen=ropen_mix rclosed=rclosed_mix
EMIXI_c001_1_13 (mix_i_src_c001_1_13 0 bpf_c001_1 0) vcvs gain=5.555702330196e-01
SMIXI_c001_1_13 (mix_i_src_c001_1_13 mix_i_c001_1 win_1_13 0) relay vt1=-1m vt2=1m ropen=ropen_mix rclosed=rclosed_mix
EMIXQ_c001_1_13 (mix_q_src_c001_1_13 0 bpf_c001_1 0) vcvs gain=-8.314696123025e-01
SMIXQ_c001_1_13 (mix_q_src_c001_1_13 mix_q_c001_1 win_1_13 0) relay vt1=-1m vt2=1m ropen=ropen_mix rclosed=rclosed_mix
EMIXI_c001_1_14 (mix_i_src_c001_1_14 0 bpf_c001_1 0) vcvs gain=8.314696123025e-01
SMIXI_c001_1_14 (mix_i_src_c001_1_14 mix_i_c001_1 win_1_14 0) relay vt1=-1m vt2=1m ropen=ropen_mix rclosed=rclosed_mix
EMIXQ_c001_1_14 (mix_q_src_c001_1_14 0 bpf_c001_1 0) vcvs gain=-5.555702330196e-01
SMIXQ_c001_1_14 (mix_q_src_c001_1_14 mix_q_c001_1 win_1_14 0) relay vt1=-1m vt2=1m ropen=ropen_mix rclosed=rclosed_mix
EMIXI_c001_1_15 (mix_i_src_c001_1_15 0 bpf_c001_1 0) vcvs gain=9.807852804032e-01
SMIXI_c001_1_15 (mix_i_src_c001_1_15 mix_i_c001_1 win_1_15 0) relay vt1=-1m vt2=1m ropen=ropen_mix rclosed=rclosed_mix
EMIXQ_c001_1_15 (mix_q_src_c001_1_15 0 bpf_c001_1 0) vcvs gain=-1.950903220161e-01
SMIXQ_c001_1_15 (mix_q_src_c001_1_15 mix_q_c001_1 win_1_15 0) relay vt1=-1m vt2=1m ropen=ropen_mix rclosed=rclosed_mix
RMIXI_c001_1 (mix_i_c001_1 0) resistor r=1G
RMIXQ_c001_1 (mix_q_c001_1 0) resistor r=1G
RINTI_c001_1 (mix_i_c001_1 Icar_c001_1) resistor r=1k
CINTI_c001_1 (Icar_c001_1 0) capacitor c=80p
RINTQ_c001_1 (mix_q_c001_1 Qcar_c001_1) resistor r=1k
CINTQ_c001_1 (Qcar_c001_1 0) capacitor c=80p
save bpf_c001_1 Icar_c001_1 Qcar_c001_1

// bl001, carrier_2: 750000000 Hz coherent I/Q phase-window verification-demod path
CBPF_c001_2 (bl001 n_cbpf_c001_2) capacitor c=4.503163717437e-14
LBPF_c001_2 (n_cbpf_c001_2 bpf_c001_2) inductor l=1.000000000000e-06
RBPF_c001_2 (bpf_c001_2 0) resistor r=2.356194490192e+02
EMIXI_c001_2_00 (mix_i_src_c001_2_00 0 bpf_c001_2 0) vcvs gain=9.807852804032e-01
SMIXI_c001_2_00 (mix_i_src_c001_2_00 mix_i_c001_2 win_2_00 0) relay vt1=-1m vt2=1m ropen=ropen_mix rclosed=rclosed_mix
EMIXQ_c001_2_00 (mix_q_src_c001_2_00 0 bpf_c001_2 0) vcvs gain=1.950903220161e-01
SMIXQ_c001_2_00 (mix_q_src_c001_2_00 mix_q_c001_2 win_2_00 0) relay vt1=-1m vt2=1m ropen=ropen_mix rclosed=rclosed_mix
EMIXI_c001_2_01 (mix_i_src_c001_2_01 0 bpf_c001_2 0) vcvs gain=8.314696123025e-01
SMIXI_c001_2_01 (mix_i_src_c001_2_01 mix_i_c001_2 win_2_01 0) relay vt1=-1m vt2=1m ropen=ropen_mix rclosed=rclosed_mix
EMIXQ_c001_2_01 (mix_q_src_c001_2_01 0 bpf_c001_2 0) vcvs gain=5.555702330196e-01
SMIXQ_c001_2_01 (mix_q_src_c001_2_01 mix_q_c001_2 win_2_01 0) relay vt1=-1m vt2=1m ropen=ropen_mix rclosed=rclosed_mix
EMIXI_c001_2_02 (mix_i_src_c001_2_02 0 bpf_c001_2 0) vcvs gain=5.555702330196e-01
SMIXI_c001_2_02 (mix_i_src_c001_2_02 mix_i_c001_2 win_2_02 0) relay vt1=-1m vt2=1m ropen=ropen_mix rclosed=rclosed_mix
EMIXQ_c001_2_02 (mix_q_src_c001_2_02 0 bpf_c001_2 0) vcvs gain=8.314696123025e-01
SMIXQ_c001_2_02 (mix_q_src_c001_2_02 mix_q_c001_2 win_2_02 0) relay vt1=-1m vt2=1m ropen=ropen_mix rclosed=rclosed_mix
EMIXI_c001_2_03 (mix_i_src_c001_2_03 0 bpf_c001_2 0) vcvs gain=1.950903220161e-01
SMIXI_c001_2_03 (mix_i_src_c001_2_03 mix_i_c001_2 win_2_03 0) relay vt1=-1m vt2=1m ropen=ropen_mix rclosed=rclosed_mix
EMIXQ_c001_2_03 (mix_q_src_c001_2_03 0 bpf_c001_2 0) vcvs gain=9.807852804032e-01
SMIXQ_c001_2_03 (mix_q_src_c001_2_03 mix_q_c001_2 win_2_03 0) relay vt1=-1m vt2=1m ropen=ropen_mix rclosed=rclosed_mix
EMIXI_c001_2_04 (mix_i_src_c001_2_04 0 bpf_c001_2 0) vcvs gain=-1.950903220161e-01
SMIXI_c001_2_04 (mix_i_src_c001_2_04 mix_i_c001_2 win_2_04 0) relay vt1=-1m vt2=1m ropen=ropen_mix rclosed=rclosed_mix
EMIXQ_c001_2_04 (mix_q_src_c001_2_04 0 bpf_c001_2 0) vcvs gain=9.807852804032e-01
SMIXQ_c001_2_04 (mix_q_src_c001_2_04 mix_q_c001_2 win_2_04 0) relay vt1=-1m vt2=1m ropen=ropen_mix rclosed=rclosed_mix
EMIXI_c001_2_05 (mix_i_src_c001_2_05 0 bpf_c001_2 0) vcvs gain=-5.555702330196e-01
SMIXI_c001_2_05 (mix_i_src_c001_2_05 mix_i_c001_2 win_2_05 0) relay vt1=-1m vt2=1m ropen=ropen_mix rclosed=rclosed_mix
EMIXQ_c001_2_05 (mix_q_src_c001_2_05 0 bpf_c001_2 0) vcvs gain=8.314696123025e-01
SMIXQ_c001_2_05 (mix_q_src_c001_2_05 mix_q_c001_2 win_2_05 0) relay vt1=-1m vt2=1m ropen=ropen_mix rclosed=rclosed_mix
EMIXI_c001_2_06 (mix_i_src_c001_2_06 0 bpf_c001_2 0) vcvs gain=-8.314696123025e-01
SMIXI_c001_2_06 (mix_i_src_c001_2_06 mix_i_c001_2 win_2_06 0) relay vt1=-1m vt2=1m ropen=ropen_mix rclosed=rclosed_mix
EMIXQ_c001_2_06 (mix_q_src_c001_2_06 0 bpf_c001_2 0) vcvs gain=5.555702330196e-01
SMIXQ_c001_2_06 (mix_q_src_c001_2_06 mix_q_c001_2 win_2_06 0) relay vt1=-1m vt2=1m ropen=ropen_mix rclosed=rclosed_mix
EMIXI_c001_2_07 (mix_i_src_c001_2_07 0 bpf_c001_2 0) vcvs gain=-9.807852804032e-01
SMIXI_c001_2_07 (mix_i_src_c001_2_07 mix_i_c001_2 win_2_07 0) relay vt1=-1m vt2=1m ropen=ropen_mix rclosed=rclosed_mix
EMIXQ_c001_2_07 (mix_q_src_c001_2_07 0 bpf_c001_2 0) vcvs gain=1.950903220161e-01
SMIXQ_c001_2_07 (mix_q_src_c001_2_07 mix_q_c001_2 win_2_07 0) relay vt1=-1m vt2=1m ropen=ropen_mix rclosed=rclosed_mix
EMIXI_c001_2_08 (mix_i_src_c001_2_08 0 bpf_c001_2 0) vcvs gain=-9.807852804032e-01
SMIXI_c001_2_08 (mix_i_src_c001_2_08 mix_i_c001_2 win_2_08 0) relay vt1=-1m vt2=1m ropen=ropen_mix rclosed=rclosed_mix
EMIXQ_c001_2_08 (mix_q_src_c001_2_08 0 bpf_c001_2 0) vcvs gain=-1.950903220161e-01
SMIXQ_c001_2_08 (mix_q_src_c001_2_08 mix_q_c001_2 win_2_08 0) relay vt1=-1m vt2=1m ropen=ropen_mix rclosed=rclosed_mix
EMIXI_c001_2_09 (mix_i_src_c001_2_09 0 bpf_c001_2 0) vcvs gain=-8.314696123025e-01
SMIXI_c001_2_09 (mix_i_src_c001_2_09 mix_i_c001_2 win_2_09 0) relay vt1=-1m vt2=1m ropen=ropen_mix rclosed=rclosed_mix
EMIXQ_c001_2_09 (mix_q_src_c001_2_09 0 bpf_c001_2 0) vcvs gain=-5.555702330196e-01
SMIXQ_c001_2_09 (mix_q_src_c001_2_09 mix_q_c001_2 win_2_09 0) relay vt1=-1m vt2=1m ropen=ropen_mix rclosed=rclosed_mix
EMIXI_c001_2_10 (mix_i_src_c001_2_10 0 bpf_c001_2 0) vcvs gain=-5.555702330196e-01
SMIXI_c001_2_10 (mix_i_src_c001_2_10 mix_i_c001_2 win_2_10 0) relay vt1=-1m vt2=1m ropen=ropen_mix rclosed=rclosed_mix
EMIXQ_c001_2_10 (mix_q_src_c001_2_10 0 bpf_c001_2 0) vcvs gain=-8.314696123025e-01
SMIXQ_c001_2_10 (mix_q_src_c001_2_10 mix_q_c001_2 win_2_10 0) relay vt1=-1m vt2=1m ropen=ropen_mix rclosed=rclosed_mix
EMIXI_c001_2_11 (mix_i_src_c001_2_11 0 bpf_c001_2 0) vcvs gain=-1.950903220161e-01
SMIXI_c001_2_11 (mix_i_src_c001_2_11 mix_i_c001_2 win_2_11 0) relay vt1=-1m vt2=1m ropen=ropen_mix rclosed=rclosed_mix
EMIXQ_c001_2_11 (mix_q_src_c001_2_11 0 bpf_c001_2 0) vcvs gain=-9.807852804032e-01
SMIXQ_c001_2_11 (mix_q_src_c001_2_11 mix_q_c001_2 win_2_11 0) relay vt1=-1m vt2=1m ropen=ropen_mix rclosed=rclosed_mix
EMIXI_c001_2_12 (mix_i_src_c001_2_12 0 bpf_c001_2 0) vcvs gain=1.950903220161e-01
SMIXI_c001_2_12 (mix_i_src_c001_2_12 mix_i_c001_2 win_2_12 0) relay vt1=-1m vt2=1m ropen=ropen_mix rclosed=rclosed_mix
EMIXQ_c001_2_12 (mix_q_src_c001_2_12 0 bpf_c001_2 0) vcvs gain=-9.807852804032e-01
SMIXQ_c001_2_12 (mix_q_src_c001_2_12 mix_q_c001_2 win_2_12 0) relay vt1=-1m vt2=1m ropen=ropen_mix rclosed=rclosed_mix
EMIXI_c001_2_13 (mix_i_src_c001_2_13 0 bpf_c001_2 0) vcvs gain=5.555702330196e-01
SMIXI_c001_2_13 (mix_i_src_c001_2_13 mix_i_c001_2 win_2_13 0) relay vt1=-1m vt2=1m ropen=ropen_mix rclosed=rclosed_mix
EMIXQ_c001_2_13 (mix_q_src_c001_2_13 0 bpf_c001_2 0) vcvs gain=-8.314696123025e-01
SMIXQ_c001_2_13 (mix_q_src_c001_2_13 mix_q_c001_2 win_2_13 0) relay vt1=-1m vt2=1m ropen=ropen_mix rclosed=rclosed_mix
EMIXI_c001_2_14 (mix_i_src_c001_2_14 0 bpf_c001_2 0) vcvs gain=8.314696123025e-01
SMIXI_c001_2_14 (mix_i_src_c001_2_14 mix_i_c001_2 win_2_14 0) relay vt1=-1m vt2=1m ropen=ropen_mix rclosed=rclosed_mix
EMIXQ_c001_2_14 (mix_q_src_c001_2_14 0 bpf_c001_2 0) vcvs gain=-5.555702330196e-01
SMIXQ_c001_2_14 (mix_q_src_c001_2_14 mix_q_c001_2 win_2_14 0) relay vt1=-1m vt2=1m ropen=ropen_mix rclosed=rclosed_mix
EMIXI_c001_2_15 (mix_i_src_c001_2_15 0 bpf_c001_2 0) vcvs gain=9.807852804032e-01
SMIXI_c001_2_15 (mix_i_src_c001_2_15 mix_i_c001_2 win_2_15 0) relay vt1=-1m vt2=1m ropen=ropen_mix rclosed=rclosed_mix
EMIXQ_c001_2_15 (mix_q_src_c001_2_15 0 bpf_c001_2 0) vcvs gain=-1.950903220161e-01
SMIXQ_c001_2_15 (mix_q_src_c001_2_15 mix_q_c001_2 win_2_15 0) relay vt1=-1m vt2=1m ropen=ropen_mix rclosed=rclosed_mix
RMIXI_c001_2 (mix_i_c001_2 0) resistor r=1G
RMIXQ_c001_2 (mix_q_c001_2 0) resistor r=1G
RINTI_c001_2 (mix_i_c001_2 Icar_c001_2) resistor r=1k
CINTI_c001_2 (Icar_c001_2 0) capacitor c=80p
RINTQ_c001_2 (mix_q_c001_2 Qcar_c001_2) resistor r=1k
CINTQ_c001_2 (Qcar_c001_2 0) capacitor c=80p
save bpf_c001_2 Icar_c001_2 Qcar_c001_2

// bl001, carrier_3: 1000000000 Hz coherent I/Q phase-window verification-demod path
CBPF_c001_3 (bl001 n_cbpf_c001_3) capacitor c=2.533029591058e-14
LBPF_c001_3 (n_cbpf_c001_3 bpf_c001_3) inductor l=1.000000000000e-06
RBPF_c001_3 (bpf_c001_3 0) resistor r=3.141592653590e+02
EMIXI_c001_3_00 (mix_i_src_c001_3_00 0 bpf_c001_3 0) vcvs gain=9.807852804032e-01
SMIXI_c001_3_00 (mix_i_src_c001_3_00 mix_i_c001_3 win_3_00 0) relay vt1=-1m vt2=1m ropen=ropen_mix rclosed=rclosed_mix
EMIXQ_c001_3_00 (mix_q_src_c001_3_00 0 bpf_c001_3 0) vcvs gain=1.950903220161e-01
SMIXQ_c001_3_00 (mix_q_src_c001_3_00 mix_q_c001_3 win_3_00 0) relay vt1=-1m vt2=1m ropen=ropen_mix rclosed=rclosed_mix
EMIXI_c001_3_01 (mix_i_src_c001_3_01 0 bpf_c001_3 0) vcvs gain=8.314696123025e-01
SMIXI_c001_3_01 (mix_i_src_c001_3_01 mix_i_c001_3 win_3_01 0) relay vt1=-1m vt2=1m ropen=ropen_mix rclosed=rclosed_mix
EMIXQ_c001_3_01 (mix_q_src_c001_3_01 0 bpf_c001_3 0) vcvs gain=5.555702330196e-01
SMIXQ_c001_3_01 (mix_q_src_c001_3_01 mix_q_c001_3 win_3_01 0) relay vt1=-1m vt2=1m ropen=ropen_mix rclosed=rclosed_mix
EMIXI_c001_3_02 (mix_i_src_c001_3_02 0 bpf_c001_3 0) vcvs gain=5.555702330196e-01
SMIXI_c001_3_02 (mix_i_src_c001_3_02 mix_i_c001_3 win_3_02 0) relay vt1=-1m vt2=1m ropen=ropen_mix rclosed=rclosed_mix
EMIXQ_c001_3_02 (mix_q_src_c001_3_02 0 bpf_c001_3 0) vcvs gain=8.314696123025e-01
SMIXQ_c001_3_02 (mix_q_src_c001_3_02 mix_q_c001_3 win_3_02 0) relay vt1=-1m vt2=1m ropen=ropen_mix rclosed=rclosed_mix
EMIXI_c001_3_03 (mix_i_src_c001_3_03 0 bpf_c001_3 0) vcvs gain=1.950903220161e-01
SMIXI_c001_3_03 (mix_i_src_c001_3_03 mix_i_c001_3 win_3_03 0) relay vt1=-1m vt2=1m ropen=ropen_mix rclosed=rclosed_mix
EMIXQ_c001_3_03 (mix_q_src_c001_3_03 0 bpf_c001_3 0) vcvs gain=9.807852804032e-01
SMIXQ_c001_3_03 (mix_q_src_c001_3_03 mix_q_c001_3 win_3_03 0) relay vt1=-1m vt2=1m ropen=ropen_mix rclosed=rclosed_mix
EMIXI_c001_3_04 (mix_i_src_c001_3_04 0 bpf_c001_3 0) vcvs gain=-1.950903220161e-01
SMIXI_c001_3_04 (mix_i_src_c001_3_04 mix_i_c001_3 win_3_04 0) relay vt1=-1m vt2=1m ropen=ropen_mix rclosed=rclosed_mix
EMIXQ_c001_3_04 (mix_q_src_c001_3_04 0 bpf_c001_3 0) vcvs gain=9.807852804032e-01
SMIXQ_c001_3_04 (mix_q_src_c001_3_04 mix_q_c001_3 win_3_04 0) relay vt1=-1m vt2=1m ropen=ropen_mix rclosed=rclosed_mix
EMIXI_c001_3_05 (mix_i_src_c001_3_05 0 bpf_c001_3 0) vcvs gain=-5.555702330196e-01
SMIXI_c001_3_05 (mix_i_src_c001_3_05 mix_i_c001_3 win_3_05 0) relay vt1=-1m vt2=1m ropen=ropen_mix rclosed=rclosed_mix
EMIXQ_c001_3_05 (mix_q_src_c001_3_05 0 bpf_c001_3 0) vcvs gain=8.314696123025e-01
SMIXQ_c001_3_05 (mix_q_src_c001_3_05 mix_q_c001_3 win_3_05 0) relay vt1=-1m vt2=1m ropen=ropen_mix rclosed=rclosed_mix
EMIXI_c001_3_06 (mix_i_src_c001_3_06 0 bpf_c001_3 0) vcvs gain=-8.314696123025e-01
SMIXI_c001_3_06 (mix_i_src_c001_3_06 mix_i_c001_3 win_3_06 0) relay vt1=-1m vt2=1m ropen=ropen_mix rclosed=rclosed_mix
EMIXQ_c001_3_06 (mix_q_src_c001_3_06 0 bpf_c001_3 0) vcvs gain=5.555702330196e-01
SMIXQ_c001_3_06 (mix_q_src_c001_3_06 mix_q_c001_3 win_3_06 0) relay vt1=-1m vt2=1m ropen=ropen_mix rclosed=rclosed_mix
EMIXI_c001_3_07 (mix_i_src_c001_3_07 0 bpf_c001_3 0) vcvs gain=-9.807852804032e-01
SMIXI_c001_3_07 (mix_i_src_c001_3_07 mix_i_c001_3 win_3_07 0) relay vt1=-1m vt2=1m ropen=ropen_mix rclosed=rclosed_mix
EMIXQ_c001_3_07 (mix_q_src_c001_3_07 0 bpf_c001_3 0) vcvs gain=1.950903220161e-01
SMIXQ_c001_3_07 (mix_q_src_c001_3_07 mix_q_c001_3 win_3_07 0) relay vt1=-1m vt2=1m ropen=ropen_mix rclosed=rclosed_mix
EMIXI_c001_3_08 (mix_i_src_c001_3_08 0 bpf_c001_3 0) vcvs gain=-9.807852804032e-01
SMIXI_c001_3_08 (mix_i_src_c001_3_08 mix_i_c001_3 win_3_08 0) relay vt1=-1m vt2=1m ropen=ropen_mix rclosed=rclosed_mix
EMIXQ_c001_3_08 (mix_q_src_c001_3_08 0 bpf_c001_3 0) vcvs gain=-1.950903220161e-01
SMIXQ_c001_3_08 (mix_q_src_c001_3_08 mix_q_c001_3 win_3_08 0) relay vt1=-1m vt2=1m ropen=ropen_mix rclosed=rclosed_mix
EMIXI_c001_3_09 (mix_i_src_c001_3_09 0 bpf_c001_3 0) vcvs gain=-8.314696123025e-01
SMIXI_c001_3_09 (mix_i_src_c001_3_09 mix_i_c001_3 win_3_09 0) relay vt1=-1m vt2=1m ropen=ropen_mix rclosed=rclosed_mix
EMIXQ_c001_3_09 (mix_q_src_c001_3_09 0 bpf_c001_3 0) vcvs gain=-5.555702330196e-01
SMIXQ_c001_3_09 (mix_q_src_c001_3_09 mix_q_c001_3 win_3_09 0) relay vt1=-1m vt2=1m ropen=ropen_mix rclosed=rclosed_mix
EMIXI_c001_3_10 (mix_i_src_c001_3_10 0 bpf_c001_3 0) vcvs gain=-5.555702330196e-01
SMIXI_c001_3_10 (mix_i_src_c001_3_10 mix_i_c001_3 win_3_10 0) relay vt1=-1m vt2=1m ropen=ropen_mix rclosed=rclosed_mix
EMIXQ_c001_3_10 (mix_q_src_c001_3_10 0 bpf_c001_3 0) vcvs gain=-8.314696123025e-01
SMIXQ_c001_3_10 (mix_q_src_c001_3_10 mix_q_c001_3 win_3_10 0) relay vt1=-1m vt2=1m ropen=ropen_mix rclosed=rclosed_mix
EMIXI_c001_3_11 (mix_i_src_c001_3_11 0 bpf_c001_3 0) vcvs gain=-1.950903220161e-01
SMIXI_c001_3_11 (mix_i_src_c001_3_11 mix_i_c001_3 win_3_11 0) relay vt1=-1m vt2=1m ropen=ropen_mix rclosed=rclosed_mix
EMIXQ_c001_3_11 (mix_q_src_c001_3_11 0 bpf_c001_3 0) vcvs gain=-9.807852804032e-01
SMIXQ_c001_3_11 (mix_q_src_c001_3_11 mix_q_c001_3 win_3_11 0) relay vt1=-1m vt2=1m ropen=ropen_mix rclosed=rclosed_mix
EMIXI_c001_3_12 (mix_i_src_c001_3_12 0 bpf_c001_3 0) vcvs gain=1.950903220161e-01
SMIXI_c001_3_12 (mix_i_src_c001_3_12 mix_i_c001_3 win_3_12 0) relay vt1=-1m vt2=1m ropen=ropen_mix rclosed=rclosed_mix
EMIXQ_c001_3_12 (mix_q_src_c001_3_12 0 bpf_c001_3 0) vcvs gain=-9.807852804032e-01
SMIXQ_c001_3_12 (mix_q_src_c001_3_12 mix_q_c001_3 win_3_12 0) relay vt1=-1m vt2=1m ropen=ropen_mix rclosed=rclosed_mix
EMIXI_c001_3_13 (mix_i_src_c001_3_13 0 bpf_c001_3 0) vcvs gain=5.555702330196e-01
SMIXI_c001_3_13 (mix_i_src_c001_3_13 mix_i_c001_3 win_3_13 0) relay vt1=-1m vt2=1m ropen=ropen_mix rclosed=rclosed_mix
EMIXQ_c001_3_13 (mix_q_src_c001_3_13 0 bpf_c001_3 0) vcvs gain=-8.314696123025e-01
SMIXQ_c001_3_13 (mix_q_src_c001_3_13 mix_q_c001_3 win_3_13 0) relay vt1=-1m vt2=1m ropen=ropen_mix rclosed=rclosed_mix
EMIXI_c001_3_14 (mix_i_src_c001_3_14 0 bpf_c001_3 0) vcvs gain=8.314696123025e-01
SMIXI_c001_3_14 (mix_i_src_c001_3_14 mix_i_c001_3 win_3_14 0) relay vt1=-1m vt2=1m ropen=ropen_mix rclosed=rclosed_mix
EMIXQ_c001_3_14 (mix_q_src_c001_3_14 0 bpf_c001_3 0) vcvs gain=-5.555702330196e-01
SMIXQ_c001_3_14 (mix_q_src_c001_3_14 mix_q_c001_3 win_3_14 0) relay vt1=-1m vt2=1m ropen=ropen_mix rclosed=rclosed_mix
EMIXI_c001_3_15 (mix_i_src_c001_3_15 0 bpf_c001_3 0) vcvs gain=9.807852804032e-01
SMIXI_c001_3_15 (mix_i_src_c001_3_15 mix_i_c001_3 win_3_15 0) relay vt1=-1m vt2=1m ropen=ropen_mix rclosed=rclosed_mix
EMIXQ_c001_3_15 (mix_q_src_c001_3_15 0 bpf_c001_3 0) vcvs gain=-1.950903220161e-01
SMIXQ_c001_3_15 (mix_q_src_c001_3_15 mix_q_c001_3 win_3_15 0) relay vt1=-1m vt2=1m ropen=ropen_mix rclosed=rclosed_mix
RMIXI_c001_3 (mix_i_c001_3 0) resistor r=1G
RMIXQ_c001_3 (mix_q_c001_3 0) resistor r=1G
RINTI_c001_3 (mix_i_c001_3 Icar_c001_3) resistor r=1k
CINTI_c001_3 (Icar_c001_3 0) capacitor c=80p
RINTQ_c001_3 (mix_q_c001_3 Qcar_c001_3) resistor r=1k
CINTQ_c001_3 (Qcar_c001_3 0) capacitor c=80p
save bpf_c001_3 Icar_c001_3 Qcar_c001_3

// bl002, carrier_0: 250000000 Hz coherent I/Q phase-window verification-demod path
CBPF_c002_0 (bl002 n_cbpf_c002_0) capacitor c=4.052847345694e-13
LBPF_c002_0 (n_cbpf_c002_0 bpf_c002_0) inductor l=1.000000000000e-06
RBPF_c002_0 (bpf_c002_0 0) resistor r=7.853981633974e+01
EMIXI_c002_0_00 (mix_i_src_c002_0_00 0 bpf_c002_0 0) vcvs gain=9.807852804032e-01
SMIXI_c002_0_00 (mix_i_src_c002_0_00 mix_i_c002_0 win_0_00 0) relay vt1=-1m vt2=1m ropen=ropen_mix rclosed=rclosed_mix
EMIXQ_c002_0_00 (mix_q_src_c002_0_00 0 bpf_c002_0 0) vcvs gain=1.950903220161e-01
SMIXQ_c002_0_00 (mix_q_src_c002_0_00 mix_q_c002_0 win_0_00 0) relay vt1=-1m vt2=1m ropen=ropen_mix rclosed=rclosed_mix
EMIXI_c002_0_01 (mix_i_src_c002_0_01 0 bpf_c002_0 0) vcvs gain=8.314696123025e-01
SMIXI_c002_0_01 (mix_i_src_c002_0_01 mix_i_c002_0 win_0_01 0) relay vt1=-1m vt2=1m ropen=ropen_mix rclosed=rclosed_mix
EMIXQ_c002_0_01 (mix_q_src_c002_0_01 0 bpf_c002_0 0) vcvs gain=5.555702330196e-01
SMIXQ_c002_0_01 (mix_q_src_c002_0_01 mix_q_c002_0 win_0_01 0) relay vt1=-1m vt2=1m ropen=ropen_mix rclosed=rclosed_mix
EMIXI_c002_0_02 (mix_i_src_c002_0_02 0 bpf_c002_0 0) vcvs gain=5.555702330196e-01
SMIXI_c002_0_02 (mix_i_src_c002_0_02 mix_i_c002_0 win_0_02 0) relay vt1=-1m vt2=1m ropen=ropen_mix rclosed=rclosed_mix
EMIXQ_c002_0_02 (mix_q_src_c002_0_02 0 bpf_c002_0 0) vcvs gain=8.314696123025e-01
SMIXQ_c002_0_02 (mix_q_src_c002_0_02 mix_q_c002_0 win_0_02 0) relay vt1=-1m vt2=1m ropen=ropen_mix rclosed=rclosed_mix
EMIXI_c002_0_03 (mix_i_src_c002_0_03 0 bpf_c002_0 0) vcvs gain=1.950903220161e-01
SMIXI_c002_0_03 (mix_i_src_c002_0_03 mix_i_c002_0 win_0_03 0) relay vt1=-1m vt2=1m ropen=ropen_mix rclosed=rclosed_mix
EMIXQ_c002_0_03 (mix_q_src_c002_0_03 0 bpf_c002_0 0) vcvs gain=9.807852804032e-01
SMIXQ_c002_0_03 (mix_q_src_c002_0_03 mix_q_c002_0 win_0_03 0) relay vt1=-1m vt2=1m ropen=ropen_mix rclosed=rclosed_mix
EMIXI_c002_0_04 (mix_i_src_c002_0_04 0 bpf_c002_0 0) vcvs gain=-1.950903220161e-01
SMIXI_c002_0_04 (mix_i_src_c002_0_04 mix_i_c002_0 win_0_04 0) relay vt1=-1m vt2=1m ropen=ropen_mix rclosed=rclosed_mix
EMIXQ_c002_0_04 (mix_q_src_c002_0_04 0 bpf_c002_0 0) vcvs gain=9.807852804032e-01
SMIXQ_c002_0_04 (mix_q_src_c002_0_04 mix_q_c002_0 win_0_04 0) relay vt1=-1m vt2=1m ropen=ropen_mix rclosed=rclosed_mix
EMIXI_c002_0_05 (mix_i_src_c002_0_05 0 bpf_c002_0 0) vcvs gain=-5.555702330196e-01
SMIXI_c002_0_05 (mix_i_src_c002_0_05 mix_i_c002_0 win_0_05 0) relay vt1=-1m vt2=1m ropen=ropen_mix rclosed=rclosed_mix
EMIXQ_c002_0_05 (mix_q_src_c002_0_05 0 bpf_c002_0 0) vcvs gain=8.314696123025e-01
SMIXQ_c002_0_05 (mix_q_src_c002_0_05 mix_q_c002_0 win_0_05 0) relay vt1=-1m vt2=1m ropen=ropen_mix rclosed=rclosed_mix
EMIXI_c002_0_06 (mix_i_src_c002_0_06 0 bpf_c002_0 0) vcvs gain=-8.314696123025e-01
SMIXI_c002_0_06 (mix_i_src_c002_0_06 mix_i_c002_0 win_0_06 0) relay vt1=-1m vt2=1m ropen=ropen_mix rclosed=rclosed_mix
EMIXQ_c002_0_06 (mix_q_src_c002_0_06 0 bpf_c002_0 0) vcvs gain=5.555702330196e-01
SMIXQ_c002_0_06 (mix_q_src_c002_0_06 mix_q_c002_0 win_0_06 0) relay vt1=-1m vt2=1m ropen=ropen_mix rclosed=rclosed_mix
EMIXI_c002_0_07 (mix_i_src_c002_0_07 0 bpf_c002_0 0) vcvs gain=-9.807852804032e-01
SMIXI_c002_0_07 (mix_i_src_c002_0_07 mix_i_c002_0 win_0_07 0) relay vt1=-1m vt2=1m ropen=ropen_mix rclosed=rclosed_mix
EMIXQ_c002_0_07 (mix_q_src_c002_0_07 0 bpf_c002_0 0) vcvs gain=1.950903220161e-01
SMIXQ_c002_0_07 (mix_q_src_c002_0_07 mix_q_c002_0 win_0_07 0) relay vt1=-1m vt2=1m ropen=ropen_mix rclosed=rclosed_mix
EMIXI_c002_0_08 (mix_i_src_c002_0_08 0 bpf_c002_0 0) vcvs gain=-9.807852804032e-01
SMIXI_c002_0_08 (mix_i_src_c002_0_08 mix_i_c002_0 win_0_08 0) relay vt1=-1m vt2=1m ropen=ropen_mix rclosed=rclosed_mix
EMIXQ_c002_0_08 (mix_q_src_c002_0_08 0 bpf_c002_0 0) vcvs gain=-1.950903220161e-01
SMIXQ_c002_0_08 (mix_q_src_c002_0_08 mix_q_c002_0 win_0_08 0) relay vt1=-1m vt2=1m ropen=ropen_mix rclosed=rclosed_mix
EMIXI_c002_0_09 (mix_i_src_c002_0_09 0 bpf_c002_0 0) vcvs gain=-8.314696123025e-01
SMIXI_c002_0_09 (mix_i_src_c002_0_09 mix_i_c002_0 win_0_09 0) relay vt1=-1m vt2=1m ropen=ropen_mix rclosed=rclosed_mix
EMIXQ_c002_0_09 (mix_q_src_c002_0_09 0 bpf_c002_0 0) vcvs gain=-5.555702330196e-01
SMIXQ_c002_0_09 (mix_q_src_c002_0_09 mix_q_c002_0 win_0_09 0) relay vt1=-1m vt2=1m ropen=ropen_mix rclosed=rclosed_mix
EMIXI_c002_0_10 (mix_i_src_c002_0_10 0 bpf_c002_0 0) vcvs gain=-5.555702330196e-01
SMIXI_c002_0_10 (mix_i_src_c002_0_10 mix_i_c002_0 win_0_10 0) relay vt1=-1m vt2=1m ropen=ropen_mix rclosed=rclosed_mix
EMIXQ_c002_0_10 (mix_q_src_c002_0_10 0 bpf_c002_0 0) vcvs gain=-8.314696123025e-01
SMIXQ_c002_0_10 (mix_q_src_c002_0_10 mix_q_c002_0 win_0_10 0) relay vt1=-1m vt2=1m ropen=ropen_mix rclosed=rclosed_mix
EMIXI_c002_0_11 (mix_i_src_c002_0_11 0 bpf_c002_0 0) vcvs gain=-1.950903220161e-01
SMIXI_c002_0_11 (mix_i_src_c002_0_11 mix_i_c002_0 win_0_11 0) relay vt1=-1m vt2=1m ropen=ropen_mix rclosed=rclosed_mix
EMIXQ_c002_0_11 (mix_q_src_c002_0_11 0 bpf_c002_0 0) vcvs gain=-9.807852804032e-01
SMIXQ_c002_0_11 (mix_q_src_c002_0_11 mix_q_c002_0 win_0_11 0) relay vt1=-1m vt2=1m ropen=ropen_mix rclosed=rclosed_mix
EMIXI_c002_0_12 (mix_i_src_c002_0_12 0 bpf_c002_0 0) vcvs gain=1.950903220161e-01
SMIXI_c002_0_12 (mix_i_src_c002_0_12 mix_i_c002_0 win_0_12 0) relay vt1=-1m vt2=1m ropen=ropen_mix rclosed=rclosed_mix
EMIXQ_c002_0_12 (mix_q_src_c002_0_12 0 bpf_c002_0 0) vcvs gain=-9.807852804032e-01
SMIXQ_c002_0_12 (mix_q_src_c002_0_12 mix_q_c002_0 win_0_12 0) relay vt1=-1m vt2=1m ropen=ropen_mix rclosed=rclosed_mix
EMIXI_c002_0_13 (mix_i_src_c002_0_13 0 bpf_c002_0 0) vcvs gain=5.555702330196e-01
SMIXI_c002_0_13 (mix_i_src_c002_0_13 mix_i_c002_0 win_0_13 0) relay vt1=-1m vt2=1m ropen=ropen_mix rclosed=rclosed_mix
EMIXQ_c002_0_13 (mix_q_src_c002_0_13 0 bpf_c002_0 0) vcvs gain=-8.314696123025e-01
SMIXQ_c002_0_13 (mix_q_src_c002_0_13 mix_q_c002_0 win_0_13 0) relay vt1=-1m vt2=1m ropen=ropen_mix rclosed=rclosed_mix
EMIXI_c002_0_14 (mix_i_src_c002_0_14 0 bpf_c002_0 0) vcvs gain=8.314696123025e-01
SMIXI_c002_0_14 (mix_i_src_c002_0_14 mix_i_c002_0 win_0_14 0) relay vt1=-1m vt2=1m ropen=ropen_mix rclosed=rclosed_mix
EMIXQ_c002_0_14 (mix_q_src_c002_0_14 0 bpf_c002_0 0) vcvs gain=-5.555702330196e-01
SMIXQ_c002_0_14 (mix_q_src_c002_0_14 mix_q_c002_0 win_0_14 0) relay vt1=-1m vt2=1m ropen=ropen_mix rclosed=rclosed_mix
EMIXI_c002_0_15 (mix_i_src_c002_0_15 0 bpf_c002_0 0) vcvs gain=9.807852804032e-01
SMIXI_c002_0_15 (mix_i_src_c002_0_15 mix_i_c002_0 win_0_15 0) relay vt1=-1m vt2=1m ropen=ropen_mix rclosed=rclosed_mix
EMIXQ_c002_0_15 (mix_q_src_c002_0_15 0 bpf_c002_0 0) vcvs gain=-1.950903220161e-01
SMIXQ_c002_0_15 (mix_q_src_c002_0_15 mix_q_c002_0 win_0_15 0) relay vt1=-1m vt2=1m ropen=ropen_mix rclosed=rclosed_mix
RMIXI_c002_0 (mix_i_c002_0 0) resistor r=1G
RMIXQ_c002_0 (mix_q_c002_0 0) resistor r=1G
RINTI_c002_0 (mix_i_c002_0 Icar_c002_0) resistor r=1k
CINTI_c002_0 (Icar_c002_0 0) capacitor c=80p
RINTQ_c002_0 (mix_q_c002_0 Qcar_c002_0) resistor r=1k
CINTQ_c002_0 (Qcar_c002_0 0) capacitor c=80p
save bpf_c002_0 Icar_c002_0 Qcar_c002_0

// bl002, carrier_1: 500000000 Hz coherent I/Q phase-window verification-demod path
CBPF_c002_1 (bl002 n_cbpf_c002_1) capacitor c=1.013211836423e-13
LBPF_c002_1 (n_cbpf_c002_1 bpf_c002_1) inductor l=1.000000000000e-06
RBPF_c002_1 (bpf_c002_1 0) resistor r=1.570796326795e+02
EMIXI_c002_1_00 (mix_i_src_c002_1_00 0 bpf_c002_1 0) vcvs gain=9.807852804032e-01
SMIXI_c002_1_00 (mix_i_src_c002_1_00 mix_i_c002_1 win_1_00 0) relay vt1=-1m vt2=1m ropen=ropen_mix rclosed=rclosed_mix
EMIXQ_c002_1_00 (mix_q_src_c002_1_00 0 bpf_c002_1 0) vcvs gain=1.950903220161e-01
SMIXQ_c002_1_00 (mix_q_src_c002_1_00 mix_q_c002_1 win_1_00 0) relay vt1=-1m vt2=1m ropen=ropen_mix rclosed=rclosed_mix
EMIXI_c002_1_01 (mix_i_src_c002_1_01 0 bpf_c002_1 0) vcvs gain=8.314696123025e-01
SMIXI_c002_1_01 (mix_i_src_c002_1_01 mix_i_c002_1 win_1_01 0) relay vt1=-1m vt2=1m ropen=ropen_mix rclosed=rclosed_mix
EMIXQ_c002_1_01 (mix_q_src_c002_1_01 0 bpf_c002_1 0) vcvs gain=5.555702330196e-01
SMIXQ_c002_1_01 (mix_q_src_c002_1_01 mix_q_c002_1 win_1_01 0) relay vt1=-1m vt2=1m ropen=ropen_mix rclosed=rclosed_mix
EMIXI_c002_1_02 (mix_i_src_c002_1_02 0 bpf_c002_1 0) vcvs gain=5.555702330196e-01
SMIXI_c002_1_02 (mix_i_src_c002_1_02 mix_i_c002_1 win_1_02 0) relay vt1=-1m vt2=1m ropen=ropen_mix rclosed=rclosed_mix
EMIXQ_c002_1_02 (mix_q_src_c002_1_02 0 bpf_c002_1 0) vcvs gain=8.314696123025e-01
SMIXQ_c002_1_02 (mix_q_src_c002_1_02 mix_q_c002_1 win_1_02 0) relay vt1=-1m vt2=1m ropen=ropen_mix rclosed=rclosed_mix
EMIXI_c002_1_03 (mix_i_src_c002_1_03 0 bpf_c002_1 0) vcvs gain=1.950903220161e-01
SMIXI_c002_1_03 (mix_i_src_c002_1_03 mix_i_c002_1 win_1_03 0) relay vt1=-1m vt2=1m ropen=ropen_mix rclosed=rclosed_mix
EMIXQ_c002_1_03 (mix_q_src_c002_1_03 0 bpf_c002_1 0) vcvs gain=9.807852804032e-01
SMIXQ_c002_1_03 (mix_q_src_c002_1_03 mix_q_c002_1 win_1_03 0) relay vt1=-1m vt2=1m ropen=ropen_mix rclosed=rclosed_mix
EMIXI_c002_1_04 (mix_i_src_c002_1_04 0 bpf_c002_1 0) vcvs gain=-1.950903220161e-01
SMIXI_c002_1_04 (mix_i_src_c002_1_04 mix_i_c002_1 win_1_04 0) relay vt1=-1m vt2=1m ropen=ropen_mix rclosed=rclosed_mix
EMIXQ_c002_1_04 (mix_q_src_c002_1_04 0 bpf_c002_1 0) vcvs gain=9.807852804032e-01
SMIXQ_c002_1_04 (mix_q_src_c002_1_04 mix_q_c002_1 win_1_04 0) relay vt1=-1m vt2=1m ropen=ropen_mix rclosed=rclosed_mix
EMIXI_c002_1_05 (mix_i_src_c002_1_05 0 bpf_c002_1 0) vcvs gain=-5.555702330196e-01
SMIXI_c002_1_05 (mix_i_src_c002_1_05 mix_i_c002_1 win_1_05 0) relay vt1=-1m vt2=1m ropen=ropen_mix rclosed=rclosed_mix
EMIXQ_c002_1_05 (mix_q_src_c002_1_05 0 bpf_c002_1 0) vcvs gain=8.314696123025e-01
SMIXQ_c002_1_05 (mix_q_src_c002_1_05 mix_q_c002_1 win_1_05 0) relay vt1=-1m vt2=1m ropen=ropen_mix rclosed=rclosed_mix
EMIXI_c002_1_06 (mix_i_src_c002_1_06 0 bpf_c002_1 0) vcvs gain=-8.314696123025e-01
SMIXI_c002_1_06 (mix_i_src_c002_1_06 mix_i_c002_1 win_1_06 0) relay vt1=-1m vt2=1m ropen=ropen_mix rclosed=rclosed_mix
EMIXQ_c002_1_06 (mix_q_src_c002_1_06 0 bpf_c002_1 0) vcvs gain=5.555702330196e-01
SMIXQ_c002_1_06 (mix_q_src_c002_1_06 mix_q_c002_1 win_1_06 0) relay vt1=-1m vt2=1m ropen=ropen_mix rclosed=rclosed_mix
EMIXI_c002_1_07 (mix_i_src_c002_1_07 0 bpf_c002_1 0) vcvs gain=-9.807852804032e-01
SMIXI_c002_1_07 (mix_i_src_c002_1_07 mix_i_c002_1 win_1_07 0) relay vt1=-1m vt2=1m ropen=ropen_mix rclosed=rclosed_mix
EMIXQ_c002_1_07 (mix_q_src_c002_1_07 0 bpf_c002_1 0) vcvs gain=1.950903220161e-01
SMIXQ_c002_1_07 (mix_q_src_c002_1_07 mix_q_c002_1 win_1_07 0) relay vt1=-1m vt2=1m ropen=ropen_mix rclosed=rclosed_mix
EMIXI_c002_1_08 (mix_i_src_c002_1_08 0 bpf_c002_1 0) vcvs gain=-9.807852804032e-01
SMIXI_c002_1_08 (mix_i_src_c002_1_08 mix_i_c002_1 win_1_08 0) relay vt1=-1m vt2=1m ropen=ropen_mix rclosed=rclosed_mix
EMIXQ_c002_1_08 (mix_q_src_c002_1_08 0 bpf_c002_1 0) vcvs gain=-1.950903220161e-01
SMIXQ_c002_1_08 (mix_q_src_c002_1_08 mix_q_c002_1 win_1_08 0) relay vt1=-1m vt2=1m ropen=ropen_mix rclosed=rclosed_mix
EMIXI_c002_1_09 (mix_i_src_c002_1_09 0 bpf_c002_1 0) vcvs gain=-8.314696123025e-01
SMIXI_c002_1_09 (mix_i_src_c002_1_09 mix_i_c002_1 win_1_09 0) relay vt1=-1m vt2=1m ropen=ropen_mix rclosed=rclosed_mix
EMIXQ_c002_1_09 (mix_q_src_c002_1_09 0 bpf_c002_1 0) vcvs gain=-5.555702330196e-01
SMIXQ_c002_1_09 (mix_q_src_c002_1_09 mix_q_c002_1 win_1_09 0) relay vt1=-1m vt2=1m ropen=ropen_mix rclosed=rclosed_mix
EMIXI_c002_1_10 (mix_i_src_c002_1_10 0 bpf_c002_1 0) vcvs gain=-5.555702330196e-01
SMIXI_c002_1_10 (mix_i_src_c002_1_10 mix_i_c002_1 win_1_10 0) relay vt1=-1m vt2=1m ropen=ropen_mix rclosed=rclosed_mix
EMIXQ_c002_1_10 (mix_q_src_c002_1_10 0 bpf_c002_1 0) vcvs gain=-8.314696123025e-01
SMIXQ_c002_1_10 (mix_q_src_c002_1_10 mix_q_c002_1 win_1_10 0) relay vt1=-1m vt2=1m ropen=ropen_mix rclosed=rclosed_mix
EMIXI_c002_1_11 (mix_i_src_c002_1_11 0 bpf_c002_1 0) vcvs gain=-1.950903220161e-01
SMIXI_c002_1_11 (mix_i_src_c002_1_11 mix_i_c002_1 win_1_11 0) relay vt1=-1m vt2=1m ropen=ropen_mix rclosed=rclosed_mix
EMIXQ_c002_1_11 (mix_q_src_c002_1_11 0 bpf_c002_1 0) vcvs gain=-9.807852804032e-01
SMIXQ_c002_1_11 (mix_q_src_c002_1_11 mix_q_c002_1 win_1_11 0) relay vt1=-1m vt2=1m ropen=ropen_mix rclosed=rclosed_mix
EMIXI_c002_1_12 (mix_i_src_c002_1_12 0 bpf_c002_1 0) vcvs gain=1.950903220161e-01
SMIXI_c002_1_12 (mix_i_src_c002_1_12 mix_i_c002_1 win_1_12 0) relay vt1=-1m vt2=1m ropen=ropen_mix rclosed=rclosed_mix
EMIXQ_c002_1_12 (mix_q_src_c002_1_12 0 bpf_c002_1 0) vcvs gain=-9.807852804032e-01
SMIXQ_c002_1_12 (mix_q_src_c002_1_12 mix_q_c002_1 win_1_12 0) relay vt1=-1m vt2=1m ropen=ropen_mix rclosed=rclosed_mix
EMIXI_c002_1_13 (mix_i_src_c002_1_13 0 bpf_c002_1 0) vcvs gain=5.555702330196e-01
SMIXI_c002_1_13 (mix_i_src_c002_1_13 mix_i_c002_1 win_1_13 0) relay vt1=-1m vt2=1m ropen=ropen_mix rclosed=rclosed_mix
EMIXQ_c002_1_13 (mix_q_src_c002_1_13 0 bpf_c002_1 0) vcvs gain=-8.314696123025e-01
SMIXQ_c002_1_13 (mix_q_src_c002_1_13 mix_q_c002_1 win_1_13 0) relay vt1=-1m vt2=1m ropen=ropen_mix rclosed=rclosed_mix
EMIXI_c002_1_14 (mix_i_src_c002_1_14 0 bpf_c002_1 0) vcvs gain=8.314696123025e-01
SMIXI_c002_1_14 (mix_i_src_c002_1_14 mix_i_c002_1 win_1_14 0) relay vt1=-1m vt2=1m ropen=ropen_mix rclosed=rclosed_mix
EMIXQ_c002_1_14 (mix_q_src_c002_1_14 0 bpf_c002_1 0) vcvs gain=-5.555702330196e-01
SMIXQ_c002_1_14 (mix_q_src_c002_1_14 mix_q_c002_1 win_1_14 0) relay vt1=-1m vt2=1m ropen=ropen_mix rclosed=rclosed_mix
EMIXI_c002_1_15 (mix_i_src_c002_1_15 0 bpf_c002_1 0) vcvs gain=9.807852804032e-01
SMIXI_c002_1_15 (mix_i_src_c002_1_15 mix_i_c002_1 win_1_15 0) relay vt1=-1m vt2=1m ropen=ropen_mix rclosed=rclosed_mix
EMIXQ_c002_1_15 (mix_q_src_c002_1_15 0 bpf_c002_1 0) vcvs gain=-1.950903220161e-01
SMIXQ_c002_1_15 (mix_q_src_c002_1_15 mix_q_c002_1 win_1_15 0) relay vt1=-1m vt2=1m ropen=ropen_mix rclosed=rclosed_mix
RMIXI_c002_1 (mix_i_c002_1 0) resistor r=1G
RMIXQ_c002_1 (mix_q_c002_1 0) resistor r=1G
RINTI_c002_1 (mix_i_c002_1 Icar_c002_1) resistor r=1k
CINTI_c002_1 (Icar_c002_1 0) capacitor c=80p
RINTQ_c002_1 (mix_q_c002_1 Qcar_c002_1) resistor r=1k
CINTQ_c002_1 (Qcar_c002_1 0) capacitor c=80p
save bpf_c002_1 Icar_c002_1 Qcar_c002_1

// bl002, carrier_2: 750000000 Hz coherent I/Q phase-window verification-demod path
CBPF_c002_2 (bl002 n_cbpf_c002_2) capacitor c=4.503163717437e-14
LBPF_c002_2 (n_cbpf_c002_2 bpf_c002_2) inductor l=1.000000000000e-06
RBPF_c002_2 (bpf_c002_2 0) resistor r=2.356194490192e+02
EMIXI_c002_2_00 (mix_i_src_c002_2_00 0 bpf_c002_2 0) vcvs gain=9.807852804032e-01
SMIXI_c002_2_00 (mix_i_src_c002_2_00 mix_i_c002_2 win_2_00 0) relay vt1=-1m vt2=1m ropen=ropen_mix rclosed=rclosed_mix
EMIXQ_c002_2_00 (mix_q_src_c002_2_00 0 bpf_c002_2 0) vcvs gain=1.950903220161e-01
SMIXQ_c002_2_00 (mix_q_src_c002_2_00 mix_q_c002_2 win_2_00 0) relay vt1=-1m vt2=1m ropen=ropen_mix rclosed=rclosed_mix
EMIXI_c002_2_01 (mix_i_src_c002_2_01 0 bpf_c002_2 0) vcvs gain=8.314696123025e-01
SMIXI_c002_2_01 (mix_i_src_c002_2_01 mix_i_c002_2 win_2_01 0) relay vt1=-1m vt2=1m ropen=ropen_mix rclosed=rclosed_mix
EMIXQ_c002_2_01 (mix_q_src_c002_2_01 0 bpf_c002_2 0) vcvs gain=5.555702330196e-01
SMIXQ_c002_2_01 (mix_q_src_c002_2_01 mix_q_c002_2 win_2_01 0) relay vt1=-1m vt2=1m ropen=ropen_mix rclosed=rclosed_mix
EMIXI_c002_2_02 (mix_i_src_c002_2_02 0 bpf_c002_2 0) vcvs gain=5.555702330196e-01
SMIXI_c002_2_02 (mix_i_src_c002_2_02 mix_i_c002_2 win_2_02 0) relay vt1=-1m vt2=1m ropen=ropen_mix rclosed=rclosed_mix
EMIXQ_c002_2_02 (mix_q_src_c002_2_02 0 bpf_c002_2 0) vcvs gain=8.314696123025e-01
SMIXQ_c002_2_02 (mix_q_src_c002_2_02 mix_q_c002_2 win_2_02 0) relay vt1=-1m vt2=1m ropen=ropen_mix rclosed=rclosed_mix
EMIXI_c002_2_03 (mix_i_src_c002_2_03 0 bpf_c002_2 0) vcvs gain=1.950903220161e-01
SMIXI_c002_2_03 (mix_i_src_c002_2_03 mix_i_c002_2 win_2_03 0) relay vt1=-1m vt2=1m ropen=ropen_mix rclosed=rclosed_mix
EMIXQ_c002_2_03 (mix_q_src_c002_2_03 0 bpf_c002_2 0) vcvs gain=9.807852804032e-01
SMIXQ_c002_2_03 (mix_q_src_c002_2_03 mix_q_c002_2 win_2_03 0) relay vt1=-1m vt2=1m ropen=ropen_mix rclosed=rclosed_mix
EMIXI_c002_2_04 (mix_i_src_c002_2_04 0 bpf_c002_2 0) vcvs gain=-1.950903220161e-01
SMIXI_c002_2_04 (mix_i_src_c002_2_04 mix_i_c002_2 win_2_04 0) relay vt1=-1m vt2=1m ropen=ropen_mix rclosed=rclosed_mix
EMIXQ_c002_2_04 (mix_q_src_c002_2_04 0 bpf_c002_2 0) vcvs gain=9.807852804032e-01
SMIXQ_c002_2_04 (mix_q_src_c002_2_04 mix_q_c002_2 win_2_04 0) relay vt1=-1m vt2=1m ropen=ropen_mix rclosed=rclosed_mix
EMIXI_c002_2_05 (mix_i_src_c002_2_05 0 bpf_c002_2 0) vcvs gain=-5.555702330196e-01
SMIXI_c002_2_05 (mix_i_src_c002_2_05 mix_i_c002_2 win_2_05 0) relay vt1=-1m vt2=1m ropen=ropen_mix rclosed=rclosed_mix
EMIXQ_c002_2_05 (mix_q_src_c002_2_05 0 bpf_c002_2 0) vcvs gain=8.314696123025e-01
SMIXQ_c002_2_05 (mix_q_src_c002_2_05 mix_q_c002_2 win_2_05 0) relay vt1=-1m vt2=1m ropen=ropen_mix rclosed=rclosed_mix
EMIXI_c002_2_06 (mix_i_src_c002_2_06 0 bpf_c002_2 0) vcvs gain=-8.314696123025e-01
SMIXI_c002_2_06 (mix_i_src_c002_2_06 mix_i_c002_2 win_2_06 0) relay vt1=-1m vt2=1m ropen=ropen_mix rclosed=rclosed_mix
EMIXQ_c002_2_06 (mix_q_src_c002_2_06 0 bpf_c002_2 0) vcvs gain=5.555702330196e-01
SMIXQ_c002_2_06 (mix_q_src_c002_2_06 mix_q_c002_2 win_2_06 0) relay vt1=-1m vt2=1m ropen=ropen_mix rclosed=rclosed_mix
EMIXI_c002_2_07 (mix_i_src_c002_2_07 0 bpf_c002_2 0) vcvs gain=-9.807852804032e-01
SMIXI_c002_2_07 (mix_i_src_c002_2_07 mix_i_c002_2 win_2_07 0) relay vt1=-1m vt2=1m ropen=ropen_mix rclosed=rclosed_mix
EMIXQ_c002_2_07 (mix_q_src_c002_2_07 0 bpf_c002_2 0) vcvs gain=1.950903220161e-01
SMIXQ_c002_2_07 (mix_q_src_c002_2_07 mix_q_c002_2 win_2_07 0) relay vt1=-1m vt2=1m ropen=ropen_mix rclosed=rclosed_mix
EMIXI_c002_2_08 (mix_i_src_c002_2_08 0 bpf_c002_2 0) vcvs gain=-9.807852804032e-01
SMIXI_c002_2_08 (mix_i_src_c002_2_08 mix_i_c002_2 win_2_08 0) relay vt1=-1m vt2=1m ropen=ropen_mix rclosed=rclosed_mix
EMIXQ_c002_2_08 (mix_q_src_c002_2_08 0 bpf_c002_2 0) vcvs gain=-1.950903220161e-01
SMIXQ_c002_2_08 (mix_q_src_c002_2_08 mix_q_c002_2 win_2_08 0) relay vt1=-1m vt2=1m ropen=ropen_mix rclosed=rclosed_mix
EMIXI_c002_2_09 (mix_i_src_c002_2_09 0 bpf_c002_2 0) vcvs gain=-8.314696123025e-01
SMIXI_c002_2_09 (mix_i_src_c002_2_09 mix_i_c002_2 win_2_09 0) relay vt1=-1m vt2=1m ropen=ropen_mix rclosed=rclosed_mix
EMIXQ_c002_2_09 (mix_q_src_c002_2_09 0 bpf_c002_2 0) vcvs gain=-5.555702330196e-01
SMIXQ_c002_2_09 (mix_q_src_c002_2_09 mix_q_c002_2 win_2_09 0) relay vt1=-1m vt2=1m ropen=ropen_mix rclosed=rclosed_mix
EMIXI_c002_2_10 (mix_i_src_c002_2_10 0 bpf_c002_2 0) vcvs gain=-5.555702330196e-01
SMIXI_c002_2_10 (mix_i_src_c002_2_10 mix_i_c002_2 win_2_10 0) relay vt1=-1m vt2=1m ropen=ropen_mix rclosed=rclosed_mix
EMIXQ_c002_2_10 (mix_q_src_c002_2_10 0 bpf_c002_2 0) vcvs gain=-8.314696123025e-01
SMIXQ_c002_2_10 (mix_q_src_c002_2_10 mix_q_c002_2 win_2_10 0) relay vt1=-1m vt2=1m ropen=ropen_mix rclosed=rclosed_mix
EMIXI_c002_2_11 (mix_i_src_c002_2_11 0 bpf_c002_2 0) vcvs gain=-1.950903220161e-01
SMIXI_c002_2_11 (mix_i_src_c002_2_11 mix_i_c002_2 win_2_11 0) relay vt1=-1m vt2=1m ropen=ropen_mix rclosed=rclosed_mix
EMIXQ_c002_2_11 (mix_q_src_c002_2_11 0 bpf_c002_2 0) vcvs gain=-9.807852804032e-01
SMIXQ_c002_2_11 (mix_q_src_c002_2_11 mix_q_c002_2 win_2_11 0) relay vt1=-1m vt2=1m ropen=ropen_mix rclosed=rclosed_mix
EMIXI_c002_2_12 (mix_i_src_c002_2_12 0 bpf_c002_2 0) vcvs gain=1.950903220161e-01
SMIXI_c002_2_12 (mix_i_src_c002_2_12 mix_i_c002_2 win_2_12 0) relay vt1=-1m vt2=1m ropen=ropen_mix rclosed=rclosed_mix
EMIXQ_c002_2_12 (mix_q_src_c002_2_12 0 bpf_c002_2 0) vcvs gain=-9.807852804032e-01
SMIXQ_c002_2_12 (mix_q_src_c002_2_12 mix_q_c002_2 win_2_12 0) relay vt1=-1m vt2=1m ropen=ropen_mix rclosed=rclosed_mix
EMIXI_c002_2_13 (mix_i_src_c002_2_13 0 bpf_c002_2 0) vcvs gain=5.555702330196e-01
SMIXI_c002_2_13 (mix_i_src_c002_2_13 mix_i_c002_2 win_2_13 0) relay vt1=-1m vt2=1m ropen=ropen_mix rclosed=rclosed_mix
EMIXQ_c002_2_13 (mix_q_src_c002_2_13 0 bpf_c002_2 0) vcvs gain=-8.314696123025e-01
SMIXQ_c002_2_13 (mix_q_src_c002_2_13 mix_q_c002_2 win_2_13 0) relay vt1=-1m vt2=1m ropen=ropen_mix rclosed=rclosed_mix
EMIXI_c002_2_14 (mix_i_src_c002_2_14 0 bpf_c002_2 0) vcvs gain=8.314696123025e-01
SMIXI_c002_2_14 (mix_i_src_c002_2_14 mix_i_c002_2 win_2_14 0) relay vt1=-1m vt2=1m ropen=ropen_mix rclosed=rclosed_mix
EMIXQ_c002_2_14 (mix_q_src_c002_2_14 0 bpf_c002_2 0) vcvs gain=-5.555702330196e-01
SMIXQ_c002_2_14 (mix_q_src_c002_2_14 mix_q_c002_2 win_2_14 0) relay vt1=-1m vt2=1m ropen=ropen_mix rclosed=rclosed_mix
EMIXI_c002_2_15 (mix_i_src_c002_2_15 0 bpf_c002_2 0) vcvs gain=9.807852804032e-01
SMIXI_c002_2_15 (mix_i_src_c002_2_15 mix_i_c002_2 win_2_15 0) relay vt1=-1m vt2=1m ropen=ropen_mix rclosed=rclosed_mix
EMIXQ_c002_2_15 (mix_q_src_c002_2_15 0 bpf_c002_2 0) vcvs gain=-1.950903220161e-01
SMIXQ_c002_2_15 (mix_q_src_c002_2_15 mix_q_c002_2 win_2_15 0) relay vt1=-1m vt2=1m ropen=ropen_mix rclosed=rclosed_mix
RMIXI_c002_2 (mix_i_c002_2 0) resistor r=1G
RMIXQ_c002_2 (mix_q_c002_2 0) resistor r=1G
RINTI_c002_2 (mix_i_c002_2 Icar_c002_2) resistor r=1k
CINTI_c002_2 (Icar_c002_2 0) capacitor c=80p
RINTQ_c002_2 (mix_q_c002_2 Qcar_c002_2) resistor r=1k
CINTQ_c002_2 (Qcar_c002_2 0) capacitor c=80p
save bpf_c002_2 Icar_c002_2 Qcar_c002_2

// bl002, carrier_3: 1000000000 Hz coherent I/Q phase-window verification-demod path
CBPF_c002_3 (bl002 n_cbpf_c002_3) capacitor c=2.533029591058e-14
LBPF_c002_3 (n_cbpf_c002_3 bpf_c002_3) inductor l=1.000000000000e-06
RBPF_c002_3 (bpf_c002_3 0) resistor r=3.141592653590e+02
EMIXI_c002_3_00 (mix_i_src_c002_3_00 0 bpf_c002_3 0) vcvs gain=9.807852804032e-01
SMIXI_c002_3_00 (mix_i_src_c002_3_00 mix_i_c002_3 win_3_00 0) relay vt1=-1m vt2=1m ropen=ropen_mix rclosed=rclosed_mix
EMIXQ_c002_3_00 (mix_q_src_c002_3_00 0 bpf_c002_3 0) vcvs gain=1.950903220161e-01
SMIXQ_c002_3_00 (mix_q_src_c002_3_00 mix_q_c002_3 win_3_00 0) relay vt1=-1m vt2=1m ropen=ropen_mix rclosed=rclosed_mix
EMIXI_c002_3_01 (mix_i_src_c002_3_01 0 bpf_c002_3 0) vcvs gain=8.314696123025e-01
SMIXI_c002_3_01 (mix_i_src_c002_3_01 mix_i_c002_3 win_3_01 0) relay vt1=-1m vt2=1m ropen=ropen_mix rclosed=rclosed_mix
EMIXQ_c002_3_01 (mix_q_src_c002_3_01 0 bpf_c002_3 0) vcvs gain=5.555702330196e-01
SMIXQ_c002_3_01 (mix_q_src_c002_3_01 mix_q_c002_3 win_3_01 0) relay vt1=-1m vt2=1m ropen=ropen_mix rclosed=rclosed_mix
EMIXI_c002_3_02 (mix_i_src_c002_3_02 0 bpf_c002_3 0) vcvs gain=5.555702330196e-01
SMIXI_c002_3_02 (mix_i_src_c002_3_02 mix_i_c002_3 win_3_02 0) relay vt1=-1m vt2=1m ropen=ropen_mix rclosed=rclosed_mix
EMIXQ_c002_3_02 (mix_q_src_c002_3_02 0 bpf_c002_3 0) vcvs gain=8.314696123025e-01
SMIXQ_c002_3_02 (mix_q_src_c002_3_02 mix_q_c002_3 win_3_02 0) relay vt1=-1m vt2=1m ropen=ropen_mix rclosed=rclosed_mix
EMIXI_c002_3_03 (mix_i_src_c002_3_03 0 bpf_c002_3 0) vcvs gain=1.950903220161e-01
SMIXI_c002_3_03 (mix_i_src_c002_3_03 mix_i_c002_3 win_3_03 0) relay vt1=-1m vt2=1m ropen=ropen_mix rclosed=rclosed_mix
EMIXQ_c002_3_03 (mix_q_src_c002_3_03 0 bpf_c002_3 0) vcvs gain=9.807852804032e-01
SMIXQ_c002_3_03 (mix_q_src_c002_3_03 mix_q_c002_3 win_3_03 0) relay vt1=-1m vt2=1m ropen=ropen_mix rclosed=rclosed_mix
EMIXI_c002_3_04 (mix_i_src_c002_3_04 0 bpf_c002_3 0) vcvs gain=-1.950903220161e-01
SMIXI_c002_3_04 (mix_i_src_c002_3_04 mix_i_c002_3 win_3_04 0) relay vt1=-1m vt2=1m ropen=ropen_mix rclosed=rclosed_mix
EMIXQ_c002_3_04 (mix_q_src_c002_3_04 0 bpf_c002_3 0) vcvs gain=9.807852804032e-01
SMIXQ_c002_3_04 (mix_q_src_c002_3_04 mix_q_c002_3 win_3_04 0) relay vt1=-1m vt2=1m ropen=ropen_mix rclosed=rclosed_mix
EMIXI_c002_3_05 (mix_i_src_c002_3_05 0 bpf_c002_3 0) vcvs gain=-5.555702330196e-01
SMIXI_c002_3_05 (mix_i_src_c002_3_05 mix_i_c002_3 win_3_05 0) relay vt1=-1m vt2=1m ropen=ropen_mix rclosed=rclosed_mix
EMIXQ_c002_3_05 (mix_q_src_c002_3_05 0 bpf_c002_3 0) vcvs gain=8.314696123025e-01
SMIXQ_c002_3_05 (mix_q_src_c002_3_05 mix_q_c002_3 win_3_05 0) relay vt1=-1m vt2=1m ropen=ropen_mix rclosed=rclosed_mix
EMIXI_c002_3_06 (mix_i_src_c002_3_06 0 bpf_c002_3 0) vcvs gain=-8.314696123025e-01
SMIXI_c002_3_06 (mix_i_src_c002_3_06 mix_i_c002_3 win_3_06 0) relay vt1=-1m vt2=1m ropen=ropen_mix rclosed=rclosed_mix
EMIXQ_c002_3_06 (mix_q_src_c002_3_06 0 bpf_c002_3 0) vcvs gain=5.555702330196e-01
SMIXQ_c002_3_06 (mix_q_src_c002_3_06 mix_q_c002_3 win_3_06 0) relay vt1=-1m vt2=1m ropen=ropen_mix rclosed=rclosed_mix
EMIXI_c002_3_07 (mix_i_src_c002_3_07 0 bpf_c002_3 0) vcvs gain=-9.807852804032e-01
SMIXI_c002_3_07 (mix_i_src_c002_3_07 mix_i_c002_3 win_3_07 0) relay vt1=-1m vt2=1m ropen=ropen_mix rclosed=rclosed_mix
EMIXQ_c002_3_07 (mix_q_src_c002_3_07 0 bpf_c002_3 0) vcvs gain=1.950903220161e-01
SMIXQ_c002_3_07 (mix_q_src_c002_3_07 mix_q_c002_3 win_3_07 0) relay vt1=-1m vt2=1m ropen=ropen_mix rclosed=rclosed_mix
EMIXI_c002_3_08 (mix_i_src_c002_3_08 0 bpf_c002_3 0) vcvs gain=-9.807852804032e-01
SMIXI_c002_3_08 (mix_i_src_c002_3_08 mix_i_c002_3 win_3_08 0) relay vt1=-1m vt2=1m ropen=ropen_mix rclosed=rclosed_mix
EMIXQ_c002_3_08 (mix_q_src_c002_3_08 0 bpf_c002_3 0) vcvs gain=-1.950903220161e-01
SMIXQ_c002_3_08 (mix_q_src_c002_3_08 mix_q_c002_3 win_3_08 0) relay vt1=-1m vt2=1m ropen=ropen_mix rclosed=rclosed_mix
EMIXI_c002_3_09 (mix_i_src_c002_3_09 0 bpf_c002_3 0) vcvs gain=-8.314696123025e-01
SMIXI_c002_3_09 (mix_i_src_c002_3_09 mix_i_c002_3 win_3_09 0) relay vt1=-1m vt2=1m ropen=ropen_mix rclosed=rclosed_mix
EMIXQ_c002_3_09 (mix_q_src_c002_3_09 0 bpf_c002_3 0) vcvs gain=-5.555702330196e-01
SMIXQ_c002_3_09 (mix_q_src_c002_3_09 mix_q_c002_3 win_3_09 0) relay vt1=-1m vt2=1m ropen=ropen_mix rclosed=rclosed_mix
EMIXI_c002_3_10 (mix_i_src_c002_3_10 0 bpf_c002_3 0) vcvs gain=-5.555702330196e-01
SMIXI_c002_3_10 (mix_i_src_c002_3_10 mix_i_c002_3 win_3_10 0) relay vt1=-1m vt2=1m ropen=ropen_mix rclosed=rclosed_mix
EMIXQ_c002_3_10 (mix_q_src_c002_3_10 0 bpf_c002_3 0) vcvs gain=-8.314696123025e-01
SMIXQ_c002_3_10 (mix_q_src_c002_3_10 mix_q_c002_3 win_3_10 0) relay vt1=-1m vt2=1m ropen=ropen_mix rclosed=rclosed_mix
EMIXI_c002_3_11 (mix_i_src_c002_3_11 0 bpf_c002_3 0) vcvs gain=-1.950903220161e-01
SMIXI_c002_3_11 (mix_i_src_c002_3_11 mix_i_c002_3 win_3_11 0) relay vt1=-1m vt2=1m ropen=ropen_mix rclosed=rclosed_mix
EMIXQ_c002_3_11 (mix_q_src_c002_3_11 0 bpf_c002_3 0) vcvs gain=-9.807852804032e-01
SMIXQ_c002_3_11 (mix_q_src_c002_3_11 mix_q_c002_3 win_3_11 0) relay vt1=-1m vt2=1m ropen=ropen_mix rclosed=rclosed_mix
EMIXI_c002_3_12 (mix_i_src_c002_3_12 0 bpf_c002_3 0) vcvs gain=1.950903220161e-01
SMIXI_c002_3_12 (mix_i_src_c002_3_12 mix_i_c002_3 win_3_12 0) relay vt1=-1m vt2=1m ropen=ropen_mix rclosed=rclosed_mix
EMIXQ_c002_3_12 (mix_q_src_c002_3_12 0 bpf_c002_3 0) vcvs gain=-9.807852804032e-01
SMIXQ_c002_3_12 (mix_q_src_c002_3_12 mix_q_c002_3 win_3_12 0) relay vt1=-1m vt2=1m ropen=ropen_mix rclosed=rclosed_mix
EMIXI_c002_3_13 (mix_i_src_c002_3_13 0 bpf_c002_3 0) vcvs gain=5.555702330196e-01
SMIXI_c002_3_13 (mix_i_src_c002_3_13 mix_i_c002_3 win_3_13 0) relay vt1=-1m vt2=1m ropen=ropen_mix rclosed=rclosed_mix
EMIXQ_c002_3_13 (mix_q_src_c002_3_13 0 bpf_c002_3 0) vcvs gain=-8.314696123025e-01
SMIXQ_c002_3_13 (mix_q_src_c002_3_13 mix_q_c002_3 win_3_13 0) relay vt1=-1m vt2=1m ropen=ropen_mix rclosed=rclosed_mix
EMIXI_c002_3_14 (mix_i_src_c002_3_14 0 bpf_c002_3 0) vcvs gain=8.314696123025e-01
SMIXI_c002_3_14 (mix_i_src_c002_3_14 mix_i_c002_3 win_3_14 0) relay vt1=-1m vt2=1m ropen=ropen_mix rclosed=rclosed_mix
EMIXQ_c002_3_14 (mix_q_src_c002_3_14 0 bpf_c002_3 0) vcvs gain=-5.555702330196e-01
SMIXQ_c002_3_14 (mix_q_src_c002_3_14 mix_q_c002_3 win_3_14 0) relay vt1=-1m vt2=1m ropen=ropen_mix rclosed=rclosed_mix
EMIXI_c002_3_15 (mix_i_src_c002_3_15 0 bpf_c002_3 0) vcvs gain=9.807852804032e-01
SMIXI_c002_3_15 (mix_i_src_c002_3_15 mix_i_c002_3 win_3_15 0) relay vt1=-1m vt2=1m ropen=ropen_mix rclosed=rclosed_mix
EMIXQ_c002_3_15 (mix_q_src_c002_3_15 0 bpf_c002_3 0) vcvs gain=-1.950903220161e-01
SMIXQ_c002_3_15 (mix_q_src_c002_3_15 mix_q_c002_3 win_3_15 0) relay vt1=-1m vt2=1m ropen=ropen_mix rclosed=rclosed_mix
RMIXI_c002_3 (mix_i_c002_3 0) resistor r=1G
RMIXQ_c002_3 (mix_q_c002_3 0) resistor r=1G
RINTI_c002_3 (mix_i_c002_3 Icar_c002_3) resistor r=1k
CINTI_c002_3 (Icar_c002_3 0) capacitor c=80p
RINTQ_c002_3 (mix_q_c002_3 Qcar_c002_3) resistor r=1k
CINTQ_c002_3 (Qcar_c002_3 0) capacitor c=80p
save bpf_c002_3 Icar_c002_3 Qcar_c002_3

// bl003, carrier_0: 250000000 Hz coherent I/Q phase-window verification-demod path
CBPF_c003_0 (bl003 n_cbpf_c003_0) capacitor c=4.052847345694e-13
LBPF_c003_0 (n_cbpf_c003_0 bpf_c003_0) inductor l=1.000000000000e-06
RBPF_c003_0 (bpf_c003_0 0) resistor r=7.853981633974e+01
EMIXI_c003_0_00 (mix_i_src_c003_0_00 0 bpf_c003_0 0) vcvs gain=9.807852804032e-01
SMIXI_c003_0_00 (mix_i_src_c003_0_00 mix_i_c003_0 win_0_00 0) relay vt1=-1m vt2=1m ropen=ropen_mix rclosed=rclosed_mix
EMIXQ_c003_0_00 (mix_q_src_c003_0_00 0 bpf_c003_0 0) vcvs gain=1.950903220161e-01
SMIXQ_c003_0_00 (mix_q_src_c003_0_00 mix_q_c003_0 win_0_00 0) relay vt1=-1m vt2=1m ropen=ropen_mix rclosed=rclosed_mix
EMIXI_c003_0_01 (mix_i_src_c003_0_01 0 bpf_c003_0 0) vcvs gain=8.314696123025e-01
SMIXI_c003_0_01 (mix_i_src_c003_0_01 mix_i_c003_0 win_0_01 0) relay vt1=-1m vt2=1m ropen=ropen_mix rclosed=rclosed_mix
EMIXQ_c003_0_01 (mix_q_src_c003_0_01 0 bpf_c003_0 0) vcvs gain=5.555702330196e-01
SMIXQ_c003_0_01 (mix_q_src_c003_0_01 mix_q_c003_0 win_0_01 0) relay vt1=-1m vt2=1m ropen=ropen_mix rclosed=rclosed_mix
EMIXI_c003_0_02 (mix_i_src_c003_0_02 0 bpf_c003_0 0) vcvs gain=5.555702330196e-01
SMIXI_c003_0_02 (mix_i_src_c003_0_02 mix_i_c003_0 win_0_02 0) relay vt1=-1m vt2=1m ropen=ropen_mix rclosed=rclosed_mix
EMIXQ_c003_0_02 (mix_q_src_c003_0_02 0 bpf_c003_0 0) vcvs gain=8.314696123025e-01
SMIXQ_c003_0_02 (mix_q_src_c003_0_02 mix_q_c003_0 win_0_02 0) relay vt1=-1m vt2=1m ropen=ropen_mix rclosed=rclosed_mix
EMIXI_c003_0_03 (mix_i_src_c003_0_03 0 bpf_c003_0 0) vcvs gain=1.950903220161e-01
SMIXI_c003_0_03 (mix_i_src_c003_0_03 mix_i_c003_0 win_0_03 0) relay vt1=-1m vt2=1m ropen=ropen_mix rclosed=rclosed_mix
EMIXQ_c003_0_03 (mix_q_src_c003_0_03 0 bpf_c003_0 0) vcvs gain=9.807852804032e-01
SMIXQ_c003_0_03 (mix_q_src_c003_0_03 mix_q_c003_0 win_0_03 0) relay vt1=-1m vt2=1m ropen=ropen_mix rclosed=rclosed_mix
EMIXI_c003_0_04 (mix_i_src_c003_0_04 0 bpf_c003_0 0) vcvs gain=-1.950903220161e-01
SMIXI_c003_0_04 (mix_i_src_c003_0_04 mix_i_c003_0 win_0_04 0) relay vt1=-1m vt2=1m ropen=ropen_mix rclosed=rclosed_mix
EMIXQ_c003_0_04 (mix_q_src_c003_0_04 0 bpf_c003_0 0) vcvs gain=9.807852804032e-01
SMIXQ_c003_0_04 (mix_q_src_c003_0_04 mix_q_c003_0 win_0_04 0) relay vt1=-1m vt2=1m ropen=ropen_mix rclosed=rclosed_mix
EMIXI_c003_0_05 (mix_i_src_c003_0_05 0 bpf_c003_0 0) vcvs gain=-5.555702330196e-01
SMIXI_c003_0_05 (mix_i_src_c003_0_05 mix_i_c003_0 win_0_05 0) relay vt1=-1m vt2=1m ropen=ropen_mix rclosed=rclosed_mix
EMIXQ_c003_0_05 (mix_q_src_c003_0_05 0 bpf_c003_0 0) vcvs gain=8.314696123025e-01
SMIXQ_c003_0_05 (mix_q_src_c003_0_05 mix_q_c003_0 win_0_05 0) relay vt1=-1m vt2=1m ropen=ropen_mix rclosed=rclosed_mix
EMIXI_c003_0_06 (mix_i_src_c003_0_06 0 bpf_c003_0 0) vcvs gain=-8.314696123025e-01
SMIXI_c003_0_06 (mix_i_src_c003_0_06 mix_i_c003_0 win_0_06 0) relay vt1=-1m vt2=1m ropen=ropen_mix rclosed=rclosed_mix
EMIXQ_c003_0_06 (mix_q_src_c003_0_06 0 bpf_c003_0 0) vcvs gain=5.555702330196e-01
SMIXQ_c003_0_06 (mix_q_src_c003_0_06 mix_q_c003_0 win_0_06 0) relay vt1=-1m vt2=1m ropen=ropen_mix rclosed=rclosed_mix
EMIXI_c003_0_07 (mix_i_src_c003_0_07 0 bpf_c003_0 0) vcvs gain=-9.807852804032e-01
SMIXI_c003_0_07 (mix_i_src_c003_0_07 mix_i_c003_0 win_0_07 0) relay vt1=-1m vt2=1m ropen=ropen_mix rclosed=rclosed_mix
EMIXQ_c003_0_07 (mix_q_src_c003_0_07 0 bpf_c003_0 0) vcvs gain=1.950903220161e-01
SMIXQ_c003_0_07 (mix_q_src_c003_0_07 mix_q_c003_0 win_0_07 0) relay vt1=-1m vt2=1m ropen=ropen_mix rclosed=rclosed_mix
EMIXI_c003_0_08 (mix_i_src_c003_0_08 0 bpf_c003_0 0) vcvs gain=-9.807852804032e-01
SMIXI_c003_0_08 (mix_i_src_c003_0_08 mix_i_c003_0 win_0_08 0) relay vt1=-1m vt2=1m ropen=ropen_mix rclosed=rclosed_mix
EMIXQ_c003_0_08 (mix_q_src_c003_0_08 0 bpf_c003_0 0) vcvs gain=-1.950903220161e-01
SMIXQ_c003_0_08 (mix_q_src_c003_0_08 mix_q_c003_0 win_0_08 0) relay vt1=-1m vt2=1m ropen=ropen_mix rclosed=rclosed_mix
EMIXI_c003_0_09 (mix_i_src_c003_0_09 0 bpf_c003_0 0) vcvs gain=-8.314696123025e-01
SMIXI_c003_0_09 (mix_i_src_c003_0_09 mix_i_c003_0 win_0_09 0) relay vt1=-1m vt2=1m ropen=ropen_mix rclosed=rclosed_mix
EMIXQ_c003_0_09 (mix_q_src_c003_0_09 0 bpf_c003_0 0) vcvs gain=-5.555702330196e-01
SMIXQ_c003_0_09 (mix_q_src_c003_0_09 mix_q_c003_0 win_0_09 0) relay vt1=-1m vt2=1m ropen=ropen_mix rclosed=rclosed_mix
EMIXI_c003_0_10 (mix_i_src_c003_0_10 0 bpf_c003_0 0) vcvs gain=-5.555702330196e-01
SMIXI_c003_0_10 (mix_i_src_c003_0_10 mix_i_c003_0 win_0_10 0) relay vt1=-1m vt2=1m ropen=ropen_mix rclosed=rclosed_mix
EMIXQ_c003_0_10 (mix_q_src_c003_0_10 0 bpf_c003_0 0) vcvs gain=-8.314696123025e-01
SMIXQ_c003_0_10 (mix_q_src_c003_0_10 mix_q_c003_0 win_0_10 0) relay vt1=-1m vt2=1m ropen=ropen_mix rclosed=rclosed_mix
EMIXI_c003_0_11 (mix_i_src_c003_0_11 0 bpf_c003_0 0) vcvs gain=-1.950903220161e-01
SMIXI_c003_0_11 (mix_i_src_c003_0_11 mix_i_c003_0 win_0_11 0) relay vt1=-1m vt2=1m ropen=ropen_mix rclosed=rclosed_mix
EMIXQ_c003_0_11 (mix_q_src_c003_0_11 0 bpf_c003_0 0) vcvs gain=-9.807852804032e-01
SMIXQ_c003_0_11 (mix_q_src_c003_0_11 mix_q_c003_0 win_0_11 0) relay vt1=-1m vt2=1m ropen=ropen_mix rclosed=rclosed_mix
EMIXI_c003_0_12 (mix_i_src_c003_0_12 0 bpf_c003_0 0) vcvs gain=1.950903220161e-01
SMIXI_c003_0_12 (mix_i_src_c003_0_12 mix_i_c003_0 win_0_12 0) relay vt1=-1m vt2=1m ropen=ropen_mix rclosed=rclosed_mix
EMIXQ_c003_0_12 (mix_q_src_c003_0_12 0 bpf_c003_0 0) vcvs gain=-9.807852804032e-01
SMIXQ_c003_0_12 (mix_q_src_c003_0_12 mix_q_c003_0 win_0_12 0) relay vt1=-1m vt2=1m ropen=ropen_mix rclosed=rclosed_mix
EMIXI_c003_0_13 (mix_i_src_c003_0_13 0 bpf_c003_0 0) vcvs gain=5.555702330196e-01
SMIXI_c003_0_13 (mix_i_src_c003_0_13 mix_i_c003_0 win_0_13 0) relay vt1=-1m vt2=1m ropen=ropen_mix rclosed=rclosed_mix
EMIXQ_c003_0_13 (mix_q_src_c003_0_13 0 bpf_c003_0 0) vcvs gain=-8.314696123025e-01
SMIXQ_c003_0_13 (mix_q_src_c003_0_13 mix_q_c003_0 win_0_13 0) relay vt1=-1m vt2=1m ropen=ropen_mix rclosed=rclosed_mix
EMIXI_c003_0_14 (mix_i_src_c003_0_14 0 bpf_c003_0 0) vcvs gain=8.314696123025e-01
SMIXI_c003_0_14 (mix_i_src_c003_0_14 mix_i_c003_0 win_0_14 0) relay vt1=-1m vt2=1m ropen=ropen_mix rclosed=rclosed_mix
EMIXQ_c003_0_14 (mix_q_src_c003_0_14 0 bpf_c003_0 0) vcvs gain=-5.555702330196e-01
SMIXQ_c003_0_14 (mix_q_src_c003_0_14 mix_q_c003_0 win_0_14 0) relay vt1=-1m vt2=1m ropen=ropen_mix rclosed=rclosed_mix
EMIXI_c003_0_15 (mix_i_src_c003_0_15 0 bpf_c003_0 0) vcvs gain=9.807852804032e-01
SMIXI_c003_0_15 (mix_i_src_c003_0_15 mix_i_c003_0 win_0_15 0) relay vt1=-1m vt2=1m ropen=ropen_mix rclosed=rclosed_mix
EMIXQ_c003_0_15 (mix_q_src_c003_0_15 0 bpf_c003_0 0) vcvs gain=-1.950903220161e-01
SMIXQ_c003_0_15 (mix_q_src_c003_0_15 mix_q_c003_0 win_0_15 0) relay vt1=-1m vt2=1m ropen=ropen_mix rclosed=rclosed_mix
RMIXI_c003_0 (mix_i_c003_0 0) resistor r=1G
RMIXQ_c003_0 (mix_q_c003_0 0) resistor r=1G
RINTI_c003_0 (mix_i_c003_0 Icar_c003_0) resistor r=1k
CINTI_c003_0 (Icar_c003_0 0) capacitor c=80p
RINTQ_c003_0 (mix_q_c003_0 Qcar_c003_0) resistor r=1k
CINTQ_c003_0 (Qcar_c003_0 0) capacitor c=80p
save bpf_c003_0 Icar_c003_0 Qcar_c003_0

// bl003, carrier_1: 500000000 Hz coherent I/Q phase-window verification-demod path
CBPF_c003_1 (bl003 n_cbpf_c003_1) capacitor c=1.013211836423e-13
LBPF_c003_1 (n_cbpf_c003_1 bpf_c003_1) inductor l=1.000000000000e-06
RBPF_c003_1 (bpf_c003_1 0) resistor r=1.570796326795e+02
EMIXI_c003_1_00 (mix_i_src_c003_1_00 0 bpf_c003_1 0) vcvs gain=9.807852804032e-01
SMIXI_c003_1_00 (mix_i_src_c003_1_00 mix_i_c003_1 win_1_00 0) relay vt1=-1m vt2=1m ropen=ropen_mix rclosed=rclosed_mix
EMIXQ_c003_1_00 (mix_q_src_c003_1_00 0 bpf_c003_1 0) vcvs gain=1.950903220161e-01
SMIXQ_c003_1_00 (mix_q_src_c003_1_00 mix_q_c003_1 win_1_00 0) relay vt1=-1m vt2=1m ropen=ropen_mix rclosed=rclosed_mix
EMIXI_c003_1_01 (mix_i_src_c003_1_01 0 bpf_c003_1 0) vcvs gain=8.314696123025e-01
SMIXI_c003_1_01 (mix_i_src_c003_1_01 mix_i_c003_1 win_1_01 0) relay vt1=-1m vt2=1m ropen=ropen_mix rclosed=rclosed_mix
EMIXQ_c003_1_01 (mix_q_src_c003_1_01 0 bpf_c003_1 0) vcvs gain=5.555702330196e-01
SMIXQ_c003_1_01 (mix_q_src_c003_1_01 mix_q_c003_1 win_1_01 0) relay vt1=-1m vt2=1m ropen=ropen_mix rclosed=rclosed_mix
EMIXI_c003_1_02 (mix_i_src_c003_1_02 0 bpf_c003_1 0) vcvs gain=5.555702330196e-01
SMIXI_c003_1_02 (mix_i_src_c003_1_02 mix_i_c003_1 win_1_02 0) relay vt1=-1m vt2=1m ropen=ropen_mix rclosed=rclosed_mix
EMIXQ_c003_1_02 (mix_q_src_c003_1_02 0 bpf_c003_1 0) vcvs gain=8.314696123025e-01
SMIXQ_c003_1_02 (mix_q_src_c003_1_02 mix_q_c003_1 win_1_02 0) relay vt1=-1m vt2=1m ropen=ropen_mix rclosed=rclosed_mix
EMIXI_c003_1_03 (mix_i_src_c003_1_03 0 bpf_c003_1 0) vcvs gain=1.950903220161e-01
SMIXI_c003_1_03 (mix_i_src_c003_1_03 mix_i_c003_1 win_1_03 0) relay vt1=-1m vt2=1m ropen=ropen_mix rclosed=rclosed_mix
EMIXQ_c003_1_03 (mix_q_src_c003_1_03 0 bpf_c003_1 0) vcvs gain=9.807852804032e-01
SMIXQ_c003_1_03 (mix_q_src_c003_1_03 mix_q_c003_1 win_1_03 0) relay vt1=-1m vt2=1m ropen=ropen_mix rclosed=rclosed_mix
EMIXI_c003_1_04 (mix_i_src_c003_1_04 0 bpf_c003_1 0) vcvs gain=-1.950903220161e-01
SMIXI_c003_1_04 (mix_i_src_c003_1_04 mix_i_c003_1 win_1_04 0) relay vt1=-1m vt2=1m ropen=ropen_mix rclosed=rclosed_mix
EMIXQ_c003_1_04 (mix_q_src_c003_1_04 0 bpf_c003_1 0) vcvs gain=9.807852804032e-01
SMIXQ_c003_1_04 (mix_q_src_c003_1_04 mix_q_c003_1 win_1_04 0) relay vt1=-1m vt2=1m ropen=ropen_mix rclosed=rclosed_mix
EMIXI_c003_1_05 (mix_i_src_c003_1_05 0 bpf_c003_1 0) vcvs gain=-5.555702330196e-01
SMIXI_c003_1_05 (mix_i_src_c003_1_05 mix_i_c003_1 win_1_05 0) relay vt1=-1m vt2=1m ropen=ropen_mix rclosed=rclosed_mix
EMIXQ_c003_1_05 (mix_q_src_c003_1_05 0 bpf_c003_1 0) vcvs gain=8.314696123025e-01
SMIXQ_c003_1_05 (mix_q_src_c003_1_05 mix_q_c003_1 win_1_05 0) relay vt1=-1m vt2=1m ropen=ropen_mix rclosed=rclosed_mix
EMIXI_c003_1_06 (mix_i_src_c003_1_06 0 bpf_c003_1 0) vcvs gain=-8.314696123025e-01
SMIXI_c003_1_06 (mix_i_src_c003_1_06 mix_i_c003_1 win_1_06 0) relay vt1=-1m vt2=1m ropen=ropen_mix rclosed=rclosed_mix
EMIXQ_c003_1_06 (mix_q_src_c003_1_06 0 bpf_c003_1 0) vcvs gain=5.555702330196e-01
SMIXQ_c003_1_06 (mix_q_src_c003_1_06 mix_q_c003_1 win_1_06 0) relay vt1=-1m vt2=1m ropen=ropen_mix rclosed=rclosed_mix
EMIXI_c003_1_07 (mix_i_src_c003_1_07 0 bpf_c003_1 0) vcvs gain=-9.807852804032e-01
SMIXI_c003_1_07 (mix_i_src_c003_1_07 mix_i_c003_1 win_1_07 0) relay vt1=-1m vt2=1m ropen=ropen_mix rclosed=rclosed_mix
EMIXQ_c003_1_07 (mix_q_src_c003_1_07 0 bpf_c003_1 0) vcvs gain=1.950903220161e-01
SMIXQ_c003_1_07 (mix_q_src_c003_1_07 mix_q_c003_1 win_1_07 0) relay vt1=-1m vt2=1m ropen=ropen_mix rclosed=rclosed_mix
EMIXI_c003_1_08 (mix_i_src_c003_1_08 0 bpf_c003_1 0) vcvs gain=-9.807852804032e-01
SMIXI_c003_1_08 (mix_i_src_c003_1_08 mix_i_c003_1 win_1_08 0) relay vt1=-1m vt2=1m ropen=ropen_mix rclosed=rclosed_mix
EMIXQ_c003_1_08 (mix_q_src_c003_1_08 0 bpf_c003_1 0) vcvs gain=-1.950903220161e-01
SMIXQ_c003_1_08 (mix_q_src_c003_1_08 mix_q_c003_1 win_1_08 0) relay vt1=-1m vt2=1m ropen=ropen_mix rclosed=rclosed_mix
EMIXI_c003_1_09 (mix_i_src_c003_1_09 0 bpf_c003_1 0) vcvs gain=-8.314696123025e-01
SMIXI_c003_1_09 (mix_i_src_c003_1_09 mix_i_c003_1 win_1_09 0) relay vt1=-1m vt2=1m ropen=ropen_mix rclosed=rclosed_mix
EMIXQ_c003_1_09 (mix_q_src_c003_1_09 0 bpf_c003_1 0) vcvs gain=-5.555702330196e-01
SMIXQ_c003_1_09 (mix_q_src_c003_1_09 mix_q_c003_1 win_1_09 0) relay vt1=-1m vt2=1m ropen=ropen_mix rclosed=rclosed_mix
EMIXI_c003_1_10 (mix_i_src_c003_1_10 0 bpf_c003_1 0) vcvs gain=-5.555702330196e-01
SMIXI_c003_1_10 (mix_i_src_c003_1_10 mix_i_c003_1 win_1_10 0) relay vt1=-1m vt2=1m ropen=ropen_mix rclosed=rclosed_mix
EMIXQ_c003_1_10 (mix_q_src_c003_1_10 0 bpf_c003_1 0) vcvs gain=-8.314696123025e-01
SMIXQ_c003_1_10 (mix_q_src_c003_1_10 mix_q_c003_1 win_1_10 0) relay vt1=-1m vt2=1m ropen=ropen_mix rclosed=rclosed_mix
EMIXI_c003_1_11 (mix_i_src_c003_1_11 0 bpf_c003_1 0) vcvs gain=-1.950903220161e-01
SMIXI_c003_1_11 (mix_i_src_c003_1_11 mix_i_c003_1 win_1_11 0) relay vt1=-1m vt2=1m ropen=ropen_mix rclosed=rclosed_mix
EMIXQ_c003_1_11 (mix_q_src_c003_1_11 0 bpf_c003_1 0) vcvs gain=-9.807852804032e-01
SMIXQ_c003_1_11 (mix_q_src_c003_1_11 mix_q_c003_1 win_1_11 0) relay vt1=-1m vt2=1m ropen=ropen_mix rclosed=rclosed_mix
EMIXI_c003_1_12 (mix_i_src_c003_1_12 0 bpf_c003_1 0) vcvs gain=1.950903220161e-01
SMIXI_c003_1_12 (mix_i_src_c003_1_12 mix_i_c003_1 win_1_12 0) relay vt1=-1m vt2=1m ropen=ropen_mix rclosed=rclosed_mix
EMIXQ_c003_1_12 (mix_q_src_c003_1_12 0 bpf_c003_1 0) vcvs gain=-9.807852804032e-01
SMIXQ_c003_1_12 (mix_q_src_c003_1_12 mix_q_c003_1 win_1_12 0) relay vt1=-1m vt2=1m ropen=ropen_mix rclosed=rclosed_mix
EMIXI_c003_1_13 (mix_i_src_c003_1_13 0 bpf_c003_1 0) vcvs gain=5.555702330196e-01
SMIXI_c003_1_13 (mix_i_src_c003_1_13 mix_i_c003_1 win_1_13 0) relay vt1=-1m vt2=1m ropen=ropen_mix rclosed=rclosed_mix
EMIXQ_c003_1_13 (mix_q_src_c003_1_13 0 bpf_c003_1 0) vcvs gain=-8.314696123025e-01
SMIXQ_c003_1_13 (mix_q_src_c003_1_13 mix_q_c003_1 win_1_13 0) relay vt1=-1m vt2=1m ropen=ropen_mix rclosed=rclosed_mix
EMIXI_c003_1_14 (mix_i_src_c003_1_14 0 bpf_c003_1 0) vcvs gain=8.314696123025e-01
SMIXI_c003_1_14 (mix_i_src_c003_1_14 mix_i_c003_1 win_1_14 0) relay vt1=-1m vt2=1m ropen=ropen_mix rclosed=rclosed_mix
EMIXQ_c003_1_14 (mix_q_src_c003_1_14 0 bpf_c003_1 0) vcvs gain=-5.555702330196e-01
SMIXQ_c003_1_14 (mix_q_src_c003_1_14 mix_q_c003_1 win_1_14 0) relay vt1=-1m vt2=1m ropen=ropen_mix rclosed=rclosed_mix
EMIXI_c003_1_15 (mix_i_src_c003_1_15 0 bpf_c003_1 0) vcvs gain=9.807852804032e-01
SMIXI_c003_1_15 (mix_i_src_c003_1_15 mix_i_c003_1 win_1_15 0) relay vt1=-1m vt2=1m ropen=ropen_mix rclosed=rclosed_mix
EMIXQ_c003_1_15 (mix_q_src_c003_1_15 0 bpf_c003_1 0) vcvs gain=-1.950903220161e-01
SMIXQ_c003_1_15 (mix_q_src_c003_1_15 mix_q_c003_1 win_1_15 0) relay vt1=-1m vt2=1m ropen=ropen_mix rclosed=rclosed_mix
RMIXI_c003_1 (mix_i_c003_1 0) resistor r=1G
RMIXQ_c003_1 (mix_q_c003_1 0) resistor r=1G
RINTI_c003_1 (mix_i_c003_1 Icar_c003_1) resistor r=1k
CINTI_c003_1 (Icar_c003_1 0) capacitor c=80p
RINTQ_c003_1 (mix_q_c003_1 Qcar_c003_1) resistor r=1k
CINTQ_c003_1 (Qcar_c003_1 0) capacitor c=80p
save bpf_c003_1 Icar_c003_1 Qcar_c003_1

// bl003, carrier_2: 750000000 Hz coherent I/Q phase-window verification-demod path
CBPF_c003_2 (bl003 n_cbpf_c003_2) capacitor c=4.503163717437e-14
LBPF_c003_2 (n_cbpf_c003_2 bpf_c003_2) inductor l=1.000000000000e-06
RBPF_c003_2 (bpf_c003_2 0) resistor r=2.356194490192e+02
EMIXI_c003_2_00 (mix_i_src_c003_2_00 0 bpf_c003_2 0) vcvs gain=9.807852804032e-01
SMIXI_c003_2_00 (mix_i_src_c003_2_00 mix_i_c003_2 win_2_00 0) relay vt1=-1m vt2=1m ropen=ropen_mix rclosed=rclosed_mix
EMIXQ_c003_2_00 (mix_q_src_c003_2_00 0 bpf_c003_2 0) vcvs gain=1.950903220161e-01
SMIXQ_c003_2_00 (mix_q_src_c003_2_00 mix_q_c003_2 win_2_00 0) relay vt1=-1m vt2=1m ropen=ropen_mix rclosed=rclosed_mix
EMIXI_c003_2_01 (mix_i_src_c003_2_01 0 bpf_c003_2 0) vcvs gain=8.314696123025e-01
SMIXI_c003_2_01 (mix_i_src_c003_2_01 mix_i_c003_2 win_2_01 0) relay vt1=-1m vt2=1m ropen=ropen_mix rclosed=rclosed_mix
EMIXQ_c003_2_01 (mix_q_src_c003_2_01 0 bpf_c003_2 0) vcvs gain=5.555702330196e-01
SMIXQ_c003_2_01 (mix_q_src_c003_2_01 mix_q_c003_2 win_2_01 0) relay vt1=-1m vt2=1m ropen=ropen_mix rclosed=rclosed_mix
EMIXI_c003_2_02 (mix_i_src_c003_2_02 0 bpf_c003_2 0) vcvs gain=5.555702330196e-01
SMIXI_c003_2_02 (mix_i_src_c003_2_02 mix_i_c003_2 win_2_02 0) relay vt1=-1m vt2=1m ropen=ropen_mix rclosed=rclosed_mix
EMIXQ_c003_2_02 (mix_q_src_c003_2_02 0 bpf_c003_2 0) vcvs gain=8.314696123025e-01
SMIXQ_c003_2_02 (mix_q_src_c003_2_02 mix_q_c003_2 win_2_02 0) relay vt1=-1m vt2=1m ropen=ropen_mix rclosed=rclosed_mix
EMIXI_c003_2_03 (mix_i_src_c003_2_03 0 bpf_c003_2 0) vcvs gain=1.950903220161e-01
SMIXI_c003_2_03 (mix_i_src_c003_2_03 mix_i_c003_2 win_2_03 0) relay vt1=-1m vt2=1m ropen=ropen_mix rclosed=rclosed_mix
EMIXQ_c003_2_03 (mix_q_src_c003_2_03 0 bpf_c003_2 0) vcvs gain=9.807852804032e-01
SMIXQ_c003_2_03 (mix_q_src_c003_2_03 mix_q_c003_2 win_2_03 0) relay vt1=-1m vt2=1m ropen=ropen_mix rclosed=rclosed_mix
EMIXI_c003_2_04 (mix_i_src_c003_2_04 0 bpf_c003_2 0) vcvs gain=-1.950903220161e-01
SMIXI_c003_2_04 (mix_i_src_c003_2_04 mix_i_c003_2 win_2_04 0) relay vt1=-1m vt2=1m ropen=ropen_mix rclosed=rclosed_mix
EMIXQ_c003_2_04 (mix_q_src_c003_2_04 0 bpf_c003_2 0) vcvs gain=9.807852804032e-01
SMIXQ_c003_2_04 (mix_q_src_c003_2_04 mix_q_c003_2 win_2_04 0) relay vt1=-1m vt2=1m ropen=ropen_mix rclosed=rclosed_mix
EMIXI_c003_2_05 (mix_i_src_c003_2_05 0 bpf_c003_2 0) vcvs gain=-5.555702330196e-01
SMIXI_c003_2_05 (mix_i_src_c003_2_05 mix_i_c003_2 win_2_05 0) relay vt1=-1m vt2=1m ropen=ropen_mix rclosed=rclosed_mix
EMIXQ_c003_2_05 (mix_q_src_c003_2_05 0 bpf_c003_2 0) vcvs gain=8.314696123025e-01
SMIXQ_c003_2_05 (mix_q_src_c003_2_05 mix_q_c003_2 win_2_05 0) relay vt1=-1m vt2=1m ropen=ropen_mix rclosed=rclosed_mix
EMIXI_c003_2_06 (mix_i_src_c003_2_06 0 bpf_c003_2 0) vcvs gain=-8.314696123025e-01
SMIXI_c003_2_06 (mix_i_src_c003_2_06 mix_i_c003_2 win_2_06 0) relay vt1=-1m vt2=1m ropen=ropen_mix rclosed=rclosed_mix
EMIXQ_c003_2_06 (mix_q_src_c003_2_06 0 bpf_c003_2 0) vcvs gain=5.555702330196e-01
SMIXQ_c003_2_06 (mix_q_src_c003_2_06 mix_q_c003_2 win_2_06 0) relay vt1=-1m vt2=1m ropen=ropen_mix rclosed=rclosed_mix
EMIXI_c003_2_07 (mix_i_src_c003_2_07 0 bpf_c003_2 0) vcvs gain=-9.807852804032e-01
SMIXI_c003_2_07 (mix_i_src_c003_2_07 mix_i_c003_2 win_2_07 0) relay vt1=-1m vt2=1m ropen=ropen_mix rclosed=rclosed_mix
EMIXQ_c003_2_07 (mix_q_src_c003_2_07 0 bpf_c003_2 0) vcvs gain=1.950903220161e-01
SMIXQ_c003_2_07 (mix_q_src_c003_2_07 mix_q_c003_2 win_2_07 0) relay vt1=-1m vt2=1m ropen=ropen_mix rclosed=rclosed_mix
EMIXI_c003_2_08 (mix_i_src_c003_2_08 0 bpf_c003_2 0) vcvs gain=-9.807852804032e-01
SMIXI_c003_2_08 (mix_i_src_c003_2_08 mix_i_c003_2 win_2_08 0) relay vt1=-1m vt2=1m ropen=ropen_mix rclosed=rclosed_mix
EMIXQ_c003_2_08 (mix_q_src_c003_2_08 0 bpf_c003_2 0) vcvs gain=-1.950903220161e-01
SMIXQ_c003_2_08 (mix_q_src_c003_2_08 mix_q_c003_2 win_2_08 0) relay vt1=-1m vt2=1m ropen=ropen_mix rclosed=rclosed_mix
EMIXI_c003_2_09 (mix_i_src_c003_2_09 0 bpf_c003_2 0) vcvs gain=-8.314696123025e-01
SMIXI_c003_2_09 (mix_i_src_c003_2_09 mix_i_c003_2 win_2_09 0) relay vt1=-1m vt2=1m ropen=ropen_mix rclosed=rclosed_mix
EMIXQ_c003_2_09 (mix_q_src_c003_2_09 0 bpf_c003_2 0) vcvs gain=-5.555702330196e-01
SMIXQ_c003_2_09 (mix_q_src_c003_2_09 mix_q_c003_2 win_2_09 0) relay vt1=-1m vt2=1m ropen=ropen_mix rclosed=rclosed_mix
EMIXI_c003_2_10 (mix_i_src_c003_2_10 0 bpf_c003_2 0) vcvs gain=-5.555702330196e-01
SMIXI_c003_2_10 (mix_i_src_c003_2_10 mix_i_c003_2 win_2_10 0) relay vt1=-1m vt2=1m ropen=ropen_mix rclosed=rclosed_mix
EMIXQ_c003_2_10 (mix_q_src_c003_2_10 0 bpf_c003_2 0) vcvs gain=-8.314696123025e-01
SMIXQ_c003_2_10 (mix_q_src_c003_2_10 mix_q_c003_2 win_2_10 0) relay vt1=-1m vt2=1m ropen=ropen_mix rclosed=rclosed_mix
EMIXI_c003_2_11 (mix_i_src_c003_2_11 0 bpf_c003_2 0) vcvs gain=-1.950903220161e-01
SMIXI_c003_2_11 (mix_i_src_c003_2_11 mix_i_c003_2 win_2_11 0) relay vt1=-1m vt2=1m ropen=ropen_mix rclosed=rclosed_mix
EMIXQ_c003_2_11 (mix_q_src_c003_2_11 0 bpf_c003_2 0) vcvs gain=-9.807852804032e-01
SMIXQ_c003_2_11 (mix_q_src_c003_2_11 mix_q_c003_2 win_2_11 0) relay vt1=-1m vt2=1m ropen=ropen_mix rclosed=rclosed_mix
EMIXI_c003_2_12 (mix_i_src_c003_2_12 0 bpf_c003_2 0) vcvs gain=1.950903220161e-01
SMIXI_c003_2_12 (mix_i_src_c003_2_12 mix_i_c003_2 win_2_12 0) relay vt1=-1m vt2=1m ropen=ropen_mix rclosed=rclosed_mix
EMIXQ_c003_2_12 (mix_q_src_c003_2_12 0 bpf_c003_2 0) vcvs gain=-9.807852804032e-01
SMIXQ_c003_2_12 (mix_q_src_c003_2_12 mix_q_c003_2 win_2_12 0) relay vt1=-1m vt2=1m ropen=ropen_mix rclosed=rclosed_mix
EMIXI_c003_2_13 (mix_i_src_c003_2_13 0 bpf_c003_2 0) vcvs gain=5.555702330196e-01
SMIXI_c003_2_13 (mix_i_src_c003_2_13 mix_i_c003_2 win_2_13 0) relay vt1=-1m vt2=1m ropen=ropen_mix rclosed=rclosed_mix
EMIXQ_c003_2_13 (mix_q_src_c003_2_13 0 bpf_c003_2 0) vcvs gain=-8.314696123025e-01
SMIXQ_c003_2_13 (mix_q_src_c003_2_13 mix_q_c003_2 win_2_13 0) relay vt1=-1m vt2=1m ropen=ropen_mix rclosed=rclosed_mix
EMIXI_c003_2_14 (mix_i_src_c003_2_14 0 bpf_c003_2 0) vcvs gain=8.314696123025e-01
SMIXI_c003_2_14 (mix_i_src_c003_2_14 mix_i_c003_2 win_2_14 0) relay vt1=-1m vt2=1m ropen=ropen_mix rclosed=rclosed_mix
EMIXQ_c003_2_14 (mix_q_src_c003_2_14 0 bpf_c003_2 0) vcvs gain=-5.555702330196e-01
SMIXQ_c003_2_14 (mix_q_src_c003_2_14 mix_q_c003_2 win_2_14 0) relay vt1=-1m vt2=1m ropen=ropen_mix rclosed=rclosed_mix
EMIXI_c003_2_15 (mix_i_src_c003_2_15 0 bpf_c003_2 0) vcvs gain=9.807852804032e-01
SMIXI_c003_2_15 (mix_i_src_c003_2_15 mix_i_c003_2 win_2_15 0) relay vt1=-1m vt2=1m ropen=ropen_mix rclosed=rclosed_mix
EMIXQ_c003_2_15 (mix_q_src_c003_2_15 0 bpf_c003_2 0) vcvs gain=-1.950903220161e-01
SMIXQ_c003_2_15 (mix_q_src_c003_2_15 mix_q_c003_2 win_2_15 0) relay vt1=-1m vt2=1m ropen=ropen_mix rclosed=rclosed_mix
RMIXI_c003_2 (mix_i_c003_2 0) resistor r=1G
RMIXQ_c003_2 (mix_q_c003_2 0) resistor r=1G
RINTI_c003_2 (mix_i_c003_2 Icar_c003_2) resistor r=1k
CINTI_c003_2 (Icar_c003_2 0) capacitor c=80p
RINTQ_c003_2 (mix_q_c003_2 Qcar_c003_2) resistor r=1k
CINTQ_c003_2 (Qcar_c003_2 0) capacitor c=80p
save bpf_c003_2 Icar_c003_2 Qcar_c003_2

// bl003, carrier_3: 1000000000 Hz coherent I/Q phase-window verification-demod path
CBPF_c003_3 (bl003 n_cbpf_c003_3) capacitor c=2.533029591058e-14
LBPF_c003_3 (n_cbpf_c003_3 bpf_c003_3) inductor l=1.000000000000e-06
RBPF_c003_3 (bpf_c003_3 0) resistor r=3.141592653590e+02
EMIXI_c003_3_00 (mix_i_src_c003_3_00 0 bpf_c003_3 0) vcvs gain=9.807852804032e-01
SMIXI_c003_3_00 (mix_i_src_c003_3_00 mix_i_c003_3 win_3_00 0) relay vt1=-1m vt2=1m ropen=ropen_mix rclosed=rclosed_mix
EMIXQ_c003_3_00 (mix_q_src_c003_3_00 0 bpf_c003_3 0) vcvs gain=1.950903220161e-01
SMIXQ_c003_3_00 (mix_q_src_c003_3_00 mix_q_c003_3 win_3_00 0) relay vt1=-1m vt2=1m ropen=ropen_mix rclosed=rclosed_mix
EMIXI_c003_3_01 (mix_i_src_c003_3_01 0 bpf_c003_3 0) vcvs gain=8.314696123025e-01
SMIXI_c003_3_01 (mix_i_src_c003_3_01 mix_i_c003_3 win_3_01 0) relay vt1=-1m vt2=1m ropen=ropen_mix rclosed=rclosed_mix
EMIXQ_c003_3_01 (mix_q_src_c003_3_01 0 bpf_c003_3 0) vcvs gain=5.555702330196e-01
SMIXQ_c003_3_01 (mix_q_src_c003_3_01 mix_q_c003_3 win_3_01 0) relay vt1=-1m vt2=1m ropen=ropen_mix rclosed=rclosed_mix
EMIXI_c003_3_02 (mix_i_src_c003_3_02 0 bpf_c003_3 0) vcvs gain=5.555702330196e-01
SMIXI_c003_3_02 (mix_i_src_c003_3_02 mix_i_c003_3 win_3_02 0) relay vt1=-1m vt2=1m ropen=ropen_mix rclosed=rclosed_mix
EMIXQ_c003_3_02 (mix_q_src_c003_3_02 0 bpf_c003_3 0) vcvs gain=8.314696123025e-01
SMIXQ_c003_3_02 (mix_q_src_c003_3_02 mix_q_c003_3 win_3_02 0) relay vt1=-1m vt2=1m ropen=ropen_mix rclosed=rclosed_mix
EMIXI_c003_3_03 (mix_i_src_c003_3_03 0 bpf_c003_3 0) vcvs gain=1.950903220161e-01
SMIXI_c003_3_03 (mix_i_src_c003_3_03 mix_i_c003_3 win_3_03 0) relay vt1=-1m vt2=1m ropen=ropen_mix rclosed=rclosed_mix
EMIXQ_c003_3_03 (mix_q_src_c003_3_03 0 bpf_c003_3 0) vcvs gain=9.807852804032e-01
SMIXQ_c003_3_03 (mix_q_src_c003_3_03 mix_q_c003_3 win_3_03 0) relay vt1=-1m vt2=1m ropen=ropen_mix rclosed=rclosed_mix
EMIXI_c003_3_04 (mix_i_src_c003_3_04 0 bpf_c003_3 0) vcvs gain=-1.950903220161e-01
SMIXI_c003_3_04 (mix_i_src_c003_3_04 mix_i_c003_3 win_3_04 0) relay vt1=-1m vt2=1m ropen=ropen_mix rclosed=rclosed_mix
EMIXQ_c003_3_04 (mix_q_src_c003_3_04 0 bpf_c003_3 0) vcvs gain=9.807852804032e-01
SMIXQ_c003_3_04 (mix_q_src_c003_3_04 mix_q_c003_3 win_3_04 0) relay vt1=-1m vt2=1m ropen=ropen_mix rclosed=rclosed_mix
EMIXI_c003_3_05 (mix_i_src_c003_3_05 0 bpf_c003_3 0) vcvs gain=-5.555702330196e-01
SMIXI_c003_3_05 (mix_i_src_c003_3_05 mix_i_c003_3 win_3_05 0) relay vt1=-1m vt2=1m ropen=ropen_mix rclosed=rclosed_mix
EMIXQ_c003_3_05 (mix_q_src_c003_3_05 0 bpf_c003_3 0) vcvs gain=8.314696123025e-01
SMIXQ_c003_3_05 (mix_q_src_c003_3_05 mix_q_c003_3 win_3_05 0) relay vt1=-1m vt2=1m ropen=ropen_mix rclosed=rclosed_mix
EMIXI_c003_3_06 (mix_i_src_c003_3_06 0 bpf_c003_3 0) vcvs gain=-8.314696123025e-01
SMIXI_c003_3_06 (mix_i_src_c003_3_06 mix_i_c003_3 win_3_06 0) relay vt1=-1m vt2=1m ropen=ropen_mix rclosed=rclosed_mix
EMIXQ_c003_3_06 (mix_q_src_c003_3_06 0 bpf_c003_3 0) vcvs gain=5.555702330196e-01
SMIXQ_c003_3_06 (mix_q_src_c003_3_06 mix_q_c003_3 win_3_06 0) relay vt1=-1m vt2=1m ropen=ropen_mix rclosed=rclosed_mix
EMIXI_c003_3_07 (mix_i_src_c003_3_07 0 bpf_c003_3 0) vcvs gain=-9.807852804032e-01
SMIXI_c003_3_07 (mix_i_src_c003_3_07 mix_i_c003_3 win_3_07 0) relay vt1=-1m vt2=1m ropen=ropen_mix rclosed=rclosed_mix
EMIXQ_c003_3_07 (mix_q_src_c003_3_07 0 bpf_c003_3 0) vcvs gain=1.950903220161e-01
SMIXQ_c003_3_07 (mix_q_src_c003_3_07 mix_q_c003_3 win_3_07 0) relay vt1=-1m vt2=1m ropen=ropen_mix rclosed=rclosed_mix
EMIXI_c003_3_08 (mix_i_src_c003_3_08 0 bpf_c003_3 0) vcvs gain=-9.807852804032e-01
SMIXI_c003_3_08 (mix_i_src_c003_3_08 mix_i_c003_3 win_3_08 0) relay vt1=-1m vt2=1m ropen=ropen_mix rclosed=rclosed_mix
EMIXQ_c003_3_08 (mix_q_src_c003_3_08 0 bpf_c003_3 0) vcvs gain=-1.950903220161e-01
SMIXQ_c003_3_08 (mix_q_src_c003_3_08 mix_q_c003_3 win_3_08 0) relay vt1=-1m vt2=1m ropen=ropen_mix rclosed=rclosed_mix
EMIXI_c003_3_09 (mix_i_src_c003_3_09 0 bpf_c003_3 0) vcvs gain=-8.314696123025e-01
SMIXI_c003_3_09 (mix_i_src_c003_3_09 mix_i_c003_3 win_3_09 0) relay vt1=-1m vt2=1m ropen=ropen_mix rclosed=rclosed_mix
EMIXQ_c003_3_09 (mix_q_src_c003_3_09 0 bpf_c003_3 0) vcvs gain=-5.555702330196e-01
SMIXQ_c003_3_09 (mix_q_src_c003_3_09 mix_q_c003_3 win_3_09 0) relay vt1=-1m vt2=1m ropen=ropen_mix rclosed=rclosed_mix
EMIXI_c003_3_10 (mix_i_src_c003_3_10 0 bpf_c003_3 0) vcvs gain=-5.555702330196e-01
SMIXI_c003_3_10 (mix_i_src_c003_3_10 mix_i_c003_3 win_3_10 0) relay vt1=-1m vt2=1m ropen=ropen_mix rclosed=rclosed_mix
EMIXQ_c003_3_10 (mix_q_src_c003_3_10 0 bpf_c003_3 0) vcvs gain=-8.314696123025e-01
SMIXQ_c003_3_10 (mix_q_src_c003_3_10 mix_q_c003_3 win_3_10 0) relay vt1=-1m vt2=1m ropen=ropen_mix rclosed=rclosed_mix
EMIXI_c003_3_11 (mix_i_src_c003_3_11 0 bpf_c003_3 0) vcvs gain=-1.950903220161e-01
SMIXI_c003_3_11 (mix_i_src_c003_3_11 mix_i_c003_3 win_3_11 0) relay vt1=-1m vt2=1m ropen=ropen_mix rclosed=rclosed_mix
EMIXQ_c003_3_11 (mix_q_src_c003_3_11 0 bpf_c003_3 0) vcvs gain=-9.807852804032e-01
SMIXQ_c003_3_11 (mix_q_src_c003_3_11 mix_q_c003_3 win_3_11 0) relay vt1=-1m vt2=1m ropen=ropen_mix rclosed=rclosed_mix
EMIXI_c003_3_12 (mix_i_src_c003_3_12 0 bpf_c003_3 0) vcvs gain=1.950903220161e-01
SMIXI_c003_3_12 (mix_i_src_c003_3_12 mix_i_c003_3 win_3_12 0) relay vt1=-1m vt2=1m ropen=ropen_mix rclosed=rclosed_mix
EMIXQ_c003_3_12 (mix_q_src_c003_3_12 0 bpf_c003_3 0) vcvs gain=-9.807852804032e-01
SMIXQ_c003_3_12 (mix_q_src_c003_3_12 mix_q_c003_3 win_3_12 0) relay vt1=-1m vt2=1m ropen=ropen_mix rclosed=rclosed_mix
EMIXI_c003_3_13 (mix_i_src_c003_3_13 0 bpf_c003_3 0) vcvs gain=5.555702330196e-01
SMIXI_c003_3_13 (mix_i_src_c003_3_13 mix_i_c003_3 win_3_13 0) relay vt1=-1m vt2=1m ropen=ropen_mix rclosed=rclosed_mix
EMIXQ_c003_3_13 (mix_q_src_c003_3_13 0 bpf_c003_3 0) vcvs gain=-8.314696123025e-01
SMIXQ_c003_3_13 (mix_q_src_c003_3_13 mix_q_c003_3 win_3_13 0) relay vt1=-1m vt2=1m ropen=ropen_mix rclosed=rclosed_mix
EMIXI_c003_3_14 (mix_i_src_c003_3_14 0 bpf_c003_3 0) vcvs gain=8.314696123025e-01
SMIXI_c003_3_14 (mix_i_src_c003_3_14 mix_i_c003_3 win_3_14 0) relay vt1=-1m vt2=1m ropen=ropen_mix rclosed=rclosed_mix
EMIXQ_c003_3_14 (mix_q_src_c003_3_14 0 bpf_c003_3 0) vcvs gain=-5.555702330196e-01
SMIXQ_c003_3_14 (mix_q_src_c003_3_14 mix_q_c003_3 win_3_14 0) relay vt1=-1m vt2=1m ropen=ropen_mix rclosed=rclosed_mix
EMIXI_c003_3_15 (mix_i_src_c003_3_15 0 bpf_c003_3 0) vcvs gain=9.807852804032e-01
SMIXI_c003_3_15 (mix_i_src_c003_3_15 mix_i_c003_3 win_3_15 0) relay vt1=-1m vt2=1m ropen=ropen_mix rclosed=rclosed_mix
EMIXQ_c003_3_15 (mix_q_src_c003_3_15 0 bpf_c003_3 0) vcvs gain=-1.950903220161e-01
SMIXQ_c003_3_15 (mix_q_src_c003_3_15 mix_q_c003_3 win_3_15 0) relay vt1=-1m vt2=1m ropen=ropen_mix rclosed=rclosed_mix
RMIXI_c003_3 (mix_i_c003_3 0) resistor r=1G
RMIXQ_c003_3 (mix_q_c003_3 0) resistor r=1G
RINTI_c003_3 (mix_i_c003_3 Icar_c003_3) resistor r=1k
CINTI_c003_3 (Icar_c003_3 0) capacitor c=80p
RINTQ_c003_3 (mix_q_c003_3 Qcar_c003_3) resistor r=1k
CINTQ_c003_3 (Qcar_c003_3 0) capacitor c=80p
save bpf_c003_3 Icar_c003_3 Qcar_c003_3

// bl004, carrier_0: 250000000 Hz coherent I/Q phase-window verification-demod path
CBPF_c004_0 (bl004 n_cbpf_c004_0) capacitor c=4.052847345694e-13
LBPF_c004_0 (n_cbpf_c004_0 bpf_c004_0) inductor l=1.000000000000e-06
RBPF_c004_0 (bpf_c004_0 0) resistor r=7.853981633974e+01
EMIXI_c004_0_00 (mix_i_src_c004_0_00 0 bpf_c004_0 0) vcvs gain=9.807852804032e-01
SMIXI_c004_0_00 (mix_i_src_c004_0_00 mix_i_c004_0 win_0_00 0) relay vt1=-1m vt2=1m ropen=ropen_mix rclosed=rclosed_mix
EMIXQ_c004_0_00 (mix_q_src_c004_0_00 0 bpf_c004_0 0) vcvs gain=1.950903220161e-01
SMIXQ_c004_0_00 (mix_q_src_c004_0_00 mix_q_c004_0 win_0_00 0) relay vt1=-1m vt2=1m ropen=ropen_mix rclosed=rclosed_mix
EMIXI_c004_0_01 (mix_i_src_c004_0_01 0 bpf_c004_0 0) vcvs gain=8.314696123025e-01
SMIXI_c004_0_01 (mix_i_src_c004_0_01 mix_i_c004_0 win_0_01 0) relay vt1=-1m vt2=1m ropen=ropen_mix rclosed=rclosed_mix
EMIXQ_c004_0_01 (mix_q_src_c004_0_01 0 bpf_c004_0 0) vcvs gain=5.555702330196e-01
SMIXQ_c004_0_01 (mix_q_src_c004_0_01 mix_q_c004_0 win_0_01 0) relay vt1=-1m vt2=1m ropen=ropen_mix rclosed=rclosed_mix
EMIXI_c004_0_02 (mix_i_src_c004_0_02 0 bpf_c004_0 0) vcvs gain=5.555702330196e-01
SMIXI_c004_0_02 (mix_i_src_c004_0_02 mix_i_c004_0 win_0_02 0) relay vt1=-1m vt2=1m ropen=ropen_mix rclosed=rclosed_mix
EMIXQ_c004_0_02 (mix_q_src_c004_0_02 0 bpf_c004_0 0) vcvs gain=8.314696123025e-01
SMIXQ_c004_0_02 (mix_q_src_c004_0_02 mix_q_c004_0 win_0_02 0) relay vt1=-1m vt2=1m ropen=ropen_mix rclosed=rclosed_mix
EMIXI_c004_0_03 (mix_i_src_c004_0_03 0 bpf_c004_0 0) vcvs gain=1.950903220161e-01
SMIXI_c004_0_03 (mix_i_src_c004_0_03 mix_i_c004_0 win_0_03 0) relay vt1=-1m vt2=1m ropen=ropen_mix rclosed=rclosed_mix
EMIXQ_c004_0_03 (mix_q_src_c004_0_03 0 bpf_c004_0 0) vcvs gain=9.807852804032e-01
SMIXQ_c004_0_03 (mix_q_src_c004_0_03 mix_q_c004_0 win_0_03 0) relay vt1=-1m vt2=1m ropen=ropen_mix rclosed=rclosed_mix
EMIXI_c004_0_04 (mix_i_src_c004_0_04 0 bpf_c004_0 0) vcvs gain=-1.950903220161e-01
SMIXI_c004_0_04 (mix_i_src_c004_0_04 mix_i_c004_0 win_0_04 0) relay vt1=-1m vt2=1m ropen=ropen_mix rclosed=rclosed_mix
EMIXQ_c004_0_04 (mix_q_src_c004_0_04 0 bpf_c004_0 0) vcvs gain=9.807852804032e-01
SMIXQ_c004_0_04 (mix_q_src_c004_0_04 mix_q_c004_0 win_0_04 0) relay vt1=-1m vt2=1m ropen=ropen_mix rclosed=rclosed_mix
EMIXI_c004_0_05 (mix_i_src_c004_0_05 0 bpf_c004_0 0) vcvs gain=-5.555702330196e-01
SMIXI_c004_0_05 (mix_i_src_c004_0_05 mix_i_c004_0 win_0_05 0) relay vt1=-1m vt2=1m ropen=ropen_mix rclosed=rclosed_mix
EMIXQ_c004_0_05 (mix_q_src_c004_0_05 0 bpf_c004_0 0) vcvs gain=8.314696123025e-01
SMIXQ_c004_0_05 (mix_q_src_c004_0_05 mix_q_c004_0 win_0_05 0) relay vt1=-1m vt2=1m ropen=ropen_mix rclosed=rclosed_mix
EMIXI_c004_0_06 (mix_i_src_c004_0_06 0 bpf_c004_0 0) vcvs gain=-8.314696123025e-01
SMIXI_c004_0_06 (mix_i_src_c004_0_06 mix_i_c004_0 win_0_06 0) relay vt1=-1m vt2=1m ropen=ropen_mix rclosed=rclosed_mix
EMIXQ_c004_0_06 (mix_q_src_c004_0_06 0 bpf_c004_0 0) vcvs gain=5.555702330196e-01
SMIXQ_c004_0_06 (mix_q_src_c004_0_06 mix_q_c004_0 win_0_06 0) relay vt1=-1m vt2=1m ropen=ropen_mix rclosed=rclosed_mix
EMIXI_c004_0_07 (mix_i_src_c004_0_07 0 bpf_c004_0 0) vcvs gain=-9.807852804032e-01
SMIXI_c004_0_07 (mix_i_src_c004_0_07 mix_i_c004_0 win_0_07 0) relay vt1=-1m vt2=1m ropen=ropen_mix rclosed=rclosed_mix
EMIXQ_c004_0_07 (mix_q_src_c004_0_07 0 bpf_c004_0 0) vcvs gain=1.950903220161e-01
SMIXQ_c004_0_07 (mix_q_src_c004_0_07 mix_q_c004_0 win_0_07 0) relay vt1=-1m vt2=1m ropen=ropen_mix rclosed=rclosed_mix
EMIXI_c004_0_08 (mix_i_src_c004_0_08 0 bpf_c004_0 0) vcvs gain=-9.807852804032e-01
SMIXI_c004_0_08 (mix_i_src_c004_0_08 mix_i_c004_0 win_0_08 0) relay vt1=-1m vt2=1m ropen=ropen_mix rclosed=rclosed_mix
EMIXQ_c004_0_08 (mix_q_src_c004_0_08 0 bpf_c004_0 0) vcvs gain=-1.950903220161e-01
SMIXQ_c004_0_08 (mix_q_src_c004_0_08 mix_q_c004_0 win_0_08 0) relay vt1=-1m vt2=1m ropen=ropen_mix rclosed=rclosed_mix
EMIXI_c004_0_09 (mix_i_src_c004_0_09 0 bpf_c004_0 0) vcvs gain=-8.314696123025e-01
SMIXI_c004_0_09 (mix_i_src_c004_0_09 mix_i_c004_0 win_0_09 0) relay vt1=-1m vt2=1m ropen=ropen_mix rclosed=rclosed_mix
EMIXQ_c004_0_09 (mix_q_src_c004_0_09 0 bpf_c004_0 0) vcvs gain=-5.555702330196e-01
SMIXQ_c004_0_09 (mix_q_src_c004_0_09 mix_q_c004_0 win_0_09 0) relay vt1=-1m vt2=1m ropen=ropen_mix rclosed=rclosed_mix
EMIXI_c004_0_10 (mix_i_src_c004_0_10 0 bpf_c004_0 0) vcvs gain=-5.555702330196e-01
SMIXI_c004_0_10 (mix_i_src_c004_0_10 mix_i_c004_0 win_0_10 0) relay vt1=-1m vt2=1m ropen=ropen_mix rclosed=rclosed_mix
EMIXQ_c004_0_10 (mix_q_src_c004_0_10 0 bpf_c004_0 0) vcvs gain=-8.314696123025e-01
SMIXQ_c004_0_10 (mix_q_src_c004_0_10 mix_q_c004_0 win_0_10 0) relay vt1=-1m vt2=1m ropen=ropen_mix rclosed=rclosed_mix
EMIXI_c004_0_11 (mix_i_src_c004_0_11 0 bpf_c004_0 0) vcvs gain=-1.950903220161e-01
SMIXI_c004_0_11 (mix_i_src_c004_0_11 mix_i_c004_0 win_0_11 0) relay vt1=-1m vt2=1m ropen=ropen_mix rclosed=rclosed_mix
EMIXQ_c004_0_11 (mix_q_src_c004_0_11 0 bpf_c004_0 0) vcvs gain=-9.807852804032e-01
SMIXQ_c004_0_11 (mix_q_src_c004_0_11 mix_q_c004_0 win_0_11 0) relay vt1=-1m vt2=1m ropen=ropen_mix rclosed=rclosed_mix
EMIXI_c004_0_12 (mix_i_src_c004_0_12 0 bpf_c004_0 0) vcvs gain=1.950903220161e-01
SMIXI_c004_0_12 (mix_i_src_c004_0_12 mix_i_c004_0 win_0_12 0) relay vt1=-1m vt2=1m ropen=ropen_mix rclosed=rclosed_mix
EMIXQ_c004_0_12 (mix_q_src_c004_0_12 0 bpf_c004_0 0) vcvs gain=-9.807852804032e-01
SMIXQ_c004_0_12 (mix_q_src_c004_0_12 mix_q_c004_0 win_0_12 0) relay vt1=-1m vt2=1m ropen=ropen_mix rclosed=rclosed_mix
EMIXI_c004_0_13 (mix_i_src_c004_0_13 0 bpf_c004_0 0) vcvs gain=5.555702330196e-01
SMIXI_c004_0_13 (mix_i_src_c004_0_13 mix_i_c004_0 win_0_13 0) relay vt1=-1m vt2=1m ropen=ropen_mix rclosed=rclosed_mix
EMIXQ_c004_0_13 (mix_q_src_c004_0_13 0 bpf_c004_0 0) vcvs gain=-8.314696123025e-01
SMIXQ_c004_0_13 (mix_q_src_c004_0_13 mix_q_c004_0 win_0_13 0) relay vt1=-1m vt2=1m ropen=ropen_mix rclosed=rclosed_mix
EMIXI_c004_0_14 (mix_i_src_c004_0_14 0 bpf_c004_0 0) vcvs gain=8.314696123025e-01
SMIXI_c004_0_14 (mix_i_src_c004_0_14 mix_i_c004_0 win_0_14 0) relay vt1=-1m vt2=1m ropen=ropen_mix rclosed=rclosed_mix
EMIXQ_c004_0_14 (mix_q_src_c004_0_14 0 bpf_c004_0 0) vcvs gain=-5.555702330196e-01
SMIXQ_c004_0_14 (mix_q_src_c004_0_14 mix_q_c004_0 win_0_14 0) relay vt1=-1m vt2=1m ropen=ropen_mix rclosed=rclosed_mix
EMIXI_c004_0_15 (mix_i_src_c004_0_15 0 bpf_c004_0 0) vcvs gain=9.807852804032e-01
SMIXI_c004_0_15 (mix_i_src_c004_0_15 mix_i_c004_0 win_0_15 0) relay vt1=-1m vt2=1m ropen=ropen_mix rclosed=rclosed_mix
EMIXQ_c004_0_15 (mix_q_src_c004_0_15 0 bpf_c004_0 0) vcvs gain=-1.950903220161e-01
SMIXQ_c004_0_15 (mix_q_src_c004_0_15 mix_q_c004_0 win_0_15 0) relay vt1=-1m vt2=1m ropen=ropen_mix rclosed=rclosed_mix
RMIXI_c004_0 (mix_i_c004_0 0) resistor r=1G
RMIXQ_c004_0 (mix_q_c004_0 0) resistor r=1G
RINTI_c004_0 (mix_i_c004_0 Icar_c004_0) resistor r=1k
CINTI_c004_0 (Icar_c004_0 0) capacitor c=80p
RINTQ_c004_0 (mix_q_c004_0 Qcar_c004_0) resistor r=1k
CINTQ_c004_0 (Qcar_c004_0 0) capacitor c=80p
save bpf_c004_0 Icar_c004_0 Qcar_c004_0

// bl004, carrier_1: 500000000 Hz coherent I/Q phase-window verification-demod path
CBPF_c004_1 (bl004 n_cbpf_c004_1) capacitor c=1.013211836423e-13
LBPF_c004_1 (n_cbpf_c004_1 bpf_c004_1) inductor l=1.000000000000e-06
RBPF_c004_1 (bpf_c004_1 0) resistor r=1.570796326795e+02
EMIXI_c004_1_00 (mix_i_src_c004_1_00 0 bpf_c004_1 0) vcvs gain=9.807852804032e-01
SMIXI_c004_1_00 (mix_i_src_c004_1_00 mix_i_c004_1 win_1_00 0) relay vt1=-1m vt2=1m ropen=ropen_mix rclosed=rclosed_mix
EMIXQ_c004_1_00 (mix_q_src_c004_1_00 0 bpf_c004_1 0) vcvs gain=1.950903220161e-01
SMIXQ_c004_1_00 (mix_q_src_c004_1_00 mix_q_c004_1 win_1_00 0) relay vt1=-1m vt2=1m ropen=ropen_mix rclosed=rclosed_mix
EMIXI_c004_1_01 (mix_i_src_c004_1_01 0 bpf_c004_1 0) vcvs gain=8.314696123025e-01
SMIXI_c004_1_01 (mix_i_src_c004_1_01 mix_i_c004_1 win_1_01 0) relay vt1=-1m vt2=1m ropen=ropen_mix rclosed=rclosed_mix
EMIXQ_c004_1_01 (mix_q_src_c004_1_01 0 bpf_c004_1 0) vcvs gain=5.555702330196e-01
SMIXQ_c004_1_01 (mix_q_src_c004_1_01 mix_q_c004_1 win_1_01 0) relay vt1=-1m vt2=1m ropen=ropen_mix rclosed=rclosed_mix
EMIXI_c004_1_02 (mix_i_src_c004_1_02 0 bpf_c004_1 0) vcvs gain=5.555702330196e-01
SMIXI_c004_1_02 (mix_i_src_c004_1_02 mix_i_c004_1 win_1_02 0) relay vt1=-1m vt2=1m ropen=ropen_mix rclosed=rclosed_mix
EMIXQ_c004_1_02 (mix_q_src_c004_1_02 0 bpf_c004_1 0) vcvs gain=8.314696123025e-01
SMIXQ_c004_1_02 (mix_q_src_c004_1_02 mix_q_c004_1 win_1_02 0) relay vt1=-1m vt2=1m ropen=ropen_mix rclosed=rclosed_mix
EMIXI_c004_1_03 (mix_i_src_c004_1_03 0 bpf_c004_1 0) vcvs gain=1.950903220161e-01
SMIXI_c004_1_03 (mix_i_src_c004_1_03 mix_i_c004_1 win_1_03 0) relay vt1=-1m vt2=1m ropen=ropen_mix rclosed=rclosed_mix
EMIXQ_c004_1_03 (mix_q_src_c004_1_03 0 bpf_c004_1 0) vcvs gain=9.807852804032e-01
SMIXQ_c004_1_03 (mix_q_src_c004_1_03 mix_q_c004_1 win_1_03 0) relay vt1=-1m vt2=1m ropen=ropen_mix rclosed=rclosed_mix
EMIXI_c004_1_04 (mix_i_src_c004_1_04 0 bpf_c004_1 0) vcvs gain=-1.950903220161e-01
SMIXI_c004_1_04 (mix_i_src_c004_1_04 mix_i_c004_1 win_1_04 0) relay vt1=-1m vt2=1m ropen=ropen_mix rclosed=rclosed_mix
EMIXQ_c004_1_04 (mix_q_src_c004_1_04 0 bpf_c004_1 0) vcvs gain=9.807852804032e-01
SMIXQ_c004_1_04 (mix_q_src_c004_1_04 mix_q_c004_1 win_1_04 0) relay vt1=-1m vt2=1m ropen=ropen_mix rclosed=rclosed_mix
EMIXI_c004_1_05 (mix_i_src_c004_1_05 0 bpf_c004_1 0) vcvs gain=-5.555702330196e-01
SMIXI_c004_1_05 (mix_i_src_c004_1_05 mix_i_c004_1 win_1_05 0) relay vt1=-1m vt2=1m ropen=ropen_mix rclosed=rclosed_mix
EMIXQ_c004_1_05 (mix_q_src_c004_1_05 0 bpf_c004_1 0) vcvs gain=8.314696123025e-01
SMIXQ_c004_1_05 (mix_q_src_c004_1_05 mix_q_c004_1 win_1_05 0) relay vt1=-1m vt2=1m ropen=ropen_mix rclosed=rclosed_mix
EMIXI_c004_1_06 (mix_i_src_c004_1_06 0 bpf_c004_1 0) vcvs gain=-8.314696123025e-01
SMIXI_c004_1_06 (mix_i_src_c004_1_06 mix_i_c004_1 win_1_06 0) relay vt1=-1m vt2=1m ropen=ropen_mix rclosed=rclosed_mix
EMIXQ_c004_1_06 (mix_q_src_c004_1_06 0 bpf_c004_1 0) vcvs gain=5.555702330196e-01
SMIXQ_c004_1_06 (mix_q_src_c004_1_06 mix_q_c004_1 win_1_06 0) relay vt1=-1m vt2=1m ropen=ropen_mix rclosed=rclosed_mix
EMIXI_c004_1_07 (mix_i_src_c004_1_07 0 bpf_c004_1 0) vcvs gain=-9.807852804032e-01
SMIXI_c004_1_07 (mix_i_src_c004_1_07 mix_i_c004_1 win_1_07 0) relay vt1=-1m vt2=1m ropen=ropen_mix rclosed=rclosed_mix
EMIXQ_c004_1_07 (mix_q_src_c004_1_07 0 bpf_c004_1 0) vcvs gain=1.950903220161e-01
SMIXQ_c004_1_07 (mix_q_src_c004_1_07 mix_q_c004_1 win_1_07 0) relay vt1=-1m vt2=1m ropen=ropen_mix rclosed=rclosed_mix
EMIXI_c004_1_08 (mix_i_src_c004_1_08 0 bpf_c004_1 0) vcvs gain=-9.807852804032e-01
SMIXI_c004_1_08 (mix_i_src_c004_1_08 mix_i_c004_1 win_1_08 0) relay vt1=-1m vt2=1m ropen=ropen_mix rclosed=rclosed_mix
EMIXQ_c004_1_08 (mix_q_src_c004_1_08 0 bpf_c004_1 0) vcvs gain=-1.950903220161e-01
SMIXQ_c004_1_08 (mix_q_src_c004_1_08 mix_q_c004_1 win_1_08 0) relay vt1=-1m vt2=1m ropen=ropen_mix rclosed=rclosed_mix
EMIXI_c004_1_09 (mix_i_src_c004_1_09 0 bpf_c004_1 0) vcvs gain=-8.314696123025e-01
SMIXI_c004_1_09 (mix_i_src_c004_1_09 mix_i_c004_1 win_1_09 0) relay vt1=-1m vt2=1m ropen=ropen_mix rclosed=rclosed_mix
EMIXQ_c004_1_09 (mix_q_src_c004_1_09 0 bpf_c004_1 0) vcvs gain=-5.555702330196e-01
SMIXQ_c004_1_09 (mix_q_src_c004_1_09 mix_q_c004_1 win_1_09 0) relay vt1=-1m vt2=1m ropen=ropen_mix rclosed=rclosed_mix
EMIXI_c004_1_10 (mix_i_src_c004_1_10 0 bpf_c004_1 0) vcvs gain=-5.555702330196e-01
SMIXI_c004_1_10 (mix_i_src_c004_1_10 mix_i_c004_1 win_1_10 0) relay vt1=-1m vt2=1m ropen=ropen_mix rclosed=rclosed_mix
EMIXQ_c004_1_10 (mix_q_src_c004_1_10 0 bpf_c004_1 0) vcvs gain=-8.314696123025e-01
SMIXQ_c004_1_10 (mix_q_src_c004_1_10 mix_q_c004_1 win_1_10 0) relay vt1=-1m vt2=1m ropen=ropen_mix rclosed=rclosed_mix
EMIXI_c004_1_11 (mix_i_src_c004_1_11 0 bpf_c004_1 0) vcvs gain=-1.950903220161e-01
SMIXI_c004_1_11 (mix_i_src_c004_1_11 mix_i_c004_1 win_1_11 0) relay vt1=-1m vt2=1m ropen=ropen_mix rclosed=rclosed_mix
EMIXQ_c004_1_11 (mix_q_src_c004_1_11 0 bpf_c004_1 0) vcvs gain=-9.807852804032e-01
SMIXQ_c004_1_11 (mix_q_src_c004_1_11 mix_q_c004_1 win_1_11 0) relay vt1=-1m vt2=1m ropen=ropen_mix rclosed=rclosed_mix
EMIXI_c004_1_12 (mix_i_src_c004_1_12 0 bpf_c004_1 0) vcvs gain=1.950903220161e-01
SMIXI_c004_1_12 (mix_i_src_c004_1_12 mix_i_c004_1 win_1_12 0) relay vt1=-1m vt2=1m ropen=ropen_mix rclosed=rclosed_mix
EMIXQ_c004_1_12 (mix_q_src_c004_1_12 0 bpf_c004_1 0) vcvs gain=-9.807852804032e-01
SMIXQ_c004_1_12 (mix_q_src_c004_1_12 mix_q_c004_1 win_1_12 0) relay vt1=-1m vt2=1m ropen=ropen_mix rclosed=rclosed_mix
EMIXI_c004_1_13 (mix_i_src_c004_1_13 0 bpf_c004_1 0) vcvs gain=5.555702330196e-01
SMIXI_c004_1_13 (mix_i_src_c004_1_13 mix_i_c004_1 win_1_13 0) relay vt1=-1m vt2=1m ropen=ropen_mix rclosed=rclosed_mix
EMIXQ_c004_1_13 (mix_q_src_c004_1_13 0 bpf_c004_1 0) vcvs gain=-8.314696123025e-01
SMIXQ_c004_1_13 (mix_q_src_c004_1_13 mix_q_c004_1 win_1_13 0) relay vt1=-1m vt2=1m ropen=ropen_mix rclosed=rclosed_mix
EMIXI_c004_1_14 (mix_i_src_c004_1_14 0 bpf_c004_1 0) vcvs gain=8.314696123025e-01
SMIXI_c004_1_14 (mix_i_src_c004_1_14 mix_i_c004_1 win_1_14 0) relay vt1=-1m vt2=1m ropen=ropen_mix rclosed=rclosed_mix
EMIXQ_c004_1_14 (mix_q_src_c004_1_14 0 bpf_c004_1 0) vcvs gain=-5.555702330196e-01
SMIXQ_c004_1_14 (mix_q_src_c004_1_14 mix_q_c004_1 win_1_14 0) relay vt1=-1m vt2=1m ropen=ropen_mix rclosed=rclosed_mix
EMIXI_c004_1_15 (mix_i_src_c004_1_15 0 bpf_c004_1 0) vcvs gain=9.807852804032e-01
SMIXI_c004_1_15 (mix_i_src_c004_1_15 mix_i_c004_1 win_1_15 0) relay vt1=-1m vt2=1m ropen=ropen_mix rclosed=rclosed_mix
EMIXQ_c004_1_15 (mix_q_src_c004_1_15 0 bpf_c004_1 0) vcvs gain=-1.950903220161e-01
SMIXQ_c004_1_15 (mix_q_src_c004_1_15 mix_q_c004_1 win_1_15 0) relay vt1=-1m vt2=1m ropen=ropen_mix rclosed=rclosed_mix
RMIXI_c004_1 (mix_i_c004_1 0) resistor r=1G
RMIXQ_c004_1 (mix_q_c004_1 0) resistor r=1G
RINTI_c004_1 (mix_i_c004_1 Icar_c004_1) resistor r=1k
CINTI_c004_1 (Icar_c004_1 0) capacitor c=80p
RINTQ_c004_1 (mix_q_c004_1 Qcar_c004_1) resistor r=1k
CINTQ_c004_1 (Qcar_c004_1 0) capacitor c=80p
save bpf_c004_1 Icar_c004_1 Qcar_c004_1

// bl004, carrier_2: 750000000 Hz coherent I/Q phase-window verification-demod path
CBPF_c004_2 (bl004 n_cbpf_c004_2) capacitor c=4.503163717437e-14
LBPF_c004_2 (n_cbpf_c004_2 bpf_c004_2) inductor l=1.000000000000e-06
RBPF_c004_2 (bpf_c004_2 0) resistor r=2.356194490192e+02
EMIXI_c004_2_00 (mix_i_src_c004_2_00 0 bpf_c004_2 0) vcvs gain=9.807852804032e-01
SMIXI_c004_2_00 (mix_i_src_c004_2_00 mix_i_c004_2 win_2_00 0) relay vt1=-1m vt2=1m ropen=ropen_mix rclosed=rclosed_mix
EMIXQ_c004_2_00 (mix_q_src_c004_2_00 0 bpf_c004_2 0) vcvs gain=1.950903220161e-01
SMIXQ_c004_2_00 (mix_q_src_c004_2_00 mix_q_c004_2 win_2_00 0) relay vt1=-1m vt2=1m ropen=ropen_mix rclosed=rclosed_mix
EMIXI_c004_2_01 (mix_i_src_c004_2_01 0 bpf_c004_2 0) vcvs gain=8.314696123025e-01
SMIXI_c004_2_01 (mix_i_src_c004_2_01 mix_i_c004_2 win_2_01 0) relay vt1=-1m vt2=1m ropen=ropen_mix rclosed=rclosed_mix
EMIXQ_c004_2_01 (mix_q_src_c004_2_01 0 bpf_c004_2 0) vcvs gain=5.555702330196e-01
SMIXQ_c004_2_01 (mix_q_src_c004_2_01 mix_q_c004_2 win_2_01 0) relay vt1=-1m vt2=1m ropen=ropen_mix rclosed=rclosed_mix
EMIXI_c004_2_02 (mix_i_src_c004_2_02 0 bpf_c004_2 0) vcvs gain=5.555702330196e-01
SMIXI_c004_2_02 (mix_i_src_c004_2_02 mix_i_c004_2 win_2_02 0) relay vt1=-1m vt2=1m ropen=ropen_mix rclosed=rclosed_mix
EMIXQ_c004_2_02 (mix_q_src_c004_2_02 0 bpf_c004_2 0) vcvs gain=8.314696123025e-01
SMIXQ_c004_2_02 (mix_q_src_c004_2_02 mix_q_c004_2 win_2_02 0) relay vt1=-1m vt2=1m ropen=ropen_mix rclosed=rclosed_mix
EMIXI_c004_2_03 (mix_i_src_c004_2_03 0 bpf_c004_2 0) vcvs gain=1.950903220161e-01
SMIXI_c004_2_03 (mix_i_src_c004_2_03 mix_i_c004_2 win_2_03 0) relay vt1=-1m vt2=1m ropen=ropen_mix rclosed=rclosed_mix
EMIXQ_c004_2_03 (mix_q_src_c004_2_03 0 bpf_c004_2 0) vcvs gain=9.807852804032e-01
SMIXQ_c004_2_03 (mix_q_src_c004_2_03 mix_q_c004_2 win_2_03 0) relay vt1=-1m vt2=1m ropen=ropen_mix rclosed=rclosed_mix
EMIXI_c004_2_04 (mix_i_src_c004_2_04 0 bpf_c004_2 0) vcvs gain=-1.950903220161e-01
SMIXI_c004_2_04 (mix_i_src_c004_2_04 mix_i_c004_2 win_2_04 0) relay vt1=-1m vt2=1m ropen=ropen_mix rclosed=rclosed_mix
EMIXQ_c004_2_04 (mix_q_src_c004_2_04 0 bpf_c004_2 0) vcvs gain=9.807852804032e-01
SMIXQ_c004_2_04 (mix_q_src_c004_2_04 mix_q_c004_2 win_2_04 0) relay vt1=-1m vt2=1m ropen=ropen_mix rclosed=rclosed_mix
EMIXI_c004_2_05 (mix_i_src_c004_2_05 0 bpf_c004_2 0) vcvs gain=-5.555702330196e-01
SMIXI_c004_2_05 (mix_i_src_c004_2_05 mix_i_c004_2 win_2_05 0) relay vt1=-1m vt2=1m ropen=ropen_mix rclosed=rclosed_mix
EMIXQ_c004_2_05 (mix_q_src_c004_2_05 0 bpf_c004_2 0) vcvs gain=8.314696123025e-01
SMIXQ_c004_2_05 (mix_q_src_c004_2_05 mix_q_c004_2 win_2_05 0) relay vt1=-1m vt2=1m ropen=ropen_mix rclosed=rclosed_mix
EMIXI_c004_2_06 (mix_i_src_c004_2_06 0 bpf_c004_2 0) vcvs gain=-8.314696123025e-01
SMIXI_c004_2_06 (mix_i_src_c004_2_06 mix_i_c004_2 win_2_06 0) relay vt1=-1m vt2=1m ropen=ropen_mix rclosed=rclosed_mix
EMIXQ_c004_2_06 (mix_q_src_c004_2_06 0 bpf_c004_2 0) vcvs gain=5.555702330196e-01
SMIXQ_c004_2_06 (mix_q_src_c004_2_06 mix_q_c004_2 win_2_06 0) relay vt1=-1m vt2=1m ropen=ropen_mix rclosed=rclosed_mix
EMIXI_c004_2_07 (mix_i_src_c004_2_07 0 bpf_c004_2 0) vcvs gain=-9.807852804032e-01
SMIXI_c004_2_07 (mix_i_src_c004_2_07 mix_i_c004_2 win_2_07 0) relay vt1=-1m vt2=1m ropen=ropen_mix rclosed=rclosed_mix
EMIXQ_c004_2_07 (mix_q_src_c004_2_07 0 bpf_c004_2 0) vcvs gain=1.950903220161e-01
SMIXQ_c004_2_07 (mix_q_src_c004_2_07 mix_q_c004_2 win_2_07 0) relay vt1=-1m vt2=1m ropen=ropen_mix rclosed=rclosed_mix
EMIXI_c004_2_08 (mix_i_src_c004_2_08 0 bpf_c004_2 0) vcvs gain=-9.807852804032e-01
SMIXI_c004_2_08 (mix_i_src_c004_2_08 mix_i_c004_2 win_2_08 0) relay vt1=-1m vt2=1m ropen=ropen_mix rclosed=rclosed_mix
EMIXQ_c004_2_08 (mix_q_src_c004_2_08 0 bpf_c004_2 0) vcvs gain=-1.950903220161e-01
SMIXQ_c004_2_08 (mix_q_src_c004_2_08 mix_q_c004_2 win_2_08 0) relay vt1=-1m vt2=1m ropen=ropen_mix rclosed=rclosed_mix
EMIXI_c004_2_09 (mix_i_src_c004_2_09 0 bpf_c004_2 0) vcvs gain=-8.314696123025e-01
SMIXI_c004_2_09 (mix_i_src_c004_2_09 mix_i_c004_2 win_2_09 0) relay vt1=-1m vt2=1m ropen=ropen_mix rclosed=rclosed_mix
EMIXQ_c004_2_09 (mix_q_src_c004_2_09 0 bpf_c004_2 0) vcvs gain=-5.555702330196e-01
SMIXQ_c004_2_09 (mix_q_src_c004_2_09 mix_q_c004_2 win_2_09 0) relay vt1=-1m vt2=1m ropen=ropen_mix rclosed=rclosed_mix
EMIXI_c004_2_10 (mix_i_src_c004_2_10 0 bpf_c004_2 0) vcvs gain=-5.555702330196e-01
SMIXI_c004_2_10 (mix_i_src_c004_2_10 mix_i_c004_2 win_2_10 0) relay vt1=-1m vt2=1m ropen=ropen_mix rclosed=rclosed_mix
EMIXQ_c004_2_10 (mix_q_src_c004_2_10 0 bpf_c004_2 0) vcvs gain=-8.314696123025e-01
SMIXQ_c004_2_10 (mix_q_src_c004_2_10 mix_q_c004_2 win_2_10 0) relay vt1=-1m vt2=1m ropen=ropen_mix rclosed=rclosed_mix
EMIXI_c004_2_11 (mix_i_src_c004_2_11 0 bpf_c004_2 0) vcvs gain=-1.950903220161e-01
SMIXI_c004_2_11 (mix_i_src_c004_2_11 mix_i_c004_2 win_2_11 0) relay vt1=-1m vt2=1m ropen=ropen_mix rclosed=rclosed_mix
EMIXQ_c004_2_11 (mix_q_src_c004_2_11 0 bpf_c004_2 0) vcvs gain=-9.807852804032e-01
SMIXQ_c004_2_11 (mix_q_src_c004_2_11 mix_q_c004_2 win_2_11 0) relay vt1=-1m vt2=1m ropen=ropen_mix rclosed=rclosed_mix
EMIXI_c004_2_12 (mix_i_src_c004_2_12 0 bpf_c004_2 0) vcvs gain=1.950903220161e-01
SMIXI_c004_2_12 (mix_i_src_c004_2_12 mix_i_c004_2 win_2_12 0) relay vt1=-1m vt2=1m ropen=ropen_mix rclosed=rclosed_mix
EMIXQ_c004_2_12 (mix_q_src_c004_2_12 0 bpf_c004_2 0) vcvs gain=-9.807852804032e-01
SMIXQ_c004_2_12 (mix_q_src_c004_2_12 mix_q_c004_2 win_2_12 0) relay vt1=-1m vt2=1m ropen=ropen_mix rclosed=rclosed_mix
EMIXI_c004_2_13 (mix_i_src_c004_2_13 0 bpf_c004_2 0) vcvs gain=5.555702330196e-01
SMIXI_c004_2_13 (mix_i_src_c004_2_13 mix_i_c004_2 win_2_13 0) relay vt1=-1m vt2=1m ropen=ropen_mix rclosed=rclosed_mix
EMIXQ_c004_2_13 (mix_q_src_c004_2_13 0 bpf_c004_2 0) vcvs gain=-8.314696123025e-01
SMIXQ_c004_2_13 (mix_q_src_c004_2_13 mix_q_c004_2 win_2_13 0) relay vt1=-1m vt2=1m ropen=ropen_mix rclosed=rclosed_mix
EMIXI_c004_2_14 (mix_i_src_c004_2_14 0 bpf_c004_2 0) vcvs gain=8.314696123025e-01
SMIXI_c004_2_14 (mix_i_src_c004_2_14 mix_i_c004_2 win_2_14 0) relay vt1=-1m vt2=1m ropen=ropen_mix rclosed=rclosed_mix
EMIXQ_c004_2_14 (mix_q_src_c004_2_14 0 bpf_c004_2 0) vcvs gain=-5.555702330196e-01
SMIXQ_c004_2_14 (mix_q_src_c004_2_14 mix_q_c004_2 win_2_14 0) relay vt1=-1m vt2=1m ropen=ropen_mix rclosed=rclosed_mix
EMIXI_c004_2_15 (mix_i_src_c004_2_15 0 bpf_c004_2 0) vcvs gain=9.807852804032e-01
SMIXI_c004_2_15 (mix_i_src_c004_2_15 mix_i_c004_2 win_2_15 0) relay vt1=-1m vt2=1m ropen=ropen_mix rclosed=rclosed_mix
EMIXQ_c004_2_15 (mix_q_src_c004_2_15 0 bpf_c004_2 0) vcvs gain=-1.950903220161e-01
SMIXQ_c004_2_15 (mix_q_src_c004_2_15 mix_q_c004_2 win_2_15 0) relay vt1=-1m vt2=1m ropen=ropen_mix rclosed=rclosed_mix
RMIXI_c004_2 (mix_i_c004_2 0) resistor r=1G
RMIXQ_c004_2 (mix_q_c004_2 0) resistor r=1G
RINTI_c004_2 (mix_i_c004_2 Icar_c004_2) resistor r=1k
CINTI_c004_2 (Icar_c004_2 0) capacitor c=80p
RINTQ_c004_2 (mix_q_c004_2 Qcar_c004_2) resistor r=1k
CINTQ_c004_2 (Qcar_c004_2 0) capacitor c=80p
save bpf_c004_2 Icar_c004_2 Qcar_c004_2

// bl004, carrier_3: 1000000000 Hz coherent I/Q phase-window verification-demod path
CBPF_c004_3 (bl004 n_cbpf_c004_3) capacitor c=2.533029591058e-14
LBPF_c004_3 (n_cbpf_c004_3 bpf_c004_3) inductor l=1.000000000000e-06
RBPF_c004_3 (bpf_c004_3 0) resistor r=3.141592653590e+02
EMIXI_c004_3_00 (mix_i_src_c004_3_00 0 bpf_c004_3 0) vcvs gain=9.807852804032e-01
SMIXI_c004_3_00 (mix_i_src_c004_3_00 mix_i_c004_3 win_3_00 0) relay vt1=-1m vt2=1m ropen=ropen_mix rclosed=rclosed_mix
EMIXQ_c004_3_00 (mix_q_src_c004_3_00 0 bpf_c004_3 0) vcvs gain=1.950903220161e-01
SMIXQ_c004_3_00 (mix_q_src_c004_3_00 mix_q_c004_3 win_3_00 0) relay vt1=-1m vt2=1m ropen=ropen_mix rclosed=rclosed_mix
EMIXI_c004_3_01 (mix_i_src_c004_3_01 0 bpf_c004_3 0) vcvs gain=8.314696123025e-01
SMIXI_c004_3_01 (mix_i_src_c004_3_01 mix_i_c004_3 win_3_01 0) relay vt1=-1m vt2=1m ropen=ropen_mix rclosed=rclosed_mix
EMIXQ_c004_3_01 (mix_q_src_c004_3_01 0 bpf_c004_3 0) vcvs gain=5.555702330196e-01
SMIXQ_c004_3_01 (mix_q_src_c004_3_01 mix_q_c004_3 win_3_01 0) relay vt1=-1m vt2=1m ropen=ropen_mix rclosed=rclosed_mix
EMIXI_c004_3_02 (mix_i_src_c004_3_02 0 bpf_c004_3 0) vcvs gain=5.555702330196e-01
SMIXI_c004_3_02 (mix_i_src_c004_3_02 mix_i_c004_3 win_3_02 0) relay vt1=-1m vt2=1m ropen=ropen_mix rclosed=rclosed_mix
EMIXQ_c004_3_02 (mix_q_src_c004_3_02 0 bpf_c004_3 0) vcvs gain=8.314696123025e-01
SMIXQ_c004_3_02 (mix_q_src_c004_3_02 mix_q_c004_3 win_3_02 0) relay vt1=-1m vt2=1m ropen=ropen_mix rclosed=rclosed_mix
EMIXI_c004_3_03 (mix_i_src_c004_3_03 0 bpf_c004_3 0) vcvs gain=1.950903220161e-01
SMIXI_c004_3_03 (mix_i_src_c004_3_03 mix_i_c004_3 win_3_03 0) relay vt1=-1m vt2=1m ropen=ropen_mix rclosed=rclosed_mix
EMIXQ_c004_3_03 (mix_q_src_c004_3_03 0 bpf_c004_3 0) vcvs gain=9.807852804032e-01
SMIXQ_c004_3_03 (mix_q_src_c004_3_03 mix_q_c004_3 win_3_03 0) relay vt1=-1m vt2=1m ropen=ropen_mix rclosed=rclosed_mix
EMIXI_c004_3_04 (mix_i_src_c004_3_04 0 bpf_c004_3 0) vcvs gain=-1.950903220161e-01
SMIXI_c004_3_04 (mix_i_src_c004_3_04 mix_i_c004_3 win_3_04 0) relay vt1=-1m vt2=1m ropen=ropen_mix rclosed=rclosed_mix
EMIXQ_c004_3_04 (mix_q_src_c004_3_04 0 bpf_c004_3 0) vcvs gain=9.807852804032e-01
SMIXQ_c004_3_04 (mix_q_src_c004_3_04 mix_q_c004_3 win_3_04 0) relay vt1=-1m vt2=1m ropen=ropen_mix rclosed=rclosed_mix
EMIXI_c004_3_05 (mix_i_src_c004_3_05 0 bpf_c004_3 0) vcvs gain=-5.555702330196e-01
SMIXI_c004_3_05 (mix_i_src_c004_3_05 mix_i_c004_3 win_3_05 0) relay vt1=-1m vt2=1m ropen=ropen_mix rclosed=rclosed_mix
EMIXQ_c004_3_05 (mix_q_src_c004_3_05 0 bpf_c004_3 0) vcvs gain=8.314696123025e-01
SMIXQ_c004_3_05 (mix_q_src_c004_3_05 mix_q_c004_3 win_3_05 0) relay vt1=-1m vt2=1m ropen=ropen_mix rclosed=rclosed_mix
EMIXI_c004_3_06 (mix_i_src_c004_3_06 0 bpf_c004_3 0) vcvs gain=-8.314696123025e-01
SMIXI_c004_3_06 (mix_i_src_c004_3_06 mix_i_c004_3 win_3_06 0) relay vt1=-1m vt2=1m ropen=ropen_mix rclosed=rclosed_mix
EMIXQ_c004_3_06 (mix_q_src_c004_3_06 0 bpf_c004_3 0) vcvs gain=5.555702330196e-01
SMIXQ_c004_3_06 (mix_q_src_c004_3_06 mix_q_c004_3 win_3_06 0) relay vt1=-1m vt2=1m ropen=ropen_mix rclosed=rclosed_mix
EMIXI_c004_3_07 (mix_i_src_c004_3_07 0 bpf_c004_3 0) vcvs gain=-9.807852804032e-01
SMIXI_c004_3_07 (mix_i_src_c004_3_07 mix_i_c004_3 win_3_07 0) relay vt1=-1m vt2=1m ropen=ropen_mix rclosed=rclosed_mix
EMIXQ_c004_3_07 (mix_q_src_c004_3_07 0 bpf_c004_3 0) vcvs gain=1.950903220161e-01
SMIXQ_c004_3_07 (mix_q_src_c004_3_07 mix_q_c004_3 win_3_07 0) relay vt1=-1m vt2=1m ropen=ropen_mix rclosed=rclosed_mix
EMIXI_c004_3_08 (mix_i_src_c004_3_08 0 bpf_c004_3 0) vcvs gain=-9.807852804032e-01
SMIXI_c004_3_08 (mix_i_src_c004_3_08 mix_i_c004_3 win_3_08 0) relay vt1=-1m vt2=1m ropen=ropen_mix rclosed=rclosed_mix
EMIXQ_c004_3_08 (mix_q_src_c004_3_08 0 bpf_c004_3 0) vcvs gain=-1.950903220161e-01
SMIXQ_c004_3_08 (mix_q_src_c004_3_08 mix_q_c004_3 win_3_08 0) relay vt1=-1m vt2=1m ropen=ropen_mix rclosed=rclosed_mix
EMIXI_c004_3_09 (mix_i_src_c004_3_09 0 bpf_c004_3 0) vcvs gain=-8.314696123025e-01
SMIXI_c004_3_09 (mix_i_src_c004_3_09 mix_i_c004_3 win_3_09 0) relay vt1=-1m vt2=1m ropen=ropen_mix rclosed=rclosed_mix
EMIXQ_c004_3_09 (mix_q_src_c004_3_09 0 bpf_c004_3 0) vcvs gain=-5.555702330196e-01
SMIXQ_c004_3_09 (mix_q_src_c004_3_09 mix_q_c004_3 win_3_09 0) relay vt1=-1m vt2=1m ropen=ropen_mix rclosed=rclosed_mix
EMIXI_c004_3_10 (mix_i_src_c004_3_10 0 bpf_c004_3 0) vcvs gain=-5.555702330196e-01
SMIXI_c004_3_10 (mix_i_src_c004_3_10 mix_i_c004_3 win_3_10 0) relay vt1=-1m vt2=1m ropen=ropen_mix rclosed=rclosed_mix
EMIXQ_c004_3_10 (mix_q_src_c004_3_10 0 bpf_c004_3 0) vcvs gain=-8.314696123025e-01
SMIXQ_c004_3_10 (mix_q_src_c004_3_10 mix_q_c004_3 win_3_10 0) relay vt1=-1m vt2=1m ropen=ropen_mix rclosed=rclosed_mix
EMIXI_c004_3_11 (mix_i_src_c004_3_11 0 bpf_c004_3 0) vcvs gain=-1.950903220161e-01
SMIXI_c004_3_11 (mix_i_src_c004_3_11 mix_i_c004_3 win_3_11 0) relay vt1=-1m vt2=1m ropen=ropen_mix rclosed=rclosed_mix
EMIXQ_c004_3_11 (mix_q_src_c004_3_11 0 bpf_c004_3 0) vcvs gain=-9.807852804032e-01
SMIXQ_c004_3_11 (mix_q_src_c004_3_11 mix_q_c004_3 win_3_11 0) relay vt1=-1m vt2=1m ropen=ropen_mix rclosed=rclosed_mix
EMIXI_c004_3_12 (mix_i_src_c004_3_12 0 bpf_c004_3 0) vcvs gain=1.950903220161e-01
SMIXI_c004_3_12 (mix_i_src_c004_3_12 mix_i_c004_3 win_3_12 0) relay vt1=-1m vt2=1m ropen=ropen_mix rclosed=rclosed_mix
EMIXQ_c004_3_12 (mix_q_src_c004_3_12 0 bpf_c004_3 0) vcvs gain=-9.807852804032e-01
SMIXQ_c004_3_12 (mix_q_src_c004_3_12 mix_q_c004_3 win_3_12 0) relay vt1=-1m vt2=1m ropen=ropen_mix rclosed=rclosed_mix
EMIXI_c004_3_13 (mix_i_src_c004_3_13 0 bpf_c004_3 0) vcvs gain=5.555702330196e-01
SMIXI_c004_3_13 (mix_i_src_c004_3_13 mix_i_c004_3 win_3_13 0) relay vt1=-1m vt2=1m ropen=ropen_mix rclosed=rclosed_mix
EMIXQ_c004_3_13 (mix_q_src_c004_3_13 0 bpf_c004_3 0) vcvs gain=-8.314696123025e-01
SMIXQ_c004_3_13 (mix_q_src_c004_3_13 mix_q_c004_3 win_3_13 0) relay vt1=-1m vt2=1m ropen=ropen_mix rclosed=rclosed_mix
EMIXI_c004_3_14 (mix_i_src_c004_3_14 0 bpf_c004_3 0) vcvs gain=8.314696123025e-01
SMIXI_c004_3_14 (mix_i_src_c004_3_14 mix_i_c004_3 win_3_14 0) relay vt1=-1m vt2=1m ropen=ropen_mix rclosed=rclosed_mix
EMIXQ_c004_3_14 (mix_q_src_c004_3_14 0 bpf_c004_3 0) vcvs gain=-5.555702330196e-01
SMIXQ_c004_3_14 (mix_q_src_c004_3_14 mix_q_c004_3 win_3_14 0) relay vt1=-1m vt2=1m ropen=ropen_mix rclosed=rclosed_mix
EMIXI_c004_3_15 (mix_i_src_c004_3_15 0 bpf_c004_3 0) vcvs gain=9.807852804032e-01
SMIXI_c004_3_15 (mix_i_src_c004_3_15 mix_i_c004_3 win_3_15 0) relay vt1=-1m vt2=1m ropen=ropen_mix rclosed=rclosed_mix
EMIXQ_c004_3_15 (mix_q_src_c004_3_15 0 bpf_c004_3 0) vcvs gain=-1.950903220161e-01
SMIXQ_c004_3_15 (mix_q_src_c004_3_15 mix_q_c004_3 win_3_15 0) relay vt1=-1m vt2=1m ropen=ropen_mix rclosed=rclosed_mix
RMIXI_c004_3 (mix_i_c004_3 0) resistor r=1G
RMIXQ_c004_3 (mix_q_c004_3 0) resistor r=1G
RINTI_c004_3 (mix_i_c004_3 Icar_c004_3) resistor r=1k
CINTI_c004_3 (Icar_c004_3 0) capacitor c=80p
RINTQ_c004_3 (mix_q_c004_3 Qcar_c004_3) resistor r=1k
CINTQ_c004_3 (Qcar_c004_3 0) capacitor c=80p
save bpf_c004_3 Icar_c004_3 Qcar_c004_3

// bl005, carrier_0: 250000000 Hz coherent I/Q phase-window verification-demod path
CBPF_c005_0 (bl005 n_cbpf_c005_0) capacitor c=4.052847345694e-13
LBPF_c005_0 (n_cbpf_c005_0 bpf_c005_0) inductor l=1.000000000000e-06
RBPF_c005_0 (bpf_c005_0 0) resistor r=7.853981633974e+01
EMIXI_c005_0_00 (mix_i_src_c005_0_00 0 bpf_c005_0 0) vcvs gain=9.807852804032e-01
SMIXI_c005_0_00 (mix_i_src_c005_0_00 mix_i_c005_0 win_0_00 0) relay vt1=-1m vt2=1m ropen=ropen_mix rclosed=rclosed_mix
EMIXQ_c005_0_00 (mix_q_src_c005_0_00 0 bpf_c005_0 0) vcvs gain=1.950903220161e-01
SMIXQ_c005_0_00 (mix_q_src_c005_0_00 mix_q_c005_0 win_0_00 0) relay vt1=-1m vt2=1m ropen=ropen_mix rclosed=rclosed_mix
EMIXI_c005_0_01 (mix_i_src_c005_0_01 0 bpf_c005_0 0) vcvs gain=8.314696123025e-01
SMIXI_c005_0_01 (mix_i_src_c005_0_01 mix_i_c005_0 win_0_01 0) relay vt1=-1m vt2=1m ropen=ropen_mix rclosed=rclosed_mix
EMIXQ_c005_0_01 (mix_q_src_c005_0_01 0 bpf_c005_0 0) vcvs gain=5.555702330196e-01
SMIXQ_c005_0_01 (mix_q_src_c005_0_01 mix_q_c005_0 win_0_01 0) relay vt1=-1m vt2=1m ropen=ropen_mix rclosed=rclosed_mix
EMIXI_c005_0_02 (mix_i_src_c005_0_02 0 bpf_c005_0 0) vcvs gain=5.555702330196e-01
SMIXI_c005_0_02 (mix_i_src_c005_0_02 mix_i_c005_0 win_0_02 0) relay vt1=-1m vt2=1m ropen=ropen_mix rclosed=rclosed_mix
EMIXQ_c005_0_02 (mix_q_src_c005_0_02 0 bpf_c005_0 0) vcvs gain=8.314696123025e-01
SMIXQ_c005_0_02 (mix_q_src_c005_0_02 mix_q_c005_0 win_0_02 0) relay vt1=-1m vt2=1m ropen=ropen_mix rclosed=rclosed_mix
EMIXI_c005_0_03 (mix_i_src_c005_0_03 0 bpf_c005_0 0) vcvs gain=1.950903220161e-01
SMIXI_c005_0_03 (mix_i_src_c005_0_03 mix_i_c005_0 win_0_03 0) relay vt1=-1m vt2=1m ropen=ropen_mix rclosed=rclosed_mix
EMIXQ_c005_0_03 (mix_q_src_c005_0_03 0 bpf_c005_0 0) vcvs gain=9.807852804032e-01
SMIXQ_c005_0_03 (mix_q_src_c005_0_03 mix_q_c005_0 win_0_03 0) relay vt1=-1m vt2=1m ropen=ropen_mix rclosed=rclosed_mix
EMIXI_c005_0_04 (mix_i_src_c005_0_04 0 bpf_c005_0 0) vcvs gain=-1.950903220161e-01
SMIXI_c005_0_04 (mix_i_src_c005_0_04 mix_i_c005_0 win_0_04 0) relay vt1=-1m vt2=1m ropen=ropen_mix rclosed=rclosed_mix
EMIXQ_c005_0_04 (mix_q_src_c005_0_04 0 bpf_c005_0 0) vcvs gain=9.807852804032e-01
SMIXQ_c005_0_04 (mix_q_src_c005_0_04 mix_q_c005_0 win_0_04 0) relay vt1=-1m vt2=1m ropen=ropen_mix rclosed=rclosed_mix
EMIXI_c005_0_05 (mix_i_src_c005_0_05 0 bpf_c005_0 0) vcvs gain=-5.555702330196e-01
SMIXI_c005_0_05 (mix_i_src_c005_0_05 mix_i_c005_0 win_0_05 0) relay vt1=-1m vt2=1m ropen=ropen_mix rclosed=rclosed_mix
EMIXQ_c005_0_05 (mix_q_src_c005_0_05 0 bpf_c005_0 0) vcvs gain=8.314696123025e-01
SMIXQ_c005_0_05 (mix_q_src_c005_0_05 mix_q_c005_0 win_0_05 0) relay vt1=-1m vt2=1m ropen=ropen_mix rclosed=rclosed_mix
EMIXI_c005_0_06 (mix_i_src_c005_0_06 0 bpf_c005_0 0) vcvs gain=-8.314696123025e-01
SMIXI_c005_0_06 (mix_i_src_c005_0_06 mix_i_c005_0 win_0_06 0) relay vt1=-1m vt2=1m ropen=ropen_mix rclosed=rclosed_mix
EMIXQ_c005_0_06 (mix_q_src_c005_0_06 0 bpf_c005_0 0) vcvs gain=5.555702330196e-01
SMIXQ_c005_0_06 (mix_q_src_c005_0_06 mix_q_c005_0 win_0_06 0) relay vt1=-1m vt2=1m ropen=ropen_mix rclosed=rclosed_mix
EMIXI_c005_0_07 (mix_i_src_c005_0_07 0 bpf_c005_0 0) vcvs gain=-9.807852804032e-01
SMIXI_c005_0_07 (mix_i_src_c005_0_07 mix_i_c005_0 win_0_07 0) relay vt1=-1m vt2=1m ropen=ropen_mix rclosed=rclosed_mix
EMIXQ_c005_0_07 (mix_q_src_c005_0_07 0 bpf_c005_0 0) vcvs gain=1.950903220161e-01
SMIXQ_c005_0_07 (mix_q_src_c005_0_07 mix_q_c005_0 win_0_07 0) relay vt1=-1m vt2=1m ropen=ropen_mix rclosed=rclosed_mix
EMIXI_c005_0_08 (mix_i_src_c005_0_08 0 bpf_c005_0 0) vcvs gain=-9.807852804032e-01
SMIXI_c005_0_08 (mix_i_src_c005_0_08 mix_i_c005_0 win_0_08 0) relay vt1=-1m vt2=1m ropen=ropen_mix rclosed=rclosed_mix
EMIXQ_c005_0_08 (mix_q_src_c005_0_08 0 bpf_c005_0 0) vcvs gain=-1.950903220161e-01
SMIXQ_c005_0_08 (mix_q_src_c005_0_08 mix_q_c005_0 win_0_08 0) relay vt1=-1m vt2=1m ropen=ropen_mix rclosed=rclosed_mix
EMIXI_c005_0_09 (mix_i_src_c005_0_09 0 bpf_c005_0 0) vcvs gain=-8.314696123025e-01
SMIXI_c005_0_09 (mix_i_src_c005_0_09 mix_i_c005_0 win_0_09 0) relay vt1=-1m vt2=1m ropen=ropen_mix rclosed=rclosed_mix
EMIXQ_c005_0_09 (mix_q_src_c005_0_09 0 bpf_c005_0 0) vcvs gain=-5.555702330196e-01
SMIXQ_c005_0_09 (mix_q_src_c005_0_09 mix_q_c005_0 win_0_09 0) relay vt1=-1m vt2=1m ropen=ropen_mix rclosed=rclosed_mix
EMIXI_c005_0_10 (mix_i_src_c005_0_10 0 bpf_c005_0 0) vcvs gain=-5.555702330196e-01
SMIXI_c005_0_10 (mix_i_src_c005_0_10 mix_i_c005_0 win_0_10 0) relay vt1=-1m vt2=1m ropen=ropen_mix rclosed=rclosed_mix
EMIXQ_c005_0_10 (mix_q_src_c005_0_10 0 bpf_c005_0 0) vcvs gain=-8.314696123025e-01
SMIXQ_c005_0_10 (mix_q_src_c005_0_10 mix_q_c005_0 win_0_10 0) relay vt1=-1m vt2=1m ropen=ropen_mix rclosed=rclosed_mix
EMIXI_c005_0_11 (mix_i_src_c005_0_11 0 bpf_c005_0 0) vcvs gain=-1.950903220161e-01
SMIXI_c005_0_11 (mix_i_src_c005_0_11 mix_i_c005_0 win_0_11 0) relay vt1=-1m vt2=1m ropen=ropen_mix rclosed=rclosed_mix
EMIXQ_c005_0_11 (mix_q_src_c005_0_11 0 bpf_c005_0 0) vcvs gain=-9.807852804032e-01
SMIXQ_c005_0_11 (mix_q_src_c005_0_11 mix_q_c005_0 win_0_11 0) relay vt1=-1m vt2=1m ropen=ropen_mix rclosed=rclosed_mix
EMIXI_c005_0_12 (mix_i_src_c005_0_12 0 bpf_c005_0 0) vcvs gain=1.950903220161e-01
SMIXI_c005_0_12 (mix_i_src_c005_0_12 mix_i_c005_0 win_0_12 0) relay vt1=-1m vt2=1m ropen=ropen_mix rclosed=rclosed_mix
EMIXQ_c005_0_12 (mix_q_src_c005_0_12 0 bpf_c005_0 0) vcvs gain=-9.807852804032e-01
SMIXQ_c005_0_12 (mix_q_src_c005_0_12 mix_q_c005_0 win_0_12 0) relay vt1=-1m vt2=1m ropen=ropen_mix rclosed=rclosed_mix
EMIXI_c005_0_13 (mix_i_src_c005_0_13 0 bpf_c005_0 0) vcvs gain=5.555702330196e-01
SMIXI_c005_0_13 (mix_i_src_c005_0_13 mix_i_c005_0 win_0_13 0) relay vt1=-1m vt2=1m ropen=ropen_mix rclosed=rclosed_mix
EMIXQ_c005_0_13 (mix_q_src_c005_0_13 0 bpf_c005_0 0) vcvs gain=-8.314696123025e-01
SMIXQ_c005_0_13 (mix_q_src_c005_0_13 mix_q_c005_0 win_0_13 0) relay vt1=-1m vt2=1m ropen=ropen_mix rclosed=rclosed_mix
EMIXI_c005_0_14 (mix_i_src_c005_0_14 0 bpf_c005_0 0) vcvs gain=8.314696123025e-01
SMIXI_c005_0_14 (mix_i_src_c005_0_14 mix_i_c005_0 win_0_14 0) relay vt1=-1m vt2=1m ropen=ropen_mix rclosed=rclosed_mix
EMIXQ_c005_0_14 (mix_q_src_c005_0_14 0 bpf_c005_0 0) vcvs gain=-5.555702330196e-01
SMIXQ_c005_0_14 (mix_q_src_c005_0_14 mix_q_c005_0 win_0_14 0) relay vt1=-1m vt2=1m ropen=ropen_mix rclosed=rclosed_mix
EMIXI_c005_0_15 (mix_i_src_c005_0_15 0 bpf_c005_0 0) vcvs gain=9.807852804032e-01
SMIXI_c005_0_15 (mix_i_src_c005_0_15 mix_i_c005_0 win_0_15 0) relay vt1=-1m vt2=1m ropen=ropen_mix rclosed=rclosed_mix
EMIXQ_c005_0_15 (mix_q_src_c005_0_15 0 bpf_c005_0 0) vcvs gain=-1.950903220161e-01
SMIXQ_c005_0_15 (mix_q_src_c005_0_15 mix_q_c005_0 win_0_15 0) relay vt1=-1m vt2=1m ropen=ropen_mix rclosed=rclosed_mix
RMIXI_c005_0 (mix_i_c005_0 0) resistor r=1G
RMIXQ_c005_0 (mix_q_c005_0 0) resistor r=1G
RINTI_c005_0 (mix_i_c005_0 Icar_c005_0) resistor r=1k
CINTI_c005_0 (Icar_c005_0 0) capacitor c=80p
RINTQ_c005_0 (mix_q_c005_0 Qcar_c005_0) resistor r=1k
CINTQ_c005_0 (Qcar_c005_0 0) capacitor c=80p
save bpf_c005_0 Icar_c005_0 Qcar_c005_0

// bl005, carrier_1: 500000000 Hz coherent I/Q phase-window verification-demod path
CBPF_c005_1 (bl005 n_cbpf_c005_1) capacitor c=1.013211836423e-13
LBPF_c005_1 (n_cbpf_c005_1 bpf_c005_1) inductor l=1.000000000000e-06
RBPF_c005_1 (bpf_c005_1 0) resistor r=1.570796326795e+02
EMIXI_c005_1_00 (mix_i_src_c005_1_00 0 bpf_c005_1 0) vcvs gain=9.807852804032e-01
SMIXI_c005_1_00 (mix_i_src_c005_1_00 mix_i_c005_1 win_1_00 0) relay vt1=-1m vt2=1m ropen=ropen_mix rclosed=rclosed_mix
EMIXQ_c005_1_00 (mix_q_src_c005_1_00 0 bpf_c005_1 0) vcvs gain=1.950903220161e-01
SMIXQ_c005_1_00 (mix_q_src_c005_1_00 mix_q_c005_1 win_1_00 0) relay vt1=-1m vt2=1m ropen=ropen_mix rclosed=rclosed_mix
EMIXI_c005_1_01 (mix_i_src_c005_1_01 0 bpf_c005_1 0) vcvs gain=8.314696123025e-01
SMIXI_c005_1_01 (mix_i_src_c005_1_01 mix_i_c005_1 win_1_01 0) relay vt1=-1m vt2=1m ropen=ropen_mix rclosed=rclosed_mix
EMIXQ_c005_1_01 (mix_q_src_c005_1_01 0 bpf_c005_1 0) vcvs gain=5.555702330196e-01
SMIXQ_c005_1_01 (mix_q_src_c005_1_01 mix_q_c005_1 win_1_01 0) relay vt1=-1m vt2=1m ropen=ropen_mix rclosed=rclosed_mix
EMIXI_c005_1_02 (mix_i_src_c005_1_02 0 bpf_c005_1 0) vcvs gain=5.555702330196e-01
SMIXI_c005_1_02 (mix_i_src_c005_1_02 mix_i_c005_1 win_1_02 0) relay vt1=-1m vt2=1m ropen=ropen_mix rclosed=rclosed_mix
EMIXQ_c005_1_02 (mix_q_src_c005_1_02 0 bpf_c005_1 0) vcvs gain=8.314696123025e-01
SMIXQ_c005_1_02 (mix_q_src_c005_1_02 mix_q_c005_1 win_1_02 0) relay vt1=-1m vt2=1m ropen=ropen_mix rclosed=rclosed_mix
EMIXI_c005_1_03 (mix_i_src_c005_1_03 0 bpf_c005_1 0) vcvs gain=1.950903220161e-01
SMIXI_c005_1_03 (mix_i_src_c005_1_03 mix_i_c005_1 win_1_03 0) relay vt1=-1m vt2=1m ropen=ropen_mix rclosed=rclosed_mix
EMIXQ_c005_1_03 (mix_q_src_c005_1_03 0 bpf_c005_1 0) vcvs gain=9.807852804032e-01
SMIXQ_c005_1_03 (mix_q_src_c005_1_03 mix_q_c005_1 win_1_03 0) relay vt1=-1m vt2=1m ropen=ropen_mix rclosed=rclosed_mix
EMIXI_c005_1_04 (mix_i_src_c005_1_04 0 bpf_c005_1 0) vcvs gain=-1.950903220161e-01
SMIXI_c005_1_04 (mix_i_src_c005_1_04 mix_i_c005_1 win_1_04 0) relay vt1=-1m vt2=1m ropen=ropen_mix rclosed=rclosed_mix
EMIXQ_c005_1_04 (mix_q_src_c005_1_04 0 bpf_c005_1 0) vcvs gain=9.807852804032e-01
SMIXQ_c005_1_04 (mix_q_src_c005_1_04 mix_q_c005_1 win_1_04 0) relay vt1=-1m vt2=1m ropen=ropen_mix rclosed=rclosed_mix
EMIXI_c005_1_05 (mix_i_src_c005_1_05 0 bpf_c005_1 0) vcvs gain=-5.555702330196e-01
SMIXI_c005_1_05 (mix_i_src_c005_1_05 mix_i_c005_1 win_1_05 0) relay vt1=-1m vt2=1m ropen=ropen_mix rclosed=rclosed_mix
EMIXQ_c005_1_05 (mix_q_src_c005_1_05 0 bpf_c005_1 0) vcvs gain=8.314696123025e-01
SMIXQ_c005_1_05 (mix_q_src_c005_1_05 mix_q_c005_1 win_1_05 0) relay vt1=-1m vt2=1m ropen=ropen_mix rclosed=rclosed_mix
EMIXI_c005_1_06 (mix_i_src_c005_1_06 0 bpf_c005_1 0) vcvs gain=-8.314696123025e-01
SMIXI_c005_1_06 (mix_i_src_c005_1_06 mix_i_c005_1 win_1_06 0) relay vt1=-1m vt2=1m ropen=ropen_mix rclosed=rclosed_mix
EMIXQ_c005_1_06 (mix_q_src_c005_1_06 0 bpf_c005_1 0) vcvs gain=5.555702330196e-01
SMIXQ_c005_1_06 (mix_q_src_c005_1_06 mix_q_c005_1 win_1_06 0) relay vt1=-1m vt2=1m ropen=ropen_mix rclosed=rclosed_mix
EMIXI_c005_1_07 (mix_i_src_c005_1_07 0 bpf_c005_1 0) vcvs gain=-9.807852804032e-01
SMIXI_c005_1_07 (mix_i_src_c005_1_07 mix_i_c005_1 win_1_07 0) relay vt1=-1m vt2=1m ropen=ropen_mix rclosed=rclosed_mix
EMIXQ_c005_1_07 (mix_q_src_c005_1_07 0 bpf_c005_1 0) vcvs gain=1.950903220161e-01
SMIXQ_c005_1_07 (mix_q_src_c005_1_07 mix_q_c005_1 win_1_07 0) relay vt1=-1m vt2=1m ropen=ropen_mix rclosed=rclosed_mix
EMIXI_c005_1_08 (mix_i_src_c005_1_08 0 bpf_c005_1 0) vcvs gain=-9.807852804032e-01
SMIXI_c005_1_08 (mix_i_src_c005_1_08 mix_i_c005_1 win_1_08 0) relay vt1=-1m vt2=1m ropen=ropen_mix rclosed=rclosed_mix
EMIXQ_c005_1_08 (mix_q_src_c005_1_08 0 bpf_c005_1 0) vcvs gain=-1.950903220161e-01
SMIXQ_c005_1_08 (mix_q_src_c005_1_08 mix_q_c005_1 win_1_08 0) relay vt1=-1m vt2=1m ropen=ropen_mix rclosed=rclosed_mix
EMIXI_c005_1_09 (mix_i_src_c005_1_09 0 bpf_c005_1 0) vcvs gain=-8.314696123025e-01
SMIXI_c005_1_09 (mix_i_src_c005_1_09 mix_i_c005_1 win_1_09 0) relay vt1=-1m vt2=1m ropen=ropen_mix rclosed=rclosed_mix
EMIXQ_c005_1_09 (mix_q_src_c005_1_09 0 bpf_c005_1 0) vcvs gain=-5.555702330196e-01
SMIXQ_c005_1_09 (mix_q_src_c005_1_09 mix_q_c005_1 win_1_09 0) relay vt1=-1m vt2=1m ropen=ropen_mix rclosed=rclosed_mix
EMIXI_c005_1_10 (mix_i_src_c005_1_10 0 bpf_c005_1 0) vcvs gain=-5.555702330196e-01
SMIXI_c005_1_10 (mix_i_src_c005_1_10 mix_i_c005_1 win_1_10 0) relay vt1=-1m vt2=1m ropen=ropen_mix rclosed=rclosed_mix
EMIXQ_c005_1_10 (mix_q_src_c005_1_10 0 bpf_c005_1 0) vcvs gain=-8.314696123025e-01
SMIXQ_c005_1_10 (mix_q_src_c005_1_10 mix_q_c005_1 win_1_10 0) relay vt1=-1m vt2=1m ropen=ropen_mix rclosed=rclosed_mix
EMIXI_c005_1_11 (mix_i_src_c005_1_11 0 bpf_c005_1 0) vcvs gain=-1.950903220161e-01
SMIXI_c005_1_11 (mix_i_src_c005_1_11 mix_i_c005_1 win_1_11 0) relay vt1=-1m vt2=1m ropen=ropen_mix rclosed=rclosed_mix
EMIXQ_c005_1_11 (mix_q_src_c005_1_11 0 bpf_c005_1 0) vcvs gain=-9.807852804032e-01
SMIXQ_c005_1_11 (mix_q_src_c005_1_11 mix_q_c005_1 win_1_11 0) relay vt1=-1m vt2=1m ropen=ropen_mix rclosed=rclosed_mix
EMIXI_c005_1_12 (mix_i_src_c005_1_12 0 bpf_c005_1 0) vcvs gain=1.950903220161e-01
SMIXI_c005_1_12 (mix_i_src_c005_1_12 mix_i_c005_1 win_1_12 0) relay vt1=-1m vt2=1m ropen=ropen_mix rclosed=rclosed_mix
EMIXQ_c005_1_12 (mix_q_src_c005_1_12 0 bpf_c005_1 0) vcvs gain=-9.807852804032e-01
SMIXQ_c005_1_12 (mix_q_src_c005_1_12 mix_q_c005_1 win_1_12 0) relay vt1=-1m vt2=1m ropen=ropen_mix rclosed=rclosed_mix
EMIXI_c005_1_13 (mix_i_src_c005_1_13 0 bpf_c005_1 0) vcvs gain=5.555702330196e-01
SMIXI_c005_1_13 (mix_i_src_c005_1_13 mix_i_c005_1 win_1_13 0) relay vt1=-1m vt2=1m ropen=ropen_mix rclosed=rclosed_mix
EMIXQ_c005_1_13 (mix_q_src_c005_1_13 0 bpf_c005_1 0) vcvs gain=-8.314696123025e-01
SMIXQ_c005_1_13 (mix_q_src_c005_1_13 mix_q_c005_1 win_1_13 0) relay vt1=-1m vt2=1m ropen=ropen_mix rclosed=rclosed_mix
EMIXI_c005_1_14 (mix_i_src_c005_1_14 0 bpf_c005_1 0) vcvs gain=8.314696123025e-01
SMIXI_c005_1_14 (mix_i_src_c005_1_14 mix_i_c005_1 win_1_14 0) relay vt1=-1m vt2=1m ropen=ropen_mix rclosed=rclosed_mix
EMIXQ_c005_1_14 (mix_q_src_c005_1_14 0 bpf_c005_1 0) vcvs gain=-5.555702330196e-01
SMIXQ_c005_1_14 (mix_q_src_c005_1_14 mix_q_c005_1 win_1_14 0) relay vt1=-1m vt2=1m ropen=ropen_mix rclosed=rclosed_mix
EMIXI_c005_1_15 (mix_i_src_c005_1_15 0 bpf_c005_1 0) vcvs gain=9.807852804032e-01
SMIXI_c005_1_15 (mix_i_src_c005_1_15 mix_i_c005_1 win_1_15 0) relay vt1=-1m vt2=1m ropen=ropen_mix rclosed=rclosed_mix
EMIXQ_c005_1_15 (mix_q_src_c005_1_15 0 bpf_c005_1 0) vcvs gain=-1.950903220161e-01
SMIXQ_c005_1_15 (mix_q_src_c005_1_15 mix_q_c005_1 win_1_15 0) relay vt1=-1m vt2=1m ropen=ropen_mix rclosed=rclosed_mix
RMIXI_c005_1 (mix_i_c005_1 0) resistor r=1G
RMIXQ_c005_1 (mix_q_c005_1 0) resistor r=1G
RINTI_c005_1 (mix_i_c005_1 Icar_c005_1) resistor r=1k
CINTI_c005_1 (Icar_c005_1 0) capacitor c=80p
RINTQ_c005_1 (mix_q_c005_1 Qcar_c005_1) resistor r=1k
CINTQ_c005_1 (Qcar_c005_1 0) capacitor c=80p
save bpf_c005_1 Icar_c005_1 Qcar_c005_1

// bl005, carrier_2: 750000000 Hz coherent I/Q phase-window verification-demod path
CBPF_c005_2 (bl005 n_cbpf_c005_2) capacitor c=4.503163717437e-14
LBPF_c005_2 (n_cbpf_c005_2 bpf_c005_2) inductor l=1.000000000000e-06
RBPF_c005_2 (bpf_c005_2 0) resistor r=2.356194490192e+02
EMIXI_c005_2_00 (mix_i_src_c005_2_00 0 bpf_c005_2 0) vcvs gain=9.807852804032e-01
SMIXI_c005_2_00 (mix_i_src_c005_2_00 mix_i_c005_2 win_2_00 0) relay vt1=-1m vt2=1m ropen=ropen_mix rclosed=rclosed_mix
EMIXQ_c005_2_00 (mix_q_src_c005_2_00 0 bpf_c005_2 0) vcvs gain=1.950903220161e-01
SMIXQ_c005_2_00 (mix_q_src_c005_2_00 mix_q_c005_2 win_2_00 0) relay vt1=-1m vt2=1m ropen=ropen_mix rclosed=rclosed_mix
EMIXI_c005_2_01 (mix_i_src_c005_2_01 0 bpf_c005_2 0) vcvs gain=8.314696123025e-01
SMIXI_c005_2_01 (mix_i_src_c005_2_01 mix_i_c005_2 win_2_01 0) relay vt1=-1m vt2=1m ropen=ropen_mix rclosed=rclosed_mix
EMIXQ_c005_2_01 (mix_q_src_c005_2_01 0 bpf_c005_2 0) vcvs gain=5.555702330196e-01
SMIXQ_c005_2_01 (mix_q_src_c005_2_01 mix_q_c005_2 win_2_01 0) relay vt1=-1m vt2=1m ropen=ropen_mix rclosed=rclosed_mix
EMIXI_c005_2_02 (mix_i_src_c005_2_02 0 bpf_c005_2 0) vcvs gain=5.555702330196e-01
SMIXI_c005_2_02 (mix_i_src_c005_2_02 mix_i_c005_2 win_2_02 0) relay vt1=-1m vt2=1m ropen=ropen_mix rclosed=rclosed_mix
EMIXQ_c005_2_02 (mix_q_src_c005_2_02 0 bpf_c005_2 0) vcvs gain=8.314696123025e-01
SMIXQ_c005_2_02 (mix_q_src_c005_2_02 mix_q_c005_2 win_2_02 0) relay vt1=-1m vt2=1m ropen=ropen_mix rclosed=rclosed_mix
EMIXI_c005_2_03 (mix_i_src_c005_2_03 0 bpf_c005_2 0) vcvs gain=1.950903220161e-01
SMIXI_c005_2_03 (mix_i_src_c005_2_03 mix_i_c005_2 win_2_03 0) relay vt1=-1m vt2=1m ropen=ropen_mix rclosed=rclosed_mix
EMIXQ_c005_2_03 (mix_q_src_c005_2_03 0 bpf_c005_2 0) vcvs gain=9.807852804032e-01
SMIXQ_c005_2_03 (mix_q_src_c005_2_03 mix_q_c005_2 win_2_03 0) relay vt1=-1m vt2=1m ropen=ropen_mix rclosed=rclosed_mix
EMIXI_c005_2_04 (mix_i_src_c005_2_04 0 bpf_c005_2 0) vcvs gain=-1.950903220161e-01
SMIXI_c005_2_04 (mix_i_src_c005_2_04 mix_i_c005_2 win_2_04 0) relay vt1=-1m vt2=1m ropen=ropen_mix rclosed=rclosed_mix
EMIXQ_c005_2_04 (mix_q_src_c005_2_04 0 bpf_c005_2 0) vcvs gain=9.807852804032e-01
SMIXQ_c005_2_04 (mix_q_src_c005_2_04 mix_q_c005_2 win_2_04 0) relay vt1=-1m vt2=1m ropen=ropen_mix rclosed=rclosed_mix
EMIXI_c005_2_05 (mix_i_src_c005_2_05 0 bpf_c005_2 0) vcvs gain=-5.555702330196e-01
SMIXI_c005_2_05 (mix_i_src_c005_2_05 mix_i_c005_2 win_2_05 0) relay vt1=-1m vt2=1m ropen=ropen_mix rclosed=rclosed_mix
EMIXQ_c005_2_05 (mix_q_src_c005_2_05 0 bpf_c005_2 0) vcvs gain=8.314696123025e-01
SMIXQ_c005_2_05 (mix_q_src_c005_2_05 mix_q_c005_2 win_2_05 0) relay vt1=-1m vt2=1m ropen=ropen_mix rclosed=rclosed_mix
EMIXI_c005_2_06 (mix_i_src_c005_2_06 0 bpf_c005_2 0) vcvs gain=-8.314696123025e-01
SMIXI_c005_2_06 (mix_i_src_c005_2_06 mix_i_c005_2 win_2_06 0) relay vt1=-1m vt2=1m ropen=ropen_mix rclosed=rclosed_mix
EMIXQ_c005_2_06 (mix_q_src_c005_2_06 0 bpf_c005_2 0) vcvs gain=5.555702330196e-01
SMIXQ_c005_2_06 (mix_q_src_c005_2_06 mix_q_c005_2 win_2_06 0) relay vt1=-1m vt2=1m ropen=ropen_mix rclosed=rclosed_mix
EMIXI_c005_2_07 (mix_i_src_c005_2_07 0 bpf_c005_2 0) vcvs gain=-9.807852804032e-01
SMIXI_c005_2_07 (mix_i_src_c005_2_07 mix_i_c005_2 win_2_07 0) relay vt1=-1m vt2=1m ropen=ropen_mix rclosed=rclosed_mix
EMIXQ_c005_2_07 (mix_q_src_c005_2_07 0 bpf_c005_2 0) vcvs gain=1.950903220161e-01
SMIXQ_c005_2_07 (mix_q_src_c005_2_07 mix_q_c005_2 win_2_07 0) relay vt1=-1m vt2=1m ropen=ropen_mix rclosed=rclosed_mix
EMIXI_c005_2_08 (mix_i_src_c005_2_08 0 bpf_c005_2 0) vcvs gain=-9.807852804032e-01
SMIXI_c005_2_08 (mix_i_src_c005_2_08 mix_i_c005_2 win_2_08 0) relay vt1=-1m vt2=1m ropen=ropen_mix rclosed=rclosed_mix
EMIXQ_c005_2_08 (mix_q_src_c005_2_08 0 bpf_c005_2 0) vcvs gain=-1.950903220161e-01
SMIXQ_c005_2_08 (mix_q_src_c005_2_08 mix_q_c005_2 win_2_08 0) relay vt1=-1m vt2=1m ropen=ropen_mix rclosed=rclosed_mix
EMIXI_c005_2_09 (mix_i_src_c005_2_09 0 bpf_c005_2 0) vcvs gain=-8.314696123025e-01
SMIXI_c005_2_09 (mix_i_src_c005_2_09 mix_i_c005_2 win_2_09 0) relay vt1=-1m vt2=1m ropen=ropen_mix rclosed=rclosed_mix
EMIXQ_c005_2_09 (mix_q_src_c005_2_09 0 bpf_c005_2 0) vcvs gain=-5.555702330196e-01
SMIXQ_c005_2_09 (mix_q_src_c005_2_09 mix_q_c005_2 win_2_09 0) relay vt1=-1m vt2=1m ropen=ropen_mix rclosed=rclosed_mix
EMIXI_c005_2_10 (mix_i_src_c005_2_10 0 bpf_c005_2 0) vcvs gain=-5.555702330196e-01
SMIXI_c005_2_10 (mix_i_src_c005_2_10 mix_i_c005_2 win_2_10 0) relay vt1=-1m vt2=1m ropen=ropen_mix rclosed=rclosed_mix
EMIXQ_c005_2_10 (mix_q_src_c005_2_10 0 bpf_c005_2 0) vcvs gain=-8.314696123025e-01
SMIXQ_c005_2_10 (mix_q_src_c005_2_10 mix_q_c005_2 win_2_10 0) relay vt1=-1m vt2=1m ropen=ropen_mix rclosed=rclosed_mix
EMIXI_c005_2_11 (mix_i_src_c005_2_11 0 bpf_c005_2 0) vcvs gain=-1.950903220161e-01
SMIXI_c005_2_11 (mix_i_src_c005_2_11 mix_i_c005_2 win_2_11 0) relay vt1=-1m vt2=1m ropen=ropen_mix rclosed=rclosed_mix
EMIXQ_c005_2_11 (mix_q_src_c005_2_11 0 bpf_c005_2 0) vcvs gain=-9.807852804032e-01
SMIXQ_c005_2_11 (mix_q_src_c005_2_11 mix_q_c005_2 win_2_11 0) relay vt1=-1m vt2=1m ropen=ropen_mix rclosed=rclosed_mix
EMIXI_c005_2_12 (mix_i_src_c005_2_12 0 bpf_c005_2 0) vcvs gain=1.950903220161e-01
SMIXI_c005_2_12 (mix_i_src_c005_2_12 mix_i_c005_2 win_2_12 0) relay vt1=-1m vt2=1m ropen=ropen_mix rclosed=rclosed_mix
EMIXQ_c005_2_12 (mix_q_src_c005_2_12 0 bpf_c005_2 0) vcvs gain=-9.807852804032e-01
SMIXQ_c005_2_12 (mix_q_src_c005_2_12 mix_q_c005_2 win_2_12 0) relay vt1=-1m vt2=1m ropen=ropen_mix rclosed=rclosed_mix
EMIXI_c005_2_13 (mix_i_src_c005_2_13 0 bpf_c005_2 0) vcvs gain=5.555702330196e-01
SMIXI_c005_2_13 (mix_i_src_c005_2_13 mix_i_c005_2 win_2_13 0) relay vt1=-1m vt2=1m ropen=ropen_mix rclosed=rclosed_mix
EMIXQ_c005_2_13 (mix_q_src_c005_2_13 0 bpf_c005_2 0) vcvs gain=-8.314696123025e-01
SMIXQ_c005_2_13 (mix_q_src_c005_2_13 mix_q_c005_2 win_2_13 0) relay vt1=-1m vt2=1m ropen=ropen_mix rclosed=rclosed_mix
EMIXI_c005_2_14 (mix_i_src_c005_2_14 0 bpf_c005_2 0) vcvs gain=8.314696123025e-01
SMIXI_c005_2_14 (mix_i_src_c005_2_14 mix_i_c005_2 win_2_14 0) relay vt1=-1m vt2=1m ropen=ropen_mix rclosed=rclosed_mix
EMIXQ_c005_2_14 (mix_q_src_c005_2_14 0 bpf_c005_2 0) vcvs gain=-5.555702330196e-01
SMIXQ_c005_2_14 (mix_q_src_c005_2_14 mix_q_c005_2 win_2_14 0) relay vt1=-1m vt2=1m ropen=ropen_mix rclosed=rclosed_mix
EMIXI_c005_2_15 (mix_i_src_c005_2_15 0 bpf_c005_2 0) vcvs gain=9.807852804032e-01
SMIXI_c005_2_15 (mix_i_src_c005_2_15 mix_i_c005_2 win_2_15 0) relay vt1=-1m vt2=1m ropen=ropen_mix rclosed=rclosed_mix
EMIXQ_c005_2_15 (mix_q_src_c005_2_15 0 bpf_c005_2 0) vcvs gain=-1.950903220161e-01
SMIXQ_c005_2_15 (mix_q_src_c005_2_15 mix_q_c005_2 win_2_15 0) relay vt1=-1m vt2=1m ropen=ropen_mix rclosed=rclosed_mix
RMIXI_c005_2 (mix_i_c005_2 0) resistor r=1G
RMIXQ_c005_2 (mix_q_c005_2 0) resistor r=1G
RINTI_c005_2 (mix_i_c005_2 Icar_c005_2) resistor r=1k
CINTI_c005_2 (Icar_c005_2 0) capacitor c=80p
RINTQ_c005_2 (mix_q_c005_2 Qcar_c005_2) resistor r=1k
CINTQ_c005_2 (Qcar_c005_2 0) capacitor c=80p
save bpf_c005_2 Icar_c005_2 Qcar_c005_2

// bl005, carrier_3: 1000000000 Hz coherent I/Q phase-window verification-demod path
CBPF_c005_3 (bl005 n_cbpf_c005_3) capacitor c=2.533029591058e-14
LBPF_c005_3 (n_cbpf_c005_3 bpf_c005_3) inductor l=1.000000000000e-06
RBPF_c005_3 (bpf_c005_3 0) resistor r=3.141592653590e+02
EMIXI_c005_3_00 (mix_i_src_c005_3_00 0 bpf_c005_3 0) vcvs gain=9.807852804032e-01
SMIXI_c005_3_00 (mix_i_src_c005_3_00 mix_i_c005_3 win_3_00 0) relay vt1=-1m vt2=1m ropen=ropen_mix rclosed=rclosed_mix
EMIXQ_c005_3_00 (mix_q_src_c005_3_00 0 bpf_c005_3 0) vcvs gain=1.950903220161e-01
SMIXQ_c005_3_00 (mix_q_src_c005_3_00 mix_q_c005_3 win_3_00 0) relay vt1=-1m vt2=1m ropen=ropen_mix rclosed=rclosed_mix
EMIXI_c005_3_01 (mix_i_src_c005_3_01 0 bpf_c005_3 0) vcvs gain=8.314696123025e-01
SMIXI_c005_3_01 (mix_i_src_c005_3_01 mix_i_c005_3 win_3_01 0) relay vt1=-1m vt2=1m ropen=ropen_mix rclosed=rclosed_mix
EMIXQ_c005_3_01 (mix_q_src_c005_3_01 0 bpf_c005_3 0) vcvs gain=5.555702330196e-01
SMIXQ_c005_3_01 (mix_q_src_c005_3_01 mix_q_c005_3 win_3_01 0) relay vt1=-1m vt2=1m ropen=ropen_mix rclosed=rclosed_mix
EMIXI_c005_3_02 (mix_i_src_c005_3_02 0 bpf_c005_3 0) vcvs gain=5.555702330196e-01
SMIXI_c005_3_02 (mix_i_src_c005_3_02 mix_i_c005_3 win_3_02 0) relay vt1=-1m vt2=1m ropen=ropen_mix rclosed=rclosed_mix
EMIXQ_c005_3_02 (mix_q_src_c005_3_02 0 bpf_c005_3 0) vcvs gain=8.314696123025e-01
SMIXQ_c005_3_02 (mix_q_src_c005_3_02 mix_q_c005_3 win_3_02 0) relay vt1=-1m vt2=1m ropen=ropen_mix rclosed=rclosed_mix
EMIXI_c005_3_03 (mix_i_src_c005_3_03 0 bpf_c005_3 0) vcvs gain=1.950903220161e-01
SMIXI_c005_3_03 (mix_i_src_c005_3_03 mix_i_c005_3 win_3_03 0) relay vt1=-1m vt2=1m ropen=ropen_mix rclosed=rclosed_mix
EMIXQ_c005_3_03 (mix_q_src_c005_3_03 0 bpf_c005_3 0) vcvs gain=9.807852804032e-01
SMIXQ_c005_3_03 (mix_q_src_c005_3_03 mix_q_c005_3 win_3_03 0) relay vt1=-1m vt2=1m ropen=ropen_mix rclosed=rclosed_mix
EMIXI_c005_3_04 (mix_i_src_c005_3_04 0 bpf_c005_3 0) vcvs gain=-1.950903220161e-01
SMIXI_c005_3_04 (mix_i_src_c005_3_04 mix_i_c005_3 win_3_04 0) relay vt1=-1m vt2=1m ropen=ropen_mix rclosed=rclosed_mix
EMIXQ_c005_3_04 (mix_q_src_c005_3_04 0 bpf_c005_3 0) vcvs gain=9.807852804032e-01
SMIXQ_c005_3_04 (mix_q_src_c005_3_04 mix_q_c005_3 win_3_04 0) relay vt1=-1m vt2=1m ropen=ropen_mix rclosed=rclosed_mix
EMIXI_c005_3_05 (mix_i_src_c005_3_05 0 bpf_c005_3 0) vcvs gain=-5.555702330196e-01
SMIXI_c005_3_05 (mix_i_src_c005_3_05 mix_i_c005_3 win_3_05 0) relay vt1=-1m vt2=1m ropen=ropen_mix rclosed=rclosed_mix
EMIXQ_c005_3_05 (mix_q_src_c005_3_05 0 bpf_c005_3 0) vcvs gain=8.314696123025e-01
SMIXQ_c005_3_05 (mix_q_src_c005_3_05 mix_q_c005_3 win_3_05 0) relay vt1=-1m vt2=1m ropen=ropen_mix rclosed=rclosed_mix
EMIXI_c005_3_06 (mix_i_src_c005_3_06 0 bpf_c005_3 0) vcvs gain=-8.314696123025e-01
SMIXI_c005_3_06 (mix_i_src_c005_3_06 mix_i_c005_3 win_3_06 0) relay vt1=-1m vt2=1m ropen=ropen_mix rclosed=rclosed_mix
EMIXQ_c005_3_06 (mix_q_src_c005_3_06 0 bpf_c005_3 0) vcvs gain=5.555702330196e-01
SMIXQ_c005_3_06 (mix_q_src_c005_3_06 mix_q_c005_3 win_3_06 0) relay vt1=-1m vt2=1m ropen=ropen_mix rclosed=rclosed_mix
EMIXI_c005_3_07 (mix_i_src_c005_3_07 0 bpf_c005_3 0) vcvs gain=-9.807852804032e-01
SMIXI_c005_3_07 (mix_i_src_c005_3_07 mix_i_c005_3 win_3_07 0) relay vt1=-1m vt2=1m ropen=ropen_mix rclosed=rclosed_mix
EMIXQ_c005_3_07 (mix_q_src_c005_3_07 0 bpf_c005_3 0) vcvs gain=1.950903220161e-01
SMIXQ_c005_3_07 (mix_q_src_c005_3_07 mix_q_c005_3 win_3_07 0) relay vt1=-1m vt2=1m ropen=ropen_mix rclosed=rclosed_mix
EMIXI_c005_3_08 (mix_i_src_c005_3_08 0 bpf_c005_3 0) vcvs gain=-9.807852804032e-01
SMIXI_c005_3_08 (mix_i_src_c005_3_08 mix_i_c005_3 win_3_08 0) relay vt1=-1m vt2=1m ropen=ropen_mix rclosed=rclosed_mix
EMIXQ_c005_3_08 (mix_q_src_c005_3_08 0 bpf_c005_3 0) vcvs gain=-1.950903220161e-01
SMIXQ_c005_3_08 (mix_q_src_c005_3_08 mix_q_c005_3 win_3_08 0) relay vt1=-1m vt2=1m ropen=ropen_mix rclosed=rclosed_mix
EMIXI_c005_3_09 (mix_i_src_c005_3_09 0 bpf_c005_3 0) vcvs gain=-8.314696123025e-01
SMIXI_c005_3_09 (mix_i_src_c005_3_09 mix_i_c005_3 win_3_09 0) relay vt1=-1m vt2=1m ropen=ropen_mix rclosed=rclosed_mix
EMIXQ_c005_3_09 (mix_q_src_c005_3_09 0 bpf_c005_3 0) vcvs gain=-5.555702330196e-01
SMIXQ_c005_3_09 (mix_q_src_c005_3_09 mix_q_c005_3 win_3_09 0) relay vt1=-1m vt2=1m ropen=ropen_mix rclosed=rclosed_mix
EMIXI_c005_3_10 (mix_i_src_c005_3_10 0 bpf_c005_3 0) vcvs gain=-5.555702330196e-01
SMIXI_c005_3_10 (mix_i_src_c005_3_10 mix_i_c005_3 win_3_10 0) relay vt1=-1m vt2=1m ropen=ropen_mix rclosed=rclosed_mix
EMIXQ_c005_3_10 (mix_q_src_c005_3_10 0 bpf_c005_3 0) vcvs gain=-8.314696123025e-01
SMIXQ_c005_3_10 (mix_q_src_c005_3_10 mix_q_c005_3 win_3_10 0) relay vt1=-1m vt2=1m ropen=ropen_mix rclosed=rclosed_mix
EMIXI_c005_3_11 (mix_i_src_c005_3_11 0 bpf_c005_3 0) vcvs gain=-1.950903220161e-01
SMIXI_c005_3_11 (mix_i_src_c005_3_11 mix_i_c005_3 win_3_11 0) relay vt1=-1m vt2=1m ropen=ropen_mix rclosed=rclosed_mix
EMIXQ_c005_3_11 (mix_q_src_c005_3_11 0 bpf_c005_3 0) vcvs gain=-9.807852804032e-01
SMIXQ_c005_3_11 (mix_q_src_c005_3_11 mix_q_c005_3 win_3_11 0) relay vt1=-1m vt2=1m ropen=ropen_mix rclosed=rclosed_mix
EMIXI_c005_3_12 (mix_i_src_c005_3_12 0 bpf_c005_3 0) vcvs gain=1.950903220161e-01
SMIXI_c005_3_12 (mix_i_src_c005_3_12 mix_i_c005_3 win_3_12 0) relay vt1=-1m vt2=1m ropen=ropen_mix rclosed=rclosed_mix
EMIXQ_c005_3_12 (mix_q_src_c005_3_12 0 bpf_c005_3 0) vcvs gain=-9.807852804032e-01
SMIXQ_c005_3_12 (mix_q_src_c005_3_12 mix_q_c005_3 win_3_12 0) relay vt1=-1m vt2=1m ropen=ropen_mix rclosed=rclosed_mix
EMIXI_c005_3_13 (mix_i_src_c005_3_13 0 bpf_c005_3 0) vcvs gain=5.555702330196e-01
SMIXI_c005_3_13 (mix_i_src_c005_3_13 mix_i_c005_3 win_3_13 0) relay vt1=-1m vt2=1m ropen=ropen_mix rclosed=rclosed_mix
EMIXQ_c005_3_13 (mix_q_src_c005_3_13 0 bpf_c005_3 0) vcvs gain=-8.314696123025e-01
SMIXQ_c005_3_13 (mix_q_src_c005_3_13 mix_q_c005_3 win_3_13 0) relay vt1=-1m vt2=1m ropen=ropen_mix rclosed=rclosed_mix
EMIXI_c005_3_14 (mix_i_src_c005_3_14 0 bpf_c005_3 0) vcvs gain=8.314696123025e-01
SMIXI_c005_3_14 (mix_i_src_c005_3_14 mix_i_c005_3 win_3_14 0) relay vt1=-1m vt2=1m ropen=ropen_mix rclosed=rclosed_mix
EMIXQ_c005_3_14 (mix_q_src_c005_3_14 0 bpf_c005_3 0) vcvs gain=-5.555702330196e-01
SMIXQ_c005_3_14 (mix_q_src_c005_3_14 mix_q_c005_3 win_3_14 0) relay vt1=-1m vt2=1m ropen=ropen_mix rclosed=rclosed_mix
EMIXI_c005_3_15 (mix_i_src_c005_3_15 0 bpf_c005_3 0) vcvs gain=9.807852804032e-01
SMIXI_c005_3_15 (mix_i_src_c005_3_15 mix_i_c005_3 win_3_15 0) relay vt1=-1m vt2=1m ropen=ropen_mix rclosed=rclosed_mix
EMIXQ_c005_3_15 (mix_q_src_c005_3_15 0 bpf_c005_3 0) vcvs gain=-1.950903220161e-01
SMIXQ_c005_3_15 (mix_q_src_c005_3_15 mix_q_c005_3 win_3_15 0) relay vt1=-1m vt2=1m ropen=ropen_mix rclosed=rclosed_mix
RMIXI_c005_3 (mix_i_c005_3 0) resistor r=1G
RMIXQ_c005_3 (mix_q_c005_3 0) resistor r=1G
RINTI_c005_3 (mix_i_c005_3 Icar_c005_3) resistor r=1k
CINTI_c005_3 (Icar_c005_3 0) capacitor c=80p
RINTQ_c005_3 (mix_q_c005_3 Qcar_c005_3) resistor r=1k
CINTQ_c005_3 (Qcar_c005_3 0) capacitor c=80p
save bpf_c005_3 Icar_c005_3 Qcar_c005_3

// bl006, carrier_0: 250000000 Hz coherent I/Q phase-window verification-demod path
CBPF_c006_0 (bl006 n_cbpf_c006_0) capacitor c=4.052847345694e-13
LBPF_c006_0 (n_cbpf_c006_0 bpf_c006_0) inductor l=1.000000000000e-06
RBPF_c006_0 (bpf_c006_0 0) resistor r=7.853981633974e+01
EMIXI_c006_0_00 (mix_i_src_c006_0_00 0 bpf_c006_0 0) vcvs gain=9.807852804032e-01
SMIXI_c006_0_00 (mix_i_src_c006_0_00 mix_i_c006_0 win_0_00 0) relay vt1=-1m vt2=1m ropen=ropen_mix rclosed=rclosed_mix
EMIXQ_c006_0_00 (mix_q_src_c006_0_00 0 bpf_c006_0 0) vcvs gain=1.950903220161e-01
SMIXQ_c006_0_00 (mix_q_src_c006_0_00 mix_q_c006_0 win_0_00 0) relay vt1=-1m vt2=1m ropen=ropen_mix rclosed=rclosed_mix
EMIXI_c006_0_01 (mix_i_src_c006_0_01 0 bpf_c006_0 0) vcvs gain=8.314696123025e-01
SMIXI_c006_0_01 (mix_i_src_c006_0_01 mix_i_c006_0 win_0_01 0) relay vt1=-1m vt2=1m ropen=ropen_mix rclosed=rclosed_mix
EMIXQ_c006_0_01 (mix_q_src_c006_0_01 0 bpf_c006_0 0) vcvs gain=5.555702330196e-01
SMIXQ_c006_0_01 (mix_q_src_c006_0_01 mix_q_c006_0 win_0_01 0) relay vt1=-1m vt2=1m ropen=ropen_mix rclosed=rclosed_mix
EMIXI_c006_0_02 (mix_i_src_c006_0_02 0 bpf_c006_0 0) vcvs gain=5.555702330196e-01
SMIXI_c006_0_02 (mix_i_src_c006_0_02 mix_i_c006_0 win_0_02 0) relay vt1=-1m vt2=1m ropen=ropen_mix rclosed=rclosed_mix
EMIXQ_c006_0_02 (mix_q_src_c006_0_02 0 bpf_c006_0 0) vcvs gain=8.314696123025e-01
SMIXQ_c006_0_02 (mix_q_src_c006_0_02 mix_q_c006_0 win_0_02 0) relay vt1=-1m vt2=1m ropen=ropen_mix rclosed=rclosed_mix
EMIXI_c006_0_03 (mix_i_src_c006_0_03 0 bpf_c006_0 0) vcvs gain=1.950903220161e-01
SMIXI_c006_0_03 (mix_i_src_c006_0_03 mix_i_c006_0 win_0_03 0) relay vt1=-1m vt2=1m ropen=ropen_mix rclosed=rclosed_mix
EMIXQ_c006_0_03 (mix_q_src_c006_0_03 0 bpf_c006_0 0) vcvs gain=9.807852804032e-01
SMIXQ_c006_0_03 (mix_q_src_c006_0_03 mix_q_c006_0 win_0_03 0) relay vt1=-1m vt2=1m ropen=ropen_mix rclosed=rclosed_mix
EMIXI_c006_0_04 (mix_i_src_c006_0_04 0 bpf_c006_0 0) vcvs gain=-1.950903220161e-01
SMIXI_c006_0_04 (mix_i_src_c006_0_04 mix_i_c006_0 win_0_04 0) relay vt1=-1m vt2=1m ropen=ropen_mix rclosed=rclosed_mix
EMIXQ_c006_0_04 (mix_q_src_c006_0_04 0 bpf_c006_0 0) vcvs gain=9.807852804032e-01
SMIXQ_c006_0_04 (mix_q_src_c006_0_04 mix_q_c006_0 win_0_04 0) relay vt1=-1m vt2=1m ropen=ropen_mix rclosed=rclosed_mix
EMIXI_c006_0_05 (mix_i_src_c006_0_05 0 bpf_c006_0 0) vcvs gain=-5.555702330196e-01
SMIXI_c006_0_05 (mix_i_src_c006_0_05 mix_i_c006_0 win_0_05 0) relay vt1=-1m vt2=1m ropen=ropen_mix rclosed=rclosed_mix
EMIXQ_c006_0_05 (mix_q_src_c006_0_05 0 bpf_c006_0 0) vcvs gain=8.314696123025e-01
SMIXQ_c006_0_05 (mix_q_src_c006_0_05 mix_q_c006_0 win_0_05 0) relay vt1=-1m vt2=1m ropen=ropen_mix rclosed=rclosed_mix
EMIXI_c006_0_06 (mix_i_src_c006_0_06 0 bpf_c006_0 0) vcvs gain=-8.314696123025e-01
SMIXI_c006_0_06 (mix_i_src_c006_0_06 mix_i_c006_0 win_0_06 0) relay vt1=-1m vt2=1m ropen=ropen_mix rclosed=rclosed_mix
EMIXQ_c006_0_06 (mix_q_src_c006_0_06 0 bpf_c006_0 0) vcvs gain=5.555702330196e-01
SMIXQ_c006_0_06 (mix_q_src_c006_0_06 mix_q_c006_0 win_0_06 0) relay vt1=-1m vt2=1m ropen=ropen_mix rclosed=rclosed_mix
EMIXI_c006_0_07 (mix_i_src_c006_0_07 0 bpf_c006_0 0) vcvs gain=-9.807852804032e-01
SMIXI_c006_0_07 (mix_i_src_c006_0_07 mix_i_c006_0 win_0_07 0) relay vt1=-1m vt2=1m ropen=ropen_mix rclosed=rclosed_mix
EMIXQ_c006_0_07 (mix_q_src_c006_0_07 0 bpf_c006_0 0) vcvs gain=1.950903220161e-01
SMIXQ_c006_0_07 (mix_q_src_c006_0_07 mix_q_c006_0 win_0_07 0) relay vt1=-1m vt2=1m ropen=ropen_mix rclosed=rclosed_mix
EMIXI_c006_0_08 (mix_i_src_c006_0_08 0 bpf_c006_0 0) vcvs gain=-9.807852804032e-01
SMIXI_c006_0_08 (mix_i_src_c006_0_08 mix_i_c006_0 win_0_08 0) relay vt1=-1m vt2=1m ropen=ropen_mix rclosed=rclosed_mix
EMIXQ_c006_0_08 (mix_q_src_c006_0_08 0 bpf_c006_0 0) vcvs gain=-1.950903220161e-01
SMIXQ_c006_0_08 (mix_q_src_c006_0_08 mix_q_c006_0 win_0_08 0) relay vt1=-1m vt2=1m ropen=ropen_mix rclosed=rclosed_mix
EMIXI_c006_0_09 (mix_i_src_c006_0_09 0 bpf_c006_0 0) vcvs gain=-8.314696123025e-01
SMIXI_c006_0_09 (mix_i_src_c006_0_09 mix_i_c006_0 win_0_09 0) relay vt1=-1m vt2=1m ropen=ropen_mix rclosed=rclosed_mix
EMIXQ_c006_0_09 (mix_q_src_c006_0_09 0 bpf_c006_0 0) vcvs gain=-5.555702330196e-01
SMIXQ_c006_0_09 (mix_q_src_c006_0_09 mix_q_c006_0 win_0_09 0) relay vt1=-1m vt2=1m ropen=ropen_mix rclosed=rclosed_mix
EMIXI_c006_0_10 (mix_i_src_c006_0_10 0 bpf_c006_0 0) vcvs gain=-5.555702330196e-01
SMIXI_c006_0_10 (mix_i_src_c006_0_10 mix_i_c006_0 win_0_10 0) relay vt1=-1m vt2=1m ropen=ropen_mix rclosed=rclosed_mix
EMIXQ_c006_0_10 (mix_q_src_c006_0_10 0 bpf_c006_0 0) vcvs gain=-8.314696123025e-01
SMIXQ_c006_0_10 (mix_q_src_c006_0_10 mix_q_c006_0 win_0_10 0) relay vt1=-1m vt2=1m ropen=ropen_mix rclosed=rclosed_mix
EMIXI_c006_0_11 (mix_i_src_c006_0_11 0 bpf_c006_0 0) vcvs gain=-1.950903220161e-01
SMIXI_c006_0_11 (mix_i_src_c006_0_11 mix_i_c006_0 win_0_11 0) relay vt1=-1m vt2=1m ropen=ropen_mix rclosed=rclosed_mix
EMIXQ_c006_0_11 (mix_q_src_c006_0_11 0 bpf_c006_0 0) vcvs gain=-9.807852804032e-01
SMIXQ_c006_0_11 (mix_q_src_c006_0_11 mix_q_c006_0 win_0_11 0) relay vt1=-1m vt2=1m ropen=ropen_mix rclosed=rclosed_mix
EMIXI_c006_0_12 (mix_i_src_c006_0_12 0 bpf_c006_0 0) vcvs gain=1.950903220161e-01
SMIXI_c006_0_12 (mix_i_src_c006_0_12 mix_i_c006_0 win_0_12 0) relay vt1=-1m vt2=1m ropen=ropen_mix rclosed=rclosed_mix
EMIXQ_c006_0_12 (mix_q_src_c006_0_12 0 bpf_c006_0 0) vcvs gain=-9.807852804032e-01
SMIXQ_c006_0_12 (mix_q_src_c006_0_12 mix_q_c006_0 win_0_12 0) relay vt1=-1m vt2=1m ropen=ropen_mix rclosed=rclosed_mix
EMIXI_c006_0_13 (mix_i_src_c006_0_13 0 bpf_c006_0 0) vcvs gain=5.555702330196e-01
SMIXI_c006_0_13 (mix_i_src_c006_0_13 mix_i_c006_0 win_0_13 0) relay vt1=-1m vt2=1m ropen=ropen_mix rclosed=rclosed_mix
EMIXQ_c006_0_13 (mix_q_src_c006_0_13 0 bpf_c006_0 0) vcvs gain=-8.314696123025e-01
SMIXQ_c006_0_13 (mix_q_src_c006_0_13 mix_q_c006_0 win_0_13 0) relay vt1=-1m vt2=1m ropen=ropen_mix rclosed=rclosed_mix
EMIXI_c006_0_14 (mix_i_src_c006_0_14 0 bpf_c006_0 0) vcvs gain=8.314696123025e-01
SMIXI_c006_0_14 (mix_i_src_c006_0_14 mix_i_c006_0 win_0_14 0) relay vt1=-1m vt2=1m ropen=ropen_mix rclosed=rclosed_mix
EMIXQ_c006_0_14 (mix_q_src_c006_0_14 0 bpf_c006_0 0) vcvs gain=-5.555702330196e-01
SMIXQ_c006_0_14 (mix_q_src_c006_0_14 mix_q_c006_0 win_0_14 0) relay vt1=-1m vt2=1m ropen=ropen_mix rclosed=rclosed_mix
EMIXI_c006_0_15 (mix_i_src_c006_0_15 0 bpf_c006_0 0) vcvs gain=9.807852804032e-01
SMIXI_c006_0_15 (mix_i_src_c006_0_15 mix_i_c006_0 win_0_15 0) relay vt1=-1m vt2=1m ropen=ropen_mix rclosed=rclosed_mix
EMIXQ_c006_0_15 (mix_q_src_c006_0_15 0 bpf_c006_0 0) vcvs gain=-1.950903220161e-01
SMIXQ_c006_0_15 (mix_q_src_c006_0_15 mix_q_c006_0 win_0_15 0) relay vt1=-1m vt2=1m ropen=ropen_mix rclosed=rclosed_mix
RMIXI_c006_0 (mix_i_c006_0 0) resistor r=1G
RMIXQ_c006_0 (mix_q_c006_0 0) resistor r=1G
RINTI_c006_0 (mix_i_c006_0 Icar_c006_0) resistor r=1k
CINTI_c006_0 (Icar_c006_0 0) capacitor c=80p
RINTQ_c006_0 (mix_q_c006_0 Qcar_c006_0) resistor r=1k
CINTQ_c006_0 (Qcar_c006_0 0) capacitor c=80p
save bpf_c006_0 Icar_c006_0 Qcar_c006_0

// bl006, carrier_1: 500000000 Hz coherent I/Q phase-window verification-demod path
CBPF_c006_1 (bl006 n_cbpf_c006_1) capacitor c=1.013211836423e-13
LBPF_c006_1 (n_cbpf_c006_1 bpf_c006_1) inductor l=1.000000000000e-06
RBPF_c006_1 (bpf_c006_1 0) resistor r=1.570796326795e+02
EMIXI_c006_1_00 (mix_i_src_c006_1_00 0 bpf_c006_1 0) vcvs gain=9.807852804032e-01
SMIXI_c006_1_00 (mix_i_src_c006_1_00 mix_i_c006_1 win_1_00 0) relay vt1=-1m vt2=1m ropen=ropen_mix rclosed=rclosed_mix
EMIXQ_c006_1_00 (mix_q_src_c006_1_00 0 bpf_c006_1 0) vcvs gain=1.950903220161e-01
SMIXQ_c006_1_00 (mix_q_src_c006_1_00 mix_q_c006_1 win_1_00 0) relay vt1=-1m vt2=1m ropen=ropen_mix rclosed=rclosed_mix
EMIXI_c006_1_01 (mix_i_src_c006_1_01 0 bpf_c006_1 0) vcvs gain=8.314696123025e-01
SMIXI_c006_1_01 (mix_i_src_c006_1_01 mix_i_c006_1 win_1_01 0) relay vt1=-1m vt2=1m ropen=ropen_mix rclosed=rclosed_mix
EMIXQ_c006_1_01 (mix_q_src_c006_1_01 0 bpf_c006_1 0) vcvs gain=5.555702330196e-01
SMIXQ_c006_1_01 (mix_q_src_c006_1_01 mix_q_c006_1 win_1_01 0) relay vt1=-1m vt2=1m ropen=ropen_mix rclosed=rclosed_mix
EMIXI_c006_1_02 (mix_i_src_c006_1_02 0 bpf_c006_1 0) vcvs gain=5.555702330196e-01
SMIXI_c006_1_02 (mix_i_src_c006_1_02 mix_i_c006_1 win_1_02 0) relay vt1=-1m vt2=1m ropen=ropen_mix rclosed=rclosed_mix
EMIXQ_c006_1_02 (mix_q_src_c006_1_02 0 bpf_c006_1 0) vcvs gain=8.314696123025e-01
SMIXQ_c006_1_02 (mix_q_src_c006_1_02 mix_q_c006_1 win_1_02 0) relay vt1=-1m vt2=1m ropen=ropen_mix rclosed=rclosed_mix
EMIXI_c006_1_03 (mix_i_src_c006_1_03 0 bpf_c006_1 0) vcvs gain=1.950903220161e-01
SMIXI_c006_1_03 (mix_i_src_c006_1_03 mix_i_c006_1 win_1_03 0) relay vt1=-1m vt2=1m ropen=ropen_mix rclosed=rclosed_mix
EMIXQ_c006_1_03 (mix_q_src_c006_1_03 0 bpf_c006_1 0) vcvs gain=9.807852804032e-01
SMIXQ_c006_1_03 (mix_q_src_c006_1_03 mix_q_c006_1 win_1_03 0) relay vt1=-1m vt2=1m ropen=ropen_mix rclosed=rclosed_mix
EMIXI_c006_1_04 (mix_i_src_c006_1_04 0 bpf_c006_1 0) vcvs gain=-1.950903220161e-01
SMIXI_c006_1_04 (mix_i_src_c006_1_04 mix_i_c006_1 win_1_04 0) relay vt1=-1m vt2=1m ropen=ropen_mix rclosed=rclosed_mix
EMIXQ_c006_1_04 (mix_q_src_c006_1_04 0 bpf_c006_1 0) vcvs gain=9.807852804032e-01
SMIXQ_c006_1_04 (mix_q_src_c006_1_04 mix_q_c006_1 win_1_04 0) relay vt1=-1m vt2=1m ropen=ropen_mix rclosed=rclosed_mix
EMIXI_c006_1_05 (mix_i_src_c006_1_05 0 bpf_c006_1 0) vcvs gain=-5.555702330196e-01
SMIXI_c006_1_05 (mix_i_src_c006_1_05 mix_i_c006_1 win_1_05 0) relay vt1=-1m vt2=1m ropen=ropen_mix rclosed=rclosed_mix
EMIXQ_c006_1_05 (mix_q_src_c006_1_05 0 bpf_c006_1 0) vcvs gain=8.314696123025e-01
SMIXQ_c006_1_05 (mix_q_src_c006_1_05 mix_q_c006_1 win_1_05 0) relay vt1=-1m vt2=1m ropen=ropen_mix rclosed=rclosed_mix
EMIXI_c006_1_06 (mix_i_src_c006_1_06 0 bpf_c006_1 0) vcvs gain=-8.314696123025e-01
SMIXI_c006_1_06 (mix_i_src_c006_1_06 mix_i_c006_1 win_1_06 0) relay vt1=-1m vt2=1m ropen=ropen_mix rclosed=rclosed_mix
EMIXQ_c006_1_06 (mix_q_src_c006_1_06 0 bpf_c006_1 0) vcvs gain=5.555702330196e-01
SMIXQ_c006_1_06 (mix_q_src_c006_1_06 mix_q_c006_1 win_1_06 0) relay vt1=-1m vt2=1m ropen=ropen_mix rclosed=rclosed_mix
EMIXI_c006_1_07 (mix_i_src_c006_1_07 0 bpf_c006_1 0) vcvs gain=-9.807852804032e-01
SMIXI_c006_1_07 (mix_i_src_c006_1_07 mix_i_c006_1 win_1_07 0) relay vt1=-1m vt2=1m ropen=ropen_mix rclosed=rclosed_mix
EMIXQ_c006_1_07 (mix_q_src_c006_1_07 0 bpf_c006_1 0) vcvs gain=1.950903220161e-01
SMIXQ_c006_1_07 (mix_q_src_c006_1_07 mix_q_c006_1 win_1_07 0) relay vt1=-1m vt2=1m ropen=ropen_mix rclosed=rclosed_mix
EMIXI_c006_1_08 (mix_i_src_c006_1_08 0 bpf_c006_1 0) vcvs gain=-9.807852804032e-01
SMIXI_c006_1_08 (mix_i_src_c006_1_08 mix_i_c006_1 win_1_08 0) relay vt1=-1m vt2=1m ropen=ropen_mix rclosed=rclosed_mix
EMIXQ_c006_1_08 (mix_q_src_c006_1_08 0 bpf_c006_1 0) vcvs gain=-1.950903220161e-01
SMIXQ_c006_1_08 (mix_q_src_c006_1_08 mix_q_c006_1 win_1_08 0) relay vt1=-1m vt2=1m ropen=ropen_mix rclosed=rclosed_mix
EMIXI_c006_1_09 (mix_i_src_c006_1_09 0 bpf_c006_1 0) vcvs gain=-8.314696123025e-01
SMIXI_c006_1_09 (mix_i_src_c006_1_09 mix_i_c006_1 win_1_09 0) relay vt1=-1m vt2=1m ropen=ropen_mix rclosed=rclosed_mix
EMIXQ_c006_1_09 (mix_q_src_c006_1_09 0 bpf_c006_1 0) vcvs gain=-5.555702330196e-01
SMIXQ_c006_1_09 (mix_q_src_c006_1_09 mix_q_c006_1 win_1_09 0) relay vt1=-1m vt2=1m ropen=ropen_mix rclosed=rclosed_mix
EMIXI_c006_1_10 (mix_i_src_c006_1_10 0 bpf_c006_1 0) vcvs gain=-5.555702330196e-01
SMIXI_c006_1_10 (mix_i_src_c006_1_10 mix_i_c006_1 win_1_10 0) relay vt1=-1m vt2=1m ropen=ropen_mix rclosed=rclosed_mix
EMIXQ_c006_1_10 (mix_q_src_c006_1_10 0 bpf_c006_1 0) vcvs gain=-8.314696123025e-01
SMIXQ_c006_1_10 (mix_q_src_c006_1_10 mix_q_c006_1 win_1_10 0) relay vt1=-1m vt2=1m ropen=ropen_mix rclosed=rclosed_mix
EMIXI_c006_1_11 (mix_i_src_c006_1_11 0 bpf_c006_1 0) vcvs gain=-1.950903220161e-01
SMIXI_c006_1_11 (mix_i_src_c006_1_11 mix_i_c006_1 win_1_11 0) relay vt1=-1m vt2=1m ropen=ropen_mix rclosed=rclosed_mix
EMIXQ_c006_1_11 (mix_q_src_c006_1_11 0 bpf_c006_1 0) vcvs gain=-9.807852804032e-01
SMIXQ_c006_1_11 (mix_q_src_c006_1_11 mix_q_c006_1 win_1_11 0) relay vt1=-1m vt2=1m ropen=ropen_mix rclosed=rclosed_mix
EMIXI_c006_1_12 (mix_i_src_c006_1_12 0 bpf_c006_1 0) vcvs gain=1.950903220161e-01
SMIXI_c006_1_12 (mix_i_src_c006_1_12 mix_i_c006_1 win_1_12 0) relay vt1=-1m vt2=1m ropen=ropen_mix rclosed=rclosed_mix
EMIXQ_c006_1_12 (mix_q_src_c006_1_12 0 bpf_c006_1 0) vcvs gain=-9.807852804032e-01
SMIXQ_c006_1_12 (mix_q_src_c006_1_12 mix_q_c006_1 win_1_12 0) relay vt1=-1m vt2=1m ropen=ropen_mix rclosed=rclosed_mix
EMIXI_c006_1_13 (mix_i_src_c006_1_13 0 bpf_c006_1 0) vcvs gain=5.555702330196e-01
SMIXI_c006_1_13 (mix_i_src_c006_1_13 mix_i_c006_1 win_1_13 0) relay vt1=-1m vt2=1m ropen=ropen_mix rclosed=rclosed_mix
EMIXQ_c006_1_13 (mix_q_src_c006_1_13 0 bpf_c006_1 0) vcvs gain=-8.314696123025e-01
SMIXQ_c006_1_13 (mix_q_src_c006_1_13 mix_q_c006_1 win_1_13 0) relay vt1=-1m vt2=1m ropen=ropen_mix rclosed=rclosed_mix
EMIXI_c006_1_14 (mix_i_src_c006_1_14 0 bpf_c006_1 0) vcvs gain=8.314696123025e-01
SMIXI_c006_1_14 (mix_i_src_c006_1_14 mix_i_c006_1 win_1_14 0) relay vt1=-1m vt2=1m ropen=ropen_mix rclosed=rclosed_mix
EMIXQ_c006_1_14 (mix_q_src_c006_1_14 0 bpf_c006_1 0) vcvs gain=-5.555702330196e-01
SMIXQ_c006_1_14 (mix_q_src_c006_1_14 mix_q_c006_1 win_1_14 0) relay vt1=-1m vt2=1m ropen=ropen_mix rclosed=rclosed_mix
EMIXI_c006_1_15 (mix_i_src_c006_1_15 0 bpf_c006_1 0) vcvs gain=9.807852804032e-01
SMIXI_c006_1_15 (mix_i_src_c006_1_15 mix_i_c006_1 win_1_15 0) relay vt1=-1m vt2=1m ropen=ropen_mix rclosed=rclosed_mix
EMIXQ_c006_1_15 (mix_q_src_c006_1_15 0 bpf_c006_1 0) vcvs gain=-1.950903220161e-01
SMIXQ_c006_1_15 (mix_q_src_c006_1_15 mix_q_c006_1 win_1_15 0) relay vt1=-1m vt2=1m ropen=ropen_mix rclosed=rclosed_mix
RMIXI_c006_1 (mix_i_c006_1 0) resistor r=1G
RMIXQ_c006_1 (mix_q_c006_1 0) resistor r=1G
RINTI_c006_1 (mix_i_c006_1 Icar_c006_1) resistor r=1k
CINTI_c006_1 (Icar_c006_1 0) capacitor c=80p
RINTQ_c006_1 (mix_q_c006_1 Qcar_c006_1) resistor r=1k
CINTQ_c006_1 (Qcar_c006_1 0) capacitor c=80p
save bpf_c006_1 Icar_c006_1 Qcar_c006_1

// bl006, carrier_2: 750000000 Hz coherent I/Q phase-window verification-demod path
CBPF_c006_2 (bl006 n_cbpf_c006_2) capacitor c=4.503163717437e-14
LBPF_c006_2 (n_cbpf_c006_2 bpf_c006_2) inductor l=1.000000000000e-06
RBPF_c006_2 (bpf_c006_2 0) resistor r=2.356194490192e+02
EMIXI_c006_2_00 (mix_i_src_c006_2_00 0 bpf_c006_2 0) vcvs gain=9.807852804032e-01
SMIXI_c006_2_00 (mix_i_src_c006_2_00 mix_i_c006_2 win_2_00 0) relay vt1=-1m vt2=1m ropen=ropen_mix rclosed=rclosed_mix
EMIXQ_c006_2_00 (mix_q_src_c006_2_00 0 bpf_c006_2 0) vcvs gain=1.950903220161e-01
SMIXQ_c006_2_00 (mix_q_src_c006_2_00 mix_q_c006_2 win_2_00 0) relay vt1=-1m vt2=1m ropen=ropen_mix rclosed=rclosed_mix
EMIXI_c006_2_01 (mix_i_src_c006_2_01 0 bpf_c006_2 0) vcvs gain=8.314696123025e-01
SMIXI_c006_2_01 (mix_i_src_c006_2_01 mix_i_c006_2 win_2_01 0) relay vt1=-1m vt2=1m ropen=ropen_mix rclosed=rclosed_mix
EMIXQ_c006_2_01 (mix_q_src_c006_2_01 0 bpf_c006_2 0) vcvs gain=5.555702330196e-01
SMIXQ_c006_2_01 (mix_q_src_c006_2_01 mix_q_c006_2 win_2_01 0) relay vt1=-1m vt2=1m ropen=ropen_mix rclosed=rclosed_mix
EMIXI_c006_2_02 (mix_i_src_c006_2_02 0 bpf_c006_2 0) vcvs gain=5.555702330196e-01
SMIXI_c006_2_02 (mix_i_src_c006_2_02 mix_i_c006_2 win_2_02 0) relay vt1=-1m vt2=1m ropen=ropen_mix rclosed=rclosed_mix
EMIXQ_c006_2_02 (mix_q_src_c006_2_02 0 bpf_c006_2 0) vcvs gain=8.314696123025e-01
SMIXQ_c006_2_02 (mix_q_src_c006_2_02 mix_q_c006_2 win_2_02 0) relay vt1=-1m vt2=1m ropen=ropen_mix rclosed=rclosed_mix
EMIXI_c006_2_03 (mix_i_src_c006_2_03 0 bpf_c006_2 0) vcvs gain=1.950903220161e-01
SMIXI_c006_2_03 (mix_i_src_c006_2_03 mix_i_c006_2 win_2_03 0) relay vt1=-1m vt2=1m ropen=ropen_mix rclosed=rclosed_mix
EMIXQ_c006_2_03 (mix_q_src_c006_2_03 0 bpf_c006_2 0) vcvs gain=9.807852804032e-01
SMIXQ_c006_2_03 (mix_q_src_c006_2_03 mix_q_c006_2 win_2_03 0) relay vt1=-1m vt2=1m ropen=ropen_mix rclosed=rclosed_mix
EMIXI_c006_2_04 (mix_i_src_c006_2_04 0 bpf_c006_2 0) vcvs gain=-1.950903220161e-01
SMIXI_c006_2_04 (mix_i_src_c006_2_04 mix_i_c006_2 win_2_04 0) relay vt1=-1m vt2=1m ropen=ropen_mix rclosed=rclosed_mix
EMIXQ_c006_2_04 (mix_q_src_c006_2_04 0 bpf_c006_2 0) vcvs gain=9.807852804032e-01
SMIXQ_c006_2_04 (mix_q_src_c006_2_04 mix_q_c006_2 win_2_04 0) relay vt1=-1m vt2=1m ropen=ropen_mix rclosed=rclosed_mix
EMIXI_c006_2_05 (mix_i_src_c006_2_05 0 bpf_c006_2 0) vcvs gain=-5.555702330196e-01
SMIXI_c006_2_05 (mix_i_src_c006_2_05 mix_i_c006_2 win_2_05 0) relay vt1=-1m vt2=1m ropen=ropen_mix rclosed=rclosed_mix
EMIXQ_c006_2_05 (mix_q_src_c006_2_05 0 bpf_c006_2 0) vcvs gain=8.314696123025e-01
SMIXQ_c006_2_05 (mix_q_src_c006_2_05 mix_q_c006_2 win_2_05 0) relay vt1=-1m vt2=1m ropen=ropen_mix rclosed=rclosed_mix
EMIXI_c006_2_06 (mix_i_src_c006_2_06 0 bpf_c006_2 0) vcvs gain=-8.314696123025e-01
SMIXI_c006_2_06 (mix_i_src_c006_2_06 mix_i_c006_2 win_2_06 0) relay vt1=-1m vt2=1m ropen=ropen_mix rclosed=rclosed_mix
EMIXQ_c006_2_06 (mix_q_src_c006_2_06 0 bpf_c006_2 0) vcvs gain=5.555702330196e-01
SMIXQ_c006_2_06 (mix_q_src_c006_2_06 mix_q_c006_2 win_2_06 0) relay vt1=-1m vt2=1m ropen=ropen_mix rclosed=rclosed_mix
EMIXI_c006_2_07 (mix_i_src_c006_2_07 0 bpf_c006_2 0) vcvs gain=-9.807852804032e-01
SMIXI_c006_2_07 (mix_i_src_c006_2_07 mix_i_c006_2 win_2_07 0) relay vt1=-1m vt2=1m ropen=ropen_mix rclosed=rclosed_mix
EMIXQ_c006_2_07 (mix_q_src_c006_2_07 0 bpf_c006_2 0) vcvs gain=1.950903220161e-01
SMIXQ_c006_2_07 (mix_q_src_c006_2_07 mix_q_c006_2 win_2_07 0) relay vt1=-1m vt2=1m ropen=ropen_mix rclosed=rclosed_mix
EMIXI_c006_2_08 (mix_i_src_c006_2_08 0 bpf_c006_2 0) vcvs gain=-9.807852804032e-01
SMIXI_c006_2_08 (mix_i_src_c006_2_08 mix_i_c006_2 win_2_08 0) relay vt1=-1m vt2=1m ropen=ropen_mix rclosed=rclosed_mix
EMIXQ_c006_2_08 (mix_q_src_c006_2_08 0 bpf_c006_2 0) vcvs gain=-1.950903220161e-01
SMIXQ_c006_2_08 (mix_q_src_c006_2_08 mix_q_c006_2 win_2_08 0) relay vt1=-1m vt2=1m ropen=ropen_mix rclosed=rclosed_mix
EMIXI_c006_2_09 (mix_i_src_c006_2_09 0 bpf_c006_2 0) vcvs gain=-8.314696123025e-01
SMIXI_c006_2_09 (mix_i_src_c006_2_09 mix_i_c006_2 win_2_09 0) relay vt1=-1m vt2=1m ropen=ropen_mix rclosed=rclosed_mix
EMIXQ_c006_2_09 (mix_q_src_c006_2_09 0 bpf_c006_2 0) vcvs gain=-5.555702330196e-01
SMIXQ_c006_2_09 (mix_q_src_c006_2_09 mix_q_c006_2 win_2_09 0) relay vt1=-1m vt2=1m ropen=ropen_mix rclosed=rclosed_mix
EMIXI_c006_2_10 (mix_i_src_c006_2_10 0 bpf_c006_2 0) vcvs gain=-5.555702330196e-01
SMIXI_c006_2_10 (mix_i_src_c006_2_10 mix_i_c006_2 win_2_10 0) relay vt1=-1m vt2=1m ropen=ropen_mix rclosed=rclosed_mix
EMIXQ_c006_2_10 (mix_q_src_c006_2_10 0 bpf_c006_2 0) vcvs gain=-8.314696123025e-01
SMIXQ_c006_2_10 (mix_q_src_c006_2_10 mix_q_c006_2 win_2_10 0) relay vt1=-1m vt2=1m ropen=ropen_mix rclosed=rclosed_mix
EMIXI_c006_2_11 (mix_i_src_c006_2_11 0 bpf_c006_2 0) vcvs gain=-1.950903220161e-01
SMIXI_c006_2_11 (mix_i_src_c006_2_11 mix_i_c006_2 win_2_11 0) relay vt1=-1m vt2=1m ropen=ropen_mix rclosed=rclosed_mix
EMIXQ_c006_2_11 (mix_q_src_c006_2_11 0 bpf_c006_2 0) vcvs gain=-9.807852804032e-01
SMIXQ_c006_2_11 (mix_q_src_c006_2_11 mix_q_c006_2 win_2_11 0) relay vt1=-1m vt2=1m ropen=ropen_mix rclosed=rclosed_mix
EMIXI_c006_2_12 (mix_i_src_c006_2_12 0 bpf_c006_2 0) vcvs gain=1.950903220161e-01
SMIXI_c006_2_12 (mix_i_src_c006_2_12 mix_i_c006_2 win_2_12 0) relay vt1=-1m vt2=1m ropen=ropen_mix rclosed=rclosed_mix
EMIXQ_c006_2_12 (mix_q_src_c006_2_12 0 bpf_c006_2 0) vcvs gain=-9.807852804032e-01
SMIXQ_c006_2_12 (mix_q_src_c006_2_12 mix_q_c006_2 win_2_12 0) relay vt1=-1m vt2=1m ropen=ropen_mix rclosed=rclosed_mix
EMIXI_c006_2_13 (mix_i_src_c006_2_13 0 bpf_c006_2 0) vcvs gain=5.555702330196e-01
SMIXI_c006_2_13 (mix_i_src_c006_2_13 mix_i_c006_2 win_2_13 0) relay vt1=-1m vt2=1m ropen=ropen_mix rclosed=rclosed_mix
EMIXQ_c006_2_13 (mix_q_src_c006_2_13 0 bpf_c006_2 0) vcvs gain=-8.314696123025e-01
SMIXQ_c006_2_13 (mix_q_src_c006_2_13 mix_q_c006_2 win_2_13 0) relay vt1=-1m vt2=1m ropen=ropen_mix rclosed=rclosed_mix
EMIXI_c006_2_14 (mix_i_src_c006_2_14 0 bpf_c006_2 0) vcvs gain=8.314696123025e-01
SMIXI_c006_2_14 (mix_i_src_c006_2_14 mix_i_c006_2 win_2_14 0) relay vt1=-1m vt2=1m ropen=ropen_mix rclosed=rclosed_mix
EMIXQ_c006_2_14 (mix_q_src_c006_2_14 0 bpf_c006_2 0) vcvs gain=-5.555702330196e-01
SMIXQ_c006_2_14 (mix_q_src_c006_2_14 mix_q_c006_2 win_2_14 0) relay vt1=-1m vt2=1m ropen=ropen_mix rclosed=rclosed_mix
EMIXI_c006_2_15 (mix_i_src_c006_2_15 0 bpf_c006_2 0) vcvs gain=9.807852804032e-01
SMIXI_c006_2_15 (mix_i_src_c006_2_15 mix_i_c006_2 win_2_15 0) relay vt1=-1m vt2=1m ropen=ropen_mix rclosed=rclosed_mix
EMIXQ_c006_2_15 (mix_q_src_c006_2_15 0 bpf_c006_2 0) vcvs gain=-1.950903220161e-01
SMIXQ_c006_2_15 (mix_q_src_c006_2_15 mix_q_c006_2 win_2_15 0) relay vt1=-1m vt2=1m ropen=ropen_mix rclosed=rclosed_mix
RMIXI_c006_2 (mix_i_c006_2 0) resistor r=1G
RMIXQ_c006_2 (mix_q_c006_2 0) resistor r=1G
RINTI_c006_2 (mix_i_c006_2 Icar_c006_2) resistor r=1k
CINTI_c006_2 (Icar_c006_2 0) capacitor c=80p
RINTQ_c006_2 (mix_q_c006_2 Qcar_c006_2) resistor r=1k
CINTQ_c006_2 (Qcar_c006_2 0) capacitor c=80p
save bpf_c006_2 Icar_c006_2 Qcar_c006_2

// bl006, carrier_3: 1000000000 Hz coherent I/Q phase-window verification-demod path
CBPF_c006_3 (bl006 n_cbpf_c006_3) capacitor c=2.533029591058e-14
LBPF_c006_3 (n_cbpf_c006_3 bpf_c006_3) inductor l=1.000000000000e-06
RBPF_c006_3 (bpf_c006_3 0) resistor r=3.141592653590e+02
EMIXI_c006_3_00 (mix_i_src_c006_3_00 0 bpf_c006_3 0) vcvs gain=9.807852804032e-01
SMIXI_c006_3_00 (mix_i_src_c006_3_00 mix_i_c006_3 win_3_00 0) relay vt1=-1m vt2=1m ropen=ropen_mix rclosed=rclosed_mix
EMIXQ_c006_3_00 (mix_q_src_c006_3_00 0 bpf_c006_3 0) vcvs gain=1.950903220161e-01
SMIXQ_c006_3_00 (mix_q_src_c006_3_00 mix_q_c006_3 win_3_00 0) relay vt1=-1m vt2=1m ropen=ropen_mix rclosed=rclosed_mix
EMIXI_c006_3_01 (mix_i_src_c006_3_01 0 bpf_c006_3 0) vcvs gain=8.314696123025e-01
SMIXI_c006_3_01 (mix_i_src_c006_3_01 mix_i_c006_3 win_3_01 0) relay vt1=-1m vt2=1m ropen=ropen_mix rclosed=rclosed_mix
EMIXQ_c006_3_01 (mix_q_src_c006_3_01 0 bpf_c006_3 0) vcvs gain=5.555702330196e-01
SMIXQ_c006_3_01 (mix_q_src_c006_3_01 mix_q_c006_3 win_3_01 0) relay vt1=-1m vt2=1m ropen=ropen_mix rclosed=rclosed_mix
EMIXI_c006_3_02 (mix_i_src_c006_3_02 0 bpf_c006_3 0) vcvs gain=5.555702330196e-01
SMIXI_c006_3_02 (mix_i_src_c006_3_02 mix_i_c006_3 win_3_02 0) relay vt1=-1m vt2=1m ropen=ropen_mix rclosed=rclosed_mix
EMIXQ_c006_3_02 (mix_q_src_c006_3_02 0 bpf_c006_3 0) vcvs gain=8.314696123025e-01
SMIXQ_c006_3_02 (mix_q_src_c006_3_02 mix_q_c006_3 win_3_02 0) relay vt1=-1m vt2=1m ropen=ropen_mix rclosed=rclosed_mix
EMIXI_c006_3_03 (mix_i_src_c006_3_03 0 bpf_c006_3 0) vcvs gain=1.950903220161e-01
SMIXI_c006_3_03 (mix_i_src_c006_3_03 mix_i_c006_3 win_3_03 0) relay vt1=-1m vt2=1m ropen=ropen_mix rclosed=rclosed_mix
EMIXQ_c006_3_03 (mix_q_src_c006_3_03 0 bpf_c006_3 0) vcvs gain=9.807852804032e-01
SMIXQ_c006_3_03 (mix_q_src_c006_3_03 mix_q_c006_3 win_3_03 0) relay vt1=-1m vt2=1m ropen=ropen_mix rclosed=rclosed_mix
EMIXI_c006_3_04 (mix_i_src_c006_3_04 0 bpf_c006_3 0) vcvs gain=-1.950903220161e-01
SMIXI_c006_3_04 (mix_i_src_c006_3_04 mix_i_c006_3 win_3_04 0) relay vt1=-1m vt2=1m ropen=ropen_mix rclosed=rclosed_mix
EMIXQ_c006_3_04 (mix_q_src_c006_3_04 0 bpf_c006_3 0) vcvs gain=9.807852804032e-01
SMIXQ_c006_3_04 (mix_q_src_c006_3_04 mix_q_c006_3 win_3_04 0) relay vt1=-1m vt2=1m ropen=ropen_mix rclosed=rclosed_mix
EMIXI_c006_3_05 (mix_i_src_c006_3_05 0 bpf_c006_3 0) vcvs gain=-5.555702330196e-01
SMIXI_c006_3_05 (mix_i_src_c006_3_05 mix_i_c006_3 win_3_05 0) relay vt1=-1m vt2=1m ropen=ropen_mix rclosed=rclosed_mix
EMIXQ_c006_3_05 (mix_q_src_c006_3_05 0 bpf_c006_3 0) vcvs gain=8.314696123025e-01
SMIXQ_c006_3_05 (mix_q_src_c006_3_05 mix_q_c006_3 win_3_05 0) relay vt1=-1m vt2=1m ropen=ropen_mix rclosed=rclosed_mix
EMIXI_c006_3_06 (mix_i_src_c006_3_06 0 bpf_c006_3 0) vcvs gain=-8.314696123025e-01
SMIXI_c006_3_06 (mix_i_src_c006_3_06 mix_i_c006_3 win_3_06 0) relay vt1=-1m vt2=1m ropen=ropen_mix rclosed=rclosed_mix
EMIXQ_c006_3_06 (mix_q_src_c006_3_06 0 bpf_c006_3 0) vcvs gain=5.555702330196e-01
SMIXQ_c006_3_06 (mix_q_src_c006_3_06 mix_q_c006_3 win_3_06 0) relay vt1=-1m vt2=1m ropen=ropen_mix rclosed=rclosed_mix
EMIXI_c006_3_07 (mix_i_src_c006_3_07 0 bpf_c006_3 0) vcvs gain=-9.807852804032e-01
SMIXI_c006_3_07 (mix_i_src_c006_3_07 mix_i_c006_3 win_3_07 0) relay vt1=-1m vt2=1m ropen=ropen_mix rclosed=rclosed_mix
EMIXQ_c006_3_07 (mix_q_src_c006_3_07 0 bpf_c006_3 0) vcvs gain=1.950903220161e-01
SMIXQ_c006_3_07 (mix_q_src_c006_3_07 mix_q_c006_3 win_3_07 0) relay vt1=-1m vt2=1m ropen=ropen_mix rclosed=rclosed_mix
EMIXI_c006_3_08 (mix_i_src_c006_3_08 0 bpf_c006_3 0) vcvs gain=-9.807852804032e-01
SMIXI_c006_3_08 (mix_i_src_c006_3_08 mix_i_c006_3 win_3_08 0) relay vt1=-1m vt2=1m ropen=ropen_mix rclosed=rclosed_mix
EMIXQ_c006_3_08 (mix_q_src_c006_3_08 0 bpf_c006_3 0) vcvs gain=-1.950903220161e-01
SMIXQ_c006_3_08 (mix_q_src_c006_3_08 mix_q_c006_3 win_3_08 0) relay vt1=-1m vt2=1m ropen=ropen_mix rclosed=rclosed_mix
EMIXI_c006_3_09 (mix_i_src_c006_3_09 0 bpf_c006_3 0) vcvs gain=-8.314696123025e-01
SMIXI_c006_3_09 (mix_i_src_c006_3_09 mix_i_c006_3 win_3_09 0) relay vt1=-1m vt2=1m ropen=ropen_mix rclosed=rclosed_mix
EMIXQ_c006_3_09 (mix_q_src_c006_3_09 0 bpf_c006_3 0) vcvs gain=-5.555702330196e-01
SMIXQ_c006_3_09 (mix_q_src_c006_3_09 mix_q_c006_3 win_3_09 0) relay vt1=-1m vt2=1m ropen=ropen_mix rclosed=rclosed_mix
EMIXI_c006_3_10 (mix_i_src_c006_3_10 0 bpf_c006_3 0) vcvs gain=-5.555702330196e-01
SMIXI_c006_3_10 (mix_i_src_c006_3_10 mix_i_c006_3 win_3_10 0) relay vt1=-1m vt2=1m ropen=ropen_mix rclosed=rclosed_mix
EMIXQ_c006_3_10 (mix_q_src_c006_3_10 0 bpf_c006_3 0) vcvs gain=-8.314696123025e-01
SMIXQ_c006_3_10 (mix_q_src_c006_3_10 mix_q_c006_3 win_3_10 0) relay vt1=-1m vt2=1m ropen=ropen_mix rclosed=rclosed_mix
EMIXI_c006_3_11 (mix_i_src_c006_3_11 0 bpf_c006_3 0) vcvs gain=-1.950903220161e-01
SMIXI_c006_3_11 (mix_i_src_c006_3_11 mix_i_c006_3 win_3_11 0) relay vt1=-1m vt2=1m ropen=ropen_mix rclosed=rclosed_mix
EMIXQ_c006_3_11 (mix_q_src_c006_3_11 0 bpf_c006_3 0) vcvs gain=-9.807852804032e-01
SMIXQ_c006_3_11 (mix_q_src_c006_3_11 mix_q_c006_3 win_3_11 0) relay vt1=-1m vt2=1m ropen=ropen_mix rclosed=rclosed_mix
EMIXI_c006_3_12 (mix_i_src_c006_3_12 0 bpf_c006_3 0) vcvs gain=1.950903220161e-01
SMIXI_c006_3_12 (mix_i_src_c006_3_12 mix_i_c006_3 win_3_12 0) relay vt1=-1m vt2=1m ropen=ropen_mix rclosed=rclosed_mix
EMIXQ_c006_3_12 (mix_q_src_c006_3_12 0 bpf_c006_3 0) vcvs gain=-9.807852804032e-01
SMIXQ_c006_3_12 (mix_q_src_c006_3_12 mix_q_c006_3 win_3_12 0) relay vt1=-1m vt2=1m ropen=ropen_mix rclosed=rclosed_mix
EMIXI_c006_3_13 (mix_i_src_c006_3_13 0 bpf_c006_3 0) vcvs gain=5.555702330196e-01
SMIXI_c006_3_13 (mix_i_src_c006_3_13 mix_i_c006_3 win_3_13 0) relay vt1=-1m vt2=1m ropen=ropen_mix rclosed=rclosed_mix
EMIXQ_c006_3_13 (mix_q_src_c006_3_13 0 bpf_c006_3 0) vcvs gain=-8.314696123025e-01
SMIXQ_c006_3_13 (mix_q_src_c006_3_13 mix_q_c006_3 win_3_13 0) relay vt1=-1m vt2=1m ropen=ropen_mix rclosed=rclosed_mix
EMIXI_c006_3_14 (mix_i_src_c006_3_14 0 bpf_c006_3 0) vcvs gain=8.314696123025e-01
SMIXI_c006_3_14 (mix_i_src_c006_3_14 mix_i_c006_3 win_3_14 0) relay vt1=-1m vt2=1m ropen=ropen_mix rclosed=rclosed_mix
EMIXQ_c006_3_14 (mix_q_src_c006_3_14 0 bpf_c006_3 0) vcvs gain=-5.555702330196e-01
SMIXQ_c006_3_14 (mix_q_src_c006_3_14 mix_q_c006_3 win_3_14 0) relay vt1=-1m vt2=1m ropen=ropen_mix rclosed=rclosed_mix
EMIXI_c006_3_15 (mix_i_src_c006_3_15 0 bpf_c006_3 0) vcvs gain=9.807852804032e-01
SMIXI_c006_3_15 (mix_i_src_c006_3_15 mix_i_c006_3 win_3_15 0) relay vt1=-1m vt2=1m ropen=ropen_mix rclosed=rclosed_mix
EMIXQ_c006_3_15 (mix_q_src_c006_3_15 0 bpf_c006_3 0) vcvs gain=-1.950903220161e-01
SMIXQ_c006_3_15 (mix_q_src_c006_3_15 mix_q_c006_3 win_3_15 0) relay vt1=-1m vt2=1m ropen=ropen_mix rclosed=rclosed_mix
RMIXI_c006_3 (mix_i_c006_3 0) resistor r=1G
RMIXQ_c006_3 (mix_q_c006_3 0) resistor r=1G
RINTI_c006_3 (mix_i_c006_3 Icar_c006_3) resistor r=1k
CINTI_c006_3 (Icar_c006_3 0) capacitor c=80p
RINTQ_c006_3 (mix_q_c006_3 Qcar_c006_3) resistor r=1k
CINTQ_c006_3 (Qcar_c006_3 0) capacitor c=80p
save bpf_c006_3 Icar_c006_3 Qcar_c006_3

// bl007, carrier_0: 250000000 Hz coherent I/Q phase-window verification-demod path
CBPF_c007_0 (bl007 n_cbpf_c007_0) capacitor c=4.052847345694e-13
LBPF_c007_0 (n_cbpf_c007_0 bpf_c007_0) inductor l=1.000000000000e-06
RBPF_c007_0 (bpf_c007_0 0) resistor r=7.853981633974e+01
EMIXI_c007_0_00 (mix_i_src_c007_0_00 0 bpf_c007_0 0) vcvs gain=9.807852804032e-01
SMIXI_c007_0_00 (mix_i_src_c007_0_00 mix_i_c007_0 win_0_00 0) relay vt1=-1m vt2=1m ropen=ropen_mix rclosed=rclosed_mix
EMIXQ_c007_0_00 (mix_q_src_c007_0_00 0 bpf_c007_0 0) vcvs gain=1.950903220161e-01
SMIXQ_c007_0_00 (mix_q_src_c007_0_00 mix_q_c007_0 win_0_00 0) relay vt1=-1m vt2=1m ropen=ropen_mix rclosed=rclosed_mix
EMIXI_c007_0_01 (mix_i_src_c007_0_01 0 bpf_c007_0 0) vcvs gain=8.314696123025e-01
SMIXI_c007_0_01 (mix_i_src_c007_0_01 mix_i_c007_0 win_0_01 0) relay vt1=-1m vt2=1m ropen=ropen_mix rclosed=rclosed_mix
EMIXQ_c007_0_01 (mix_q_src_c007_0_01 0 bpf_c007_0 0) vcvs gain=5.555702330196e-01
SMIXQ_c007_0_01 (mix_q_src_c007_0_01 mix_q_c007_0 win_0_01 0) relay vt1=-1m vt2=1m ropen=ropen_mix rclosed=rclosed_mix
EMIXI_c007_0_02 (mix_i_src_c007_0_02 0 bpf_c007_0 0) vcvs gain=5.555702330196e-01
SMIXI_c007_0_02 (mix_i_src_c007_0_02 mix_i_c007_0 win_0_02 0) relay vt1=-1m vt2=1m ropen=ropen_mix rclosed=rclosed_mix
EMIXQ_c007_0_02 (mix_q_src_c007_0_02 0 bpf_c007_0 0) vcvs gain=8.314696123025e-01
SMIXQ_c007_0_02 (mix_q_src_c007_0_02 mix_q_c007_0 win_0_02 0) relay vt1=-1m vt2=1m ropen=ropen_mix rclosed=rclosed_mix
EMIXI_c007_0_03 (mix_i_src_c007_0_03 0 bpf_c007_0 0) vcvs gain=1.950903220161e-01
SMIXI_c007_0_03 (mix_i_src_c007_0_03 mix_i_c007_0 win_0_03 0) relay vt1=-1m vt2=1m ropen=ropen_mix rclosed=rclosed_mix
EMIXQ_c007_0_03 (mix_q_src_c007_0_03 0 bpf_c007_0 0) vcvs gain=9.807852804032e-01
SMIXQ_c007_0_03 (mix_q_src_c007_0_03 mix_q_c007_0 win_0_03 0) relay vt1=-1m vt2=1m ropen=ropen_mix rclosed=rclosed_mix
EMIXI_c007_0_04 (mix_i_src_c007_0_04 0 bpf_c007_0 0) vcvs gain=-1.950903220161e-01
SMIXI_c007_0_04 (mix_i_src_c007_0_04 mix_i_c007_0 win_0_04 0) relay vt1=-1m vt2=1m ropen=ropen_mix rclosed=rclosed_mix
EMIXQ_c007_0_04 (mix_q_src_c007_0_04 0 bpf_c007_0 0) vcvs gain=9.807852804032e-01
SMIXQ_c007_0_04 (mix_q_src_c007_0_04 mix_q_c007_0 win_0_04 0) relay vt1=-1m vt2=1m ropen=ropen_mix rclosed=rclosed_mix
EMIXI_c007_0_05 (mix_i_src_c007_0_05 0 bpf_c007_0 0) vcvs gain=-5.555702330196e-01
SMIXI_c007_0_05 (mix_i_src_c007_0_05 mix_i_c007_0 win_0_05 0) relay vt1=-1m vt2=1m ropen=ropen_mix rclosed=rclosed_mix
EMIXQ_c007_0_05 (mix_q_src_c007_0_05 0 bpf_c007_0 0) vcvs gain=8.314696123025e-01
SMIXQ_c007_0_05 (mix_q_src_c007_0_05 mix_q_c007_0 win_0_05 0) relay vt1=-1m vt2=1m ropen=ropen_mix rclosed=rclosed_mix
EMIXI_c007_0_06 (mix_i_src_c007_0_06 0 bpf_c007_0 0) vcvs gain=-8.314696123025e-01
SMIXI_c007_0_06 (mix_i_src_c007_0_06 mix_i_c007_0 win_0_06 0) relay vt1=-1m vt2=1m ropen=ropen_mix rclosed=rclosed_mix
EMIXQ_c007_0_06 (mix_q_src_c007_0_06 0 bpf_c007_0 0) vcvs gain=5.555702330196e-01
SMIXQ_c007_0_06 (mix_q_src_c007_0_06 mix_q_c007_0 win_0_06 0) relay vt1=-1m vt2=1m ropen=ropen_mix rclosed=rclosed_mix
EMIXI_c007_0_07 (mix_i_src_c007_0_07 0 bpf_c007_0 0) vcvs gain=-9.807852804032e-01
SMIXI_c007_0_07 (mix_i_src_c007_0_07 mix_i_c007_0 win_0_07 0) relay vt1=-1m vt2=1m ropen=ropen_mix rclosed=rclosed_mix
EMIXQ_c007_0_07 (mix_q_src_c007_0_07 0 bpf_c007_0 0) vcvs gain=1.950903220161e-01
SMIXQ_c007_0_07 (mix_q_src_c007_0_07 mix_q_c007_0 win_0_07 0) relay vt1=-1m vt2=1m ropen=ropen_mix rclosed=rclosed_mix
EMIXI_c007_0_08 (mix_i_src_c007_0_08 0 bpf_c007_0 0) vcvs gain=-9.807852804032e-01
SMIXI_c007_0_08 (mix_i_src_c007_0_08 mix_i_c007_0 win_0_08 0) relay vt1=-1m vt2=1m ropen=ropen_mix rclosed=rclosed_mix
EMIXQ_c007_0_08 (mix_q_src_c007_0_08 0 bpf_c007_0 0) vcvs gain=-1.950903220161e-01
SMIXQ_c007_0_08 (mix_q_src_c007_0_08 mix_q_c007_0 win_0_08 0) relay vt1=-1m vt2=1m ropen=ropen_mix rclosed=rclosed_mix
EMIXI_c007_0_09 (mix_i_src_c007_0_09 0 bpf_c007_0 0) vcvs gain=-8.314696123025e-01
SMIXI_c007_0_09 (mix_i_src_c007_0_09 mix_i_c007_0 win_0_09 0) relay vt1=-1m vt2=1m ropen=ropen_mix rclosed=rclosed_mix
EMIXQ_c007_0_09 (mix_q_src_c007_0_09 0 bpf_c007_0 0) vcvs gain=-5.555702330196e-01
SMIXQ_c007_0_09 (mix_q_src_c007_0_09 mix_q_c007_0 win_0_09 0) relay vt1=-1m vt2=1m ropen=ropen_mix rclosed=rclosed_mix
EMIXI_c007_0_10 (mix_i_src_c007_0_10 0 bpf_c007_0 0) vcvs gain=-5.555702330196e-01
SMIXI_c007_0_10 (mix_i_src_c007_0_10 mix_i_c007_0 win_0_10 0) relay vt1=-1m vt2=1m ropen=ropen_mix rclosed=rclosed_mix
EMIXQ_c007_0_10 (mix_q_src_c007_0_10 0 bpf_c007_0 0) vcvs gain=-8.314696123025e-01
SMIXQ_c007_0_10 (mix_q_src_c007_0_10 mix_q_c007_0 win_0_10 0) relay vt1=-1m vt2=1m ropen=ropen_mix rclosed=rclosed_mix
EMIXI_c007_0_11 (mix_i_src_c007_0_11 0 bpf_c007_0 0) vcvs gain=-1.950903220161e-01
SMIXI_c007_0_11 (mix_i_src_c007_0_11 mix_i_c007_0 win_0_11 0) relay vt1=-1m vt2=1m ropen=ropen_mix rclosed=rclosed_mix
EMIXQ_c007_0_11 (mix_q_src_c007_0_11 0 bpf_c007_0 0) vcvs gain=-9.807852804032e-01
SMIXQ_c007_0_11 (mix_q_src_c007_0_11 mix_q_c007_0 win_0_11 0) relay vt1=-1m vt2=1m ropen=ropen_mix rclosed=rclosed_mix
EMIXI_c007_0_12 (mix_i_src_c007_0_12 0 bpf_c007_0 0) vcvs gain=1.950903220161e-01
SMIXI_c007_0_12 (mix_i_src_c007_0_12 mix_i_c007_0 win_0_12 0) relay vt1=-1m vt2=1m ropen=ropen_mix rclosed=rclosed_mix
EMIXQ_c007_0_12 (mix_q_src_c007_0_12 0 bpf_c007_0 0) vcvs gain=-9.807852804032e-01
SMIXQ_c007_0_12 (mix_q_src_c007_0_12 mix_q_c007_0 win_0_12 0) relay vt1=-1m vt2=1m ropen=ropen_mix rclosed=rclosed_mix
EMIXI_c007_0_13 (mix_i_src_c007_0_13 0 bpf_c007_0 0) vcvs gain=5.555702330196e-01
SMIXI_c007_0_13 (mix_i_src_c007_0_13 mix_i_c007_0 win_0_13 0) relay vt1=-1m vt2=1m ropen=ropen_mix rclosed=rclosed_mix
EMIXQ_c007_0_13 (mix_q_src_c007_0_13 0 bpf_c007_0 0) vcvs gain=-8.314696123025e-01
SMIXQ_c007_0_13 (mix_q_src_c007_0_13 mix_q_c007_0 win_0_13 0) relay vt1=-1m vt2=1m ropen=ropen_mix rclosed=rclosed_mix
EMIXI_c007_0_14 (mix_i_src_c007_0_14 0 bpf_c007_0 0) vcvs gain=8.314696123025e-01
SMIXI_c007_0_14 (mix_i_src_c007_0_14 mix_i_c007_0 win_0_14 0) relay vt1=-1m vt2=1m ropen=ropen_mix rclosed=rclosed_mix
EMIXQ_c007_0_14 (mix_q_src_c007_0_14 0 bpf_c007_0 0) vcvs gain=-5.555702330196e-01
SMIXQ_c007_0_14 (mix_q_src_c007_0_14 mix_q_c007_0 win_0_14 0) relay vt1=-1m vt2=1m ropen=ropen_mix rclosed=rclosed_mix
EMIXI_c007_0_15 (mix_i_src_c007_0_15 0 bpf_c007_0 0) vcvs gain=9.807852804032e-01
SMIXI_c007_0_15 (mix_i_src_c007_0_15 mix_i_c007_0 win_0_15 0) relay vt1=-1m vt2=1m ropen=ropen_mix rclosed=rclosed_mix
EMIXQ_c007_0_15 (mix_q_src_c007_0_15 0 bpf_c007_0 0) vcvs gain=-1.950903220161e-01
SMIXQ_c007_0_15 (mix_q_src_c007_0_15 mix_q_c007_0 win_0_15 0) relay vt1=-1m vt2=1m ropen=ropen_mix rclosed=rclosed_mix
RMIXI_c007_0 (mix_i_c007_0 0) resistor r=1G
RMIXQ_c007_0 (mix_q_c007_0 0) resistor r=1G
RINTI_c007_0 (mix_i_c007_0 Icar_c007_0) resistor r=1k
CINTI_c007_0 (Icar_c007_0 0) capacitor c=80p
RINTQ_c007_0 (mix_q_c007_0 Qcar_c007_0) resistor r=1k
CINTQ_c007_0 (Qcar_c007_0 0) capacitor c=80p
save bpf_c007_0 Icar_c007_0 Qcar_c007_0

// bl007, carrier_1: 500000000 Hz coherent I/Q phase-window verification-demod path
CBPF_c007_1 (bl007 n_cbpf_c007_1) capacitor c=1.013211836423e-13
LBPF_c007_1 (n_cbpf_c007_1 bpf_c007_1) inductor l=1.000000000000e-06
RBPF_c007_1 (bpf_c007_1 0) resistor r=1.570796326795e+02
EMIXI_c007_1_00 (mix_i_src_c007_1_00 0 bpf_c007_1 0) vcvs gain=9.807852804032e-01
SMIXI_c007_1_00 (mix_i_src_c007_1_00 mix_i_c007_1 win_1_00 0) relay vt1=-1m vt2=1m ropen=ropen_mix rclosed=rclosed_mix
EMIXQ_c007_1_00 (mix_q_src_c007_1_00 0 bpf_c007_1 0) vcvs gain=1.950903220161e-01
SMIXQ_c007_1_00 (mix_q_src_c007_1_00 mix_q_c007_1 win_1_00 0) relay vt1=-1m vt2=1m ropen=ropen_mix rclosed=rclosed_mix
EMIXI_c007_1_01 (mix_i_src_c007_1_01 0 bpf_c007_1 0) vcvs gain=8.314696123025e-01
SMIXI_c007_1_01 (mix_i_src_c007_1_01 mix_i_c007_1 win_1_01 0) relay vt1=-1m vt2=1m ropen=ropen_mix rclosed=rclosed_mix
EMIXQ_c007_1_01 (mix_q_src_c007_1_01 0 bpf_c007_1 0) vcvs gain=5.555702330196e-01
SMIXQ_c007_1_01 (mix_q_src_c007_1_01 mix_q_c007_1 win_1_01 0) relay vt1=-1m vt2=1m ropen=ropen_mix rclosed=rclosed_mix
EMIXI_c007_1_02 (mix_i_src_c007_1_02 0 bpf_c007_1 0) vcvs gain=5.555702330196e-01
SMIXI_c007_1_02 (mix_i_src_c007_1_02 mix_i_c007_1 win_1_02 0) relay vt1=-1m vt2=1m ropen=ropen_mix rclosed=rclosed_mix
EMIXQ_c007_1_02 (mix_q_src_c007_1_02 0 bpf_c007_1 0) vcvs gain=8.314696123025e-01
SMIXQ_c007_1_02 (mix_q_src_c007_1_02 mix_q_c007_1 win_1_02 0) relay vt1=-1m vt2=1m ropen=ropen_mix rclosed=rclosed_mix
EMIXI_c007_1_03 (mix_i_src_c007_1_03 0 bpf_c007_1 0) vcvs gain=1.950903220161e-01
SMIXI_c007_1_03 (mix_i_src_c007_1_03 mix_i_c007_1 win_1_03 0) relay vt1=-1m vt2=1m ropen=ropen_mix rclosed=rclosed_mix
EMIXQ_c007_1_03 (mix_q_src_c007_1_03 0 bpf_c007_1 0) vcvs gain=9.807852804032e-01
SMIXQ_c007_1_03 (mix_q_src_c007_1_03 mix_q_c007_1 win_1_03 0) relay vt1=-1m vt2=1m ropen=ropen_mix rclosed=rclosed_mix
EMIXI_c007_1_04 (mix_i_src_c007_1_04 0 bpf_c007_1 0) vcvs gain=-1.950903220161e-01
SMIXI_c007_1_04 (mix_i_src_c007_1_04 mix_i_c007_1 win_1_04 0) relay vt1=-1m vt2=1m ropen=ropen_mix rclosed=rclosed_mix
EMIXQ_c007_1_04 (mix_q_src_c007_1_04 0 bpf_c007_1 0) vcvs gain=9.807852804032e-01
SMIXQ_c007_1_04 (mix_q_src_c007_1_04 mix_q_c007_1 win_1_04 0) relay vt1=-1m vt2=1m ropen=ropen_mix rclosed=rclosed_mix
EMIXI_c007_1_05 (mix_i_src_c007_1_05 0 bpf_c007_1 0) vcvs gain=-5.555702330196e-01
SMIXI_c007_1_05 (mix_i_src_c007_1_05 mix_i_c007_1 win_1_05 0) relay vt1=-1m vt2=1m ropen=ropen_mix rclosed=rclosed_mix
EMIXQ_c007_1_05 (mix_q_src_c007_1_05 0 bpf_c007_1 0) vcvs gain=8.314696123025e-01
SMIXQ_c007_1_05 (mix_q_src_c007_1_05 mix_q_c007_1 win_1_05 0) relay vt1=-1m vt2=1m ropen=ropen_mix rclosed=rclosed_mix
EMIXI_c007_1_06 (mix_i_src_c007_1_06 0 bpf_c007_1 0) vcvs gain=-8.314696123025e-01
SMIXI_c007_1_06 (mix_i_src_c007_1_06 mix_i_c007_1 win_1_06 0) relay vt1=-1m vt2=1m ropen=ropen_mix rclosed=rclosed_mix
EMIXQ_c007_1_06 (mix_q_src_c007_1_06 0 bpf_c007_1 0) vcvs gain=5.555702330196e-01
SMIXQ_c007_1_06 (mix_q_src_c007_1_06 mix_q_c007_1 win_1_06 0) relay vt1=-1m vt2=1m ropen=ropen_mix rclosed=rclosed_mix
EMIXI_c007_1_07 (mix_i_src_c007_1_07 0 bpf_c007_1 0) vcvs gain=-9.807852804032e-01
SMIXI_c007_1_07 (mix_i_src_c007_1_07 mix_i_c007_1 win_1_07 0) relay vt1=-1m vt2=1m ropen=ropen_mix rclosed=rclosed_mix
EMIXQ_c007_1_07 (mix_q_src_c007_1_07 0 bpf_c007_1 0) vcvs gain=1.950903220161e-01
SMIXQ_c007_1_07 (mix_q_src_c007_1_07 mix_q_c007_1 win_1_07 0) relay vt1=-1m vt2=1m ropen=ropen_mix rclosed=rclosed_mix
EMIXI_c007_1_08 (mix_i_src_c007_1_08 0 bpf_c007_1 0) vcvs gain=-9.807852804032e-01
SMIXI_c007_1_08 (mix_i_src_c007_1_08 mix_i_c007_1 win_1_08 0) relay vt1=-1m vt2=1m ropen=ropen_mix rclosed=rclosed_mix
EMIXQ_c007_1_08 (mix_q_src_c007_1_08 0 bpf_c007_1 0) vcvs gain=-1.950903220161e-01
SMIXQ_c007_1_08 (mix_q_src_c007_1_08 mix_q_c007_1 win_1_08 0) relay vt1=-1m vt2=1m ropen=ropen_mix rclosed=rclosed_mix
EMIXI_c007_1_09 (mix_i_src_c007_1_09 0 bpf_c007_1 0) vcvs gain=-8.314696123025e-01
SMIXI_c007_1_09 (mix_i_src_c007_1_09 mix_i_c007_1 win_1_09 0) relay vt1=-1m vt2=1m ropen=ropen_mix rclosed=rclosed_mix
EMIXQ_c007_1_09 (mix_q_src_c007_1_09 0 bpf_c007_1 0) vcvs gain=-5.555702330196e-01
SMIXQ_c007_1_09 (mix_q_src_c007_1_09 mix_q_c007_1 win_1_09 0) relay vt1=-1m vt2=1m ropen=ropen_mix rclosed=rclosed_mix
EMIXI_c007_1_10 (mix_i_src_c007_1_10 0 bpf_c007_1 0) vcvs gain=-5.555702330196e-01
SMIXI_c007_1_10 (mix_i_src_c007_1_10 mix_i_c007_1 win_1_10 0) relay vt1=-1m vt2=1m ropen=ropen_mix rclosed=rclosed_mix
EMIXQ_c007_1_10 (mix_q_src_c007_1_10 0 bpf_c007_1 0) vcvs gain=-8.314696123025e-01
SMIXQ_c007_1_10 (mix_q_src_c007_1_10 mix_q_c007_1 win_1_10 0) relay vt1=-1m vt2=1m ropen=ropen_mix rclosed=rclosed_mix
EMIXI_c007_1_11 (mix_i_src_c007_1_11 0 bpf_c007_1 0) vcvs gain=-1.950903220161e-01
SMIXI_c007_1_11 (mix_i_src_c007_1_11 mix_i_c007_1 win_1_11 0) relay vt1=-1m vt2=1m ropen=ropen_mix rclosed=rclosed_mix
EMIXQ_c007_1_11 (mix_q_src_c007_1_11 0 bpf_c007_1 0) vcvs gain=-9.807852804032e-01
SMIXQ_c007_1_11 (mix_q_src_c007_1_11 mix_q_c007_1 win_1_11 0) relay vt1=-1m vt2=1m ropen=ropen_mix rclosed=rclosed_mix
EMIXI_c007_1_12 (mix_i_src_c007_1_12 0 bpf_c007_1 0) vcvs gain=1.950903220161e-01
SMIXI_c007_1_12 (mix_i_src_c007_1_12 mix_i_c007_1 win_1_12 0) relay vt1=-1m vt2=1m ropen=ropen_mix rclosed=rclosed_mix
EMIXQ_c007_1_12 (mix_q_src_c007_1_12 0 bpf_c007_1 0) vcvs gain=-9.807852804032e-01
SMIXQ_c007_1_12 (mix_q_src_c007_1_12 mix_q_c007_1 win_1_12 0) relay vt1=-1m vt2=1m ropen=ropen_mix rclosed=rclosed_mix
EMIXI_c007_1_13 (mix_i_src_c007_1_13 0 bpf_c007_1 0) vcvs gain=5.555702330196e-01
SMIXI_c007_1_13 (mix_i_src_c007_1_13 mix_i_c007_1 win_1_13 0) relay vt1=-1m vt2=1m ropen=ropen_mix rclosed=rclosed_mix
EMIXQ_c007_1_13 (mix_q_src_c007_1_13 0 bpf_c007_1 0) vcvs gain=-8.314696123025e-01
SMIXQ_c007_1_13 (mix_q_src_c007_1_13 mix_q_c007_1 win_1_13 0) relay vt1=-1m vt2=1m ropen=ropen_mix rclosed=rclosed_mix
EMIXI_c007_1_14 (mix_i_src_c007_1_14 0 bpf_c007_1 0) vcvs gain=8.314696123025e-01
SMIXI_c007_1_14 (mix_i_src_c007_1_14 mix_i_c007_1 win_1_14 0) relay vt1=-1m vt2=1m ropen=ropen_mix rclosed=rclosed_mix
EMIXQ_c007_1_14 (mix_q_src_c007_1_14 0 bpf_c007_1 0) vcvs gain=-5.555702330196e-01
SMIXQ_c007_1_14 (mix_q_src_c007_1_14 mix_q_c007_1 win_1_14 0) relay vt1=-1m vt2=1m ropen=ropen_mix rclosed=rclosed_mix
EMIXI_c007_1_15 (mix_i_src_c007_1_15 0 bpf_c007_1 0) vcvs gain=9.807852804032e-01
SMIXI_c007_1_15 (mix_i_src_c007_1_15 mix_i_c007_1 win_1_15 0) relay vt1=-1m vt2=1m ropen=ropen_mix rclosed=rclosed_mix
EMIXQ_c007_1_15 (mix_q_src_c007_1_15 0 bpf_c007_1 0) vcvs gain=-1.950903220161e-01
SMIXQ_c007_1_15 (mix_q_src_c007_1_15 mix_q_c007_1 win_1_15 0) relay vt1=-1m vt2=1m ropen=ropen_mix rclosed=rclosed_mix
RMIXI_c007_1 (mix_i_c007_1 0) resistor r=1G
RMIXQ_c007_1 (mix_q_c007_1 0) resistor r=1G
RINTI_c007_1 (mix_i_c007_1 Icar_c007_1) resistor r=1k
CINTI_c007_1 (Icar_c007_1 0) capacitor c=80p
RINTQ_c007_1 (mix_q_c007_1 Qcar_c007_1) resistor r=1k
CINTQ_c007_1 (Qcar_c007_1 0) capacitor c=80p
save bpf_c007_1 Icar_c007_1 Qcar_c007_1

// bl007, carrier_2: 750000000 Hz coherent I/Q phase-window verification-demod path
CBPF_c007_2 (bl007 n_cbpf_c007_2) capacitor c=4.503163717437e-14
LBPF_c007_2 (n_cbpf_c007_2 bpf_c007_2) inductor l=1.000000000000e-06
RBPF_c007_2 (bpf_c007_2 0) resistor r=2.356194490192e+02
EMIXI_c007_2_00 (mix_i_src_c007_2_00 0 bpf_c007_2 0) vcvs gain=9.807852804032e-01
SMIXI_c007_2_00 (mix_i_src_c007_2_00 mix_i_c007_2 win_2_00 0) relay vt1=-1m vt2=1m ropen=ropen_mix rclosed=rclosed_mix
EMIXQ_c007_2_00 (mix_q_src_c007_2_00 0 bpf_c007_2 0) vcvs gain=1.950903220161e-01
SMIXQ_c007_2_00 (mix_q_src_c007_2_00 mix_q_c007_2 win_2_00 0) relay vt1=-1m vt2=1m ropen=ropen_mix rclosed=rclosed_mix
EMIXI_c007_2_01 (mix_i_src_c007_2_01 0 bpf_c007_2 0) vcvs gain=8.314696123025e-01
SMIXI_c007_2_01 (mix_i_src_c007_2_01 mix_i_c007_2 win_2_01 0) relay vt1=-1m vt2=1m ropen=ropen_mix rclosed=rclosed_mix
EMIXQ_c007_2_01 (mix_q_src_c007_2_01 0 bpf_c007_2 0) vcvs gain=5.555702330196e-01
SMIXQ_c007_2_01 (mix_q_src_c007_2_01 mix_q_c007_2 win_2_01 0) relay vt1=-1m vt2=1m ropen=ropen_mix rclosed=rclosed_mix
EMIXI_c007_2_02 (mix_i_src_c007_2_02 0 bpf_c007_2 0) vcvs gain=5.555702330196e-01
SMIXI_c007_2_02 (mix_i_src_c007_2_02 mix_i_c007_2 win_2_02 0) relay vt1=-1m vt2=1m ropen=ropen_mix rclosed=rclosed_mix
EMIXQ_c007_2_02 (mix_q_src_c007_2_02 0 bpf_c007_2 0) vcvs gain=8.314696123025e-01
SMIXQ_c007_2_02 (mix_q_src_c007_2_02 mix_q_c007_2 win_2_02 0) relay vt1=-1m vt2=1m ropen=ropen_mix rclosed=rclosed_mix
EMIXI_c007_2_03 (mix_i_src_c007_2_03 0 bpf_c007_2 0) vcvs gain=1.950903220161e-01
SMIXI_c007_2_03 (mix_i_src_c007_2_03 mix_i_c007_2 win_2_03 0) relay vt1=-1m vt2=1m ropen=ropen_mix rclosed=rclosed_mix
EMIXQ_c007_2_03 (mix_q_src_c007_2_03 0 bpf_c007_2 0) vcvs gain=9.807852804032e-01
SMIXQ_c007_2_03 (mix_q_src_c007_2_03 mix_q_c007_2 win_2_03 0) relay vt1=-1m vt2=1m ropen=ropen_mix rclosed=rclosed_mix
EMIXI_c007_2_04 (mix_i_src_c007_2_04 0 bpf_c007_2 0) vcvs gain=-1.950903220161e-01
SMIXI_c007_2_04 (mix_i_src_c007_2_04 mix_i_c007_2 win_2_04 0) relay vt1=-1m vt2=1m ropen=ropen_mix rclosed=rclosed_mix
EMIXQ_c007_2_04 (mix_q_src_c007_2_04 0 bpf_c007_2 0) vcvs gain=9.807852804032e-01
SMIXQ_c007_2_04 (mix_q_src_c007_2_04 mix_q_c007_2 win_2_04 0) relay vt1=-1m vt2=1m ropen=ropen_mix rclosed=rclosed_mix
EMIXI_c007_2_05 (mix_i_src_c007_2_05 0 bpf_c007_2 0) vcvs gain=-5.555702330196e-01
SMIXI_c007_2_05 (mix_i_src_c007_2_05 mix_i_c007_2 win_2_05 0) relay vt1=-1m vt2=1m ropen=ropen_mix rclosed=rclosed_mix
EMIXQ_c007_2_05 (mix_q_src_c007_2_05 0 bpf_c007_2 0) vcvs gain=8.314696123025e-01
SMIXQ_c007_2_05 (mix_q_src_c007_2_05 mix_q_c007_2 win_2_05 0) relay vt1=-1m vt2=1m ropen=ropen_mix rclosed=rclosed_mix
EMIXI_c007_2_06 (mix_i_src_c007_2_06 0 bpf_c007_2 0) vcvs gain=-8.314696123025e-01
SMIXI_c007_2_06 (mix_i_src_c007_2_06 mix_i_c007_2 win_2_06 0) relay vt1=-1m vt2=1m ropen=ropen_mix rclosed=rclosed_mix
EMIXQ_c007_2_06 (mix_q_src_c007_2_06 0 bpf_c007_2 0) vcvs gain=5.555702330196e-01
SMIXQ_c007_2_06 (mix_q_src_c007_2_06 mix_q_c007_2 win_2_06 0) relay vt1=-1m vt2=1m ropen=ropen_mix rclosed=rclosed_mix
EMIXI_c007_2_07 (mix_i_src_c007_2_07 0 bpf_c007_2 0) vcvs gain=-9.807852804032e-01
SMIXI_c007_2_07 (mix_i_src_c007_2_07 mix_i_c007_2 win_2_07 0) relay vt1=-1m vt2=1m ropen=ropen_mix rclosed=rclosed_mix
EMIXQ_c007_2_07 (mix_q_src_c007_2_07 0 bpf_c007_2 0) vcvs gain=1.950903220161e-01
SMIXQ_c007_2_07 (mix_q_src_c007_2_07 mix_q_c007_2 win_2_07 0) relay vt1=-1m vt2=1m ropen=ropen_mix rclosed=rclosed_mix
EMIXI_c007_2_08 (mix_i_src_c007_2_08 0 bpf_c007_2 0) vcvs gain=-9.807852804032e-01
SMIXI_c007_2_08 (mix_i_src_c007_2_08 mix_i_c007_2 win_2_08 0) relay vt1=-1m vt2=1m ropen=ropen_mix rclosed=rclosed_mix
EMIXQ_c007_2_08 (mix_q_src_c007_2_08 0 bpf_c007_2 0) vcvs gain=-1.950903220161e-01
SMIXQ_c007_2_08 (mix_q_src_c007_2_08 mix_q_c007_2 win_2_08 0) relay vt1=-1m vt2=1m ropen=ropen_mix rclosed=rclosed_mix
EMIXI_c007_2_09 (mix_i_src_c007_2_09 0 bpf_c007_2 0) vcvs gain=-8.314696123025e-01
SMIXI_c007_2_09 (mix_i_src_c007_2_09 mix_i_c007_2 win_2_09 0) relay vt1=-1m vt2=1m ropen=ropen_mix rclosed=rclosed_mix
EMIXQ_c007_2_09 (mix_q_src_c007_2_09 0 bpf_c007_2 0) vcvs gain=-5.555702330196e-01
SMIXQ_c007_2_09 (mix_q_src_c007_2_09 mix_q_c007_2 win_2_09 0) relay vt1=-1m vt2=1m ropen=ropen_mix rclosed=rclosed_mix
EMIXI_c007_2_10 (mix_i_src_c007_2_10 0 bpf_c007_2 0) vcvs gain=-5.555702330196e-01
SMIXI_c007_2_10 (mix_i_src_c007_2_10 mix_i_c007_2 win_2_10 0) relay vt1=-1m vt2=1m ropen=ropen_mix rclosed=rclosed_mix
EMIXQ_c007_2_10 (mix_q_src_c007_2_10 0 bpf_c007_2 0) vcvs gain=-8.314696123025e-01
SMIXQ_c007_2_10 (mix_q_src_c007_2_10 mix_q_c007_2 win_2_10 0) relay vt1=-1m vt2=1m ropen=ropen_mix rclosed=rclosed_mix
EMIXI_c007_2_11 (mix_i_src_c007_2_11 0 bpf_c007_2 0) vcvs gain=-1.950903220161e-01
SMIXI_c007_2_11 (mix_i_src_c007_2_11 mix_i_c007_2 win_2_11 0) relay vt1=-1m vt2=1m ropen=ropen_mix rclosed=rclosed_mix
EMIXQ_c007_2_11 (mix_q_src_c007_2_11 0 bpf_c007_2 0) vcvs gain=-9.807852804032e-01
SMIXQ_c007_2_11 (mix_q_src_c007_2_11 mix_q_c007_2 win_2_11 0) relay vt1=-1m vt2=1m ropen=ropen_mix rclosed=rclosed_mix
EMIXI_c007_2_12 (mix_i_src_c007_2_12 0 bpf_c007_2 0) vcvs gain=1.950903220161e-01
SMIXI_c007_2_12 (mix_i_src_c007_2_12 mix_i_c007_2 win_2_12 0) relay vt1=-1m vt2=1m ropen=ropen_mix rclosed=rclosed_mix
EMIXQ_c007_2_12 (mix_q_src_c007_2_12 0 bpf_c007_2 0) vcvs gain=-9.807852804032e-01
SMIXQ_c007_2_12 (mix_q_src_c007_2_12 mix_q_c007_2 win_2_12 0) relay vt1=-1m vt2=1m ropen=ropen_mix rclosed=rclosed_mix
EMIXI_c007_2_13 (mix_i_src_c007_2_13 0 bpf_c007_2 0) vcvs gain=5.555702330196e-01
SMIXI_c007_2_13 (mix_i_src_c007_2_13 mix_i_c007_2 win_2_13 0) relay vt1=-1m vt2=1m ropen=ropen_mix rclosed=rclosed_mix
EMIXQ_c007_2_13 (mix_q_src_c007_2_13 0 bpf_c007_2 0) vcvs gain=-8.314696123025e-01
SMIXQ_c007_2_13 (mix_q_src_c007_2_13 mix_q_c007_2 win_2_13 0) relay vt1=-1m vt2=1m ropen=ropen_mix rclosed=rclosed_mix
EMIXI_c007_2_14 (mix_i_src_c007_2_14 0 bpf_c007_2 0) vcvs gain=8.314696123025e-01
SMIXI_c007_2_14 (mix_i_src_c007_2_14 mix_i_c007_2 win_2_14 0) relay vt1=-1m vt2=1m ropen=ropen_mix rclosed=rclosed_mix
EMIXQ_c007_2_14 (mix_q_src_c007_2_14 0 bpf_c007_2 0) vcvs gain=-5.555702330196e-01
SMIXQ_c007_2_14 (mix_q_src_c007_2_14 mix_q_c007_2 win_2_14 0) relay vt1=-1m vt2=1m ropen=ropen_mix rclosed=rclosed_mix
EMIXI_c007_2_15 (mix_i_src_c007_2_15 0 bpf_c007_2 0) vcvs gain=9.807852804032e-01
SMIXI_c007_2_15 (mix_i_src_c007_2_15 mix_i_c007_2 win_2_15 0) relay vt1=-1m vt2=1m ropen=ropen_mix rclosed=rclosed_mix
EMIXQ_c007_2_15 (mix_q_src_c007_2_15 0 bpf_c007_2 0) vcvs gain=-1.950903220161e-01
SMIXQ_c007_2_15 (mix_q_src_c007_2_15 mix_q_c007_2 win_2_15 0) relay vt1=-1m vt2=1m ropen=ropen_mix rclosed=rclosed_mix
RMIXI_c007_2 (mix_i_c007_2 0) resistor r=1G
RMIXQ_c007_2 (mix_q_c007_2 0) resistor r=1G
RINTI_c007_2 (mix_i_c007_2 Icar_c007_2) resistor r=1k
CINTI_c007_2 (Icar_c007_2 0) capacitor c=80p
RINTQ_c007_2 (mix_q_c007_2 Qcar_c007_2) resistor r=1k
CINTQ_c007_2 (Qcar_c007_2 0) capacitor c=80p
save bpf_c007_2 Icar_c007_2 Qcar_c007_2

// bl007, carrier_3: 1000000000 Hz coherent I/Q phase-window verification-demod path
CBPF_c007_3 (bl007 n_cbpf_c007_3) capacitor c=2.533029591058e-14
LBPF_c007_3 (n_cbpf_c007_3 bpf_c007_3) inductor l=1.000000000000e-06
RBPF_c007_3 (bpf_c007_3 0) resistor r=3.141592653590e+02
EMIXI_c007_3_00 (mix_i_src_c007_3_00 0 bpf_c007_3 0) vcvs gain=9.807852804032e-01
SMIXI_c007_3_00 (mix_i_src_c007_3_00 mix_i_c007_3 win_3_00 0) relay vt1=-1m vt2=1m ropen=ropen_mix rclosed=rclosed_mix
EMIXQ_c007_3_00 (mix_q_src_c007_3_00 0 bpf_c007_3 0) vcvs gain=1.950903220161e-01
SMIXQ_c007_3_00 (mix_q_src_c007_3_00 mix_q_c007_3 win_3_00 0) relay vt1=-1m vt2=1m ropen=ropen_mix rclosed=rclosed_mix
EMIXI_c007_3_01 (mix_i_src_c007_3_01 0 bpf_c007_3 0) vcvs gain=8.314696123025e-01
SMIXI_c007_3_01 (mix_i_src_c007_3_01 mix_i_c007_3 win_3_01 0) relay vt1=-1m vt2=1m ropen=ropen_mix rclosed=rclosed_mix
EMIXQ_c007_3_01 (mix_q_src_c007_3_01 0 bpf_c007_3 0) vcvs gain=5.555702330196e-01
SMIXQ_c007_3_01 (mix_q_src_c007_3_01 mix_q_c007_3 win_3_01 0) relay vt1=-1m vt2=1m ropen=ropen_mix rclosed=rclosed_mix
EMIXI_c007_3_02 (mix_i_src_c007_3_02 0 bpf_c007_3 0) vcvs gain=5.555702330196e-01
SMIXI_c007_3_02 (mix_i_src_c007_3_02 mix_i_c007_3 win_3_02 0) relay vt1=-1m vt2=1m ropen=ropen_mix rclosed=rclosed_mix
EMIXQ_c007_3_02 (mix_q_src_c007_3_02 0 bpf_c007_3 0) vcvs gain=8.314696123025e-01
SMIXQ_c007_3_02 (mix_q_src_c007_3_02 mix_q_c007_3 win_3_02 0) relay vt1=-1m vt2=1m ropen=ropen_mix rclosed=rclosed_mix
EMIXI_c007_3_03 (mix_i_src_c007_3_03 0 bpf_c007_3 0) vcvs gain=1.950903220161e-01
SMIXI_c007_3_03 (mix_i_src_c007_3_03 mix_i_c007_3 win_3_03 0) relay vt1=-1m vt2=1m ropen=ropen_mix rclosed=rclosed_mix
EMIXQ_c007_3_03 (mix_q_src_c007_3_03 0 bpf_c007_3 0) vcvs gain=9.807852804032e-01
SMIXQ_c007_3_03 (mix_q_src_c007_3_03 mix_q_c007_3 win_3_03 0) relay vt1=-1m vt2=1m ropen=ropen_mix rclosed=rclosed_mix
EMIXI_c007_3_04 (mix_i_src_c007_3_04 0 bpf_c007_3 0) vcvs gain=-1.950903220161e-01
SMIXI_c007_3_04 (mix_i_src_c007_3_04 mix_i_c007_3 win_3_04 0) relay vt1=-1m vt2=1m ropen=ropen_mix rclosed=rclosed_mix
EMIXQ_c007_3_04 (mix_q_src_c007_3_04 0 bpf_c007_3 0) vcvs gain=9.807852804032e-01
SMIXQ_c007_3_04 (mix_q_src_c007_3_04 mix_q_c007_3 win_3_04 0) relay vt1=-1m vt2=1m ropen=ropen_mix rclosed=rclosed_mix
EMIXI_c007_3_05 (mix_i_src_c007_3_05 0 bpf_c007_3 0) vcvs gain=-5.555702330196e-01
SMIXI_c007_3_05 (mix_i_src_c007_3_05 mix_i_c007_3 win_3_05 0) relay vt1=-1m vt2=1m ropen=ropen_mix rclosed=rclosed_mix
EMIXQ_c007_3_05 (mix_q_src_c007_3_05 0 bpf_c007_3 0) vcvs gain=8.314696123025e-01
SMIXQ_c007_3_05 (mix_q_src_c007_3_05 mix_q_c007_3 win_3_05 0) relay vt1=-1m vt2=1m ropen=ropen_mix rclosed=rclosed_mix
EMIXI_c007_3_06 (mix_i_src_c007_3_06 0 bpf_c007_3 0) vcvs gain=-8.314696123025e-01
SMIXI_c007_3_06 (mix_i_src_c007_3_06 mix_i_c007_3 win_3_06 0) relay vt1=-1m vt2=1m ropen=ropen_mix rclosed=rclosed_mix
EMIXQ_c007_3_06 (mix_q_src_c007_3_06 0 bpf_c007_3 0) vcvs gain=5.555702330196e-01
SMIXQ_c007_3_06 (mix_q_src_c007_3_06 mix_q_c007_3 win_3_06 0) relay vt1=-1m vt2=1m ropen=ropen_mix rclosed=rclosed_mix
EMIXI_c007_3_07 (mix_i_src_c007_3_07 0 bpf_c007_3 0) vcvs gain=-9.807852804032e-01
SMIXI_c007_3_07 (mix_i_src_c007_3_07 mix_i_c007_3 win_3_07 0) relay vt1=-1m vt2=1m ropen=ropen_mix rclosed=rclosed_mix
EMIXQ_c007_3_07 (mix_q_src_c007_3_07 0 bpf_c007_3 0) vcvs gain=1.950903220161e-01
SMIXQ_c007_3_07 (mix_q_src_c007_3_07 mix_q_c007_3 win_3_07 0) relay vt1=-1m vt2=1m ropen=ropen_mix rclosed=rclosed_mix
EMIXI_c007_3_08 (mix_i_src_c007_3_08 0 bpf_c007_3 0) vcvs gain=-9.807852804032e-01
SMIXI_c007_3_08 (mix_i_src_c007_3_08 mix_i_c007_3 win_3_08 0) relay vt1=-1m vt2=1m ropen=ropen_mix rclosed=rclosed_mix
EMIXQ_c007_3_08 (mix_q_src_c007_3_08 0 bpf_c007_3 0) vcvs gain=-1.950903220161e-01
SMIXQ_c007_3_08 (mix_q_src_c007_3_08 mix_q_c007_3 win_3_08 0) relay vt1=-1m vt2=1m ropen=ropen_mix rclosed=rclosed_mix
EMIXI_c007_3_09 (mix_i_src_c007_3_09 0 bpf_c007_3 0) vcvs gain=-8.314696123025e-01
SMIXI_c007_3_09 (mix_i_src_c007_3_09 mix_i_c007_3 win_3_09 0) relay vt1=-1m vt2=1m ropen=ropen_mix rclosed=rclosed_mix
EMIXQ_c007_3_09 (mix_q_src_c007_3_09 0 bpf_c007_3 0) vcvs gain=-5.555702330196e-01
SMIXQ_c007_3_09 (mix_q_src_c007_3_09 mix_q_c007_3 win_3_09 0) relay vt1=-1m vt2=1m ropen=ropen_mix rclosed=rclosed_mix
EMIXI_c007_3_10 (mix_i_src_c007_3_10 0 bpf_c007_3 0) vcvs gain=-5.555702330196e-01
SMIXI_c007_3_10 (mix_i_src_c007_3_10 mix_i_c007_3 win_3_10 0) relay vt1=-1m vt2=1m ropen=ropen_mix rclosed=rclosed_mix
EMIXQ_c007_3_10 (mix_q_src_c007_3_10 0 bpf_c007_3 0) vcvs gain=-8.314696123025e-01
SMIXQ_c007_3_10 (mix_q_src_c007_3_10 mix_q_c007_3 win_3_10 0) relay vt1=-1m vt2=1m ropen=ropen_mix rclosed=rclosed_mix
EMIXI_c007_3_11 (mix_i_src_c007_3_11 0 bpf_c007_3 0) vcvs gain=-1.950903220161e-01
SMIXI_c007_3_11 (mix_i_src_c007_3_11 mix_i_c007_3 win_3_11 0) relay vt1=-1m vt2=1m ropen=ropen_mix rclosed=rclosed_mix
EMIXQ_c007_3_11 (mix_q_src_c007_3_11 0 bpf_c007_3 0) vcvs gain=-9.807852804032e-01
SMIXQ_c007_3_11 (mix_q_src_c007_3_11 mix_q_c007_3 win_3_11 0) relay vt1=-1m vt2=1m ropen=ropen_mix rclosed=rclosed_mix
EMIXI_c007_3_12 (mix_i_src_c007_3_12 0 bpf_c007_3 0) vcvs gain=1.950903220161e-01
SMIXI_c007_3_12 (mix_i_src_c007_3_12 mix_i_c007_3 win_3_12 0) relay vt1=-1m vt2=1m ropen=ropen_mix rclosed=rclosed_mix
EMIXQ_c007_3_12 (mix_q_src_c007_3_12 0 bpf_c007_3 0) vcvs gain=-9.807852804032e-01
SMIXQ_c007_3_12 (mix_q_src_c007_3_12 mix_q_c007_3 win_3_12 0) relay vt1=-1m vt2=1m ropen=ropen_mix rclosed=rclosed_mix
EMIXI_c007_3_13 (mix_i_src_c007_3_13 0 bpf_c007_3 0) vcvs gain=5.555702330196e-01
SMIXI_c007_3_13 (mix_i_src_c007_3_13 mix_i_c007_3 win_3_13 0) relay vt1=-1m vt2=1m ropen=ropen_mix rclosed=rclosed_mix
EMIXQ_c007_3_13 (mix_q_src_c007_3_13 0 bpf_c007_3 0) vcvs gain=-8.314696123025e-01
SMIXQ_c007_3_13 (mix_q_src_c007_3_13 mix_q_c007_3 win_3_13 0) relay vt1=-1m vt2=1m ropen=ropen_mix rclosed=rclosed_mix
EMIXI_c007_3_14 (mix_i_src_c007_3_14 0 bpf_c007_3 0) vcvs gain=8.314696123025e-01
SMIXI_c007_3_14 (mix_i_src_c007_3_14 mix_i_c007_3 win_3_14 0) relay vt1=-1m vt2=1m ropen=ropen_mix rclosed=rclosed_mix
EMIXQ_c007_3_14 (mix_q_src_c007_3_14 0 bpf_c007_3 0) vcvs gain=-5.555702330196e-01
SMIXQ_c007_3_14 (mix_q_src_c007_3_14 mix_q_c007_3 win_3_14 0) relay vt1=-1m vt2=1m ropen=ropen_mix rclosed=rclosed_mix
EMIXI_c007_3_15 (mix_i_src_c007_3_15 0 bpf_c007_3 0) vcvs gain=9.807852804032e-01
SMIXI_c007_3_15 (mix_i_src_c007_3_15 mix_i_c007_3 win_3_15 0) relay vt1=-1m vt2=1m ropen=ropen_mix rclosed=rclosed_mix
EMIXQ_c007_3_15 (mix_q_src_c007_3_15 0 bpf_c007_3 0) vcvs gain=-1.950903220161e-01
SMIXQ_c007_3_15 (mix_q_src_c007_3_15 mix_q_c007_3 win_3_15 0) relay vt1=-1m vt2=1m ropen=ropen_mix rclosed=rclosed_mix
RMIXI_c007_3 (mix_i_c007_3 0) resistor r=1G
RMIXQ_c007_3 (mix_q_c007_3 0) resistor r=1G
RINTI_c007_3 (mix_i_c007_3 Icar_c007_3) resistor r=1k
CINTI_c007_3 (Icar_c007_3 0) capacitor c=80p
RINTQ_c007_3 (mix_q_c007_3 Qcar_c007_3) resistor r=1k
CINTQ_c007_3 (Qcar_c007_3 0) capacitor c=80p
save bpf_c007_3 Icar_c007_3 Qcar_c007_3

// bl008, carrier_0: 250000000 Hz coherent I/Q phase-window verification-demod path
CBPF_c008_0 (bl008 n_cbpf_c008_0) capacitor c=4.052847345694e-13
LBPF_c008_0 (n_cbpf_c008_0 bpf_c008_0) inductor l=1.000000000000e-06
RBPF_c008_0 (bpf_c008_0 0) resistor r=7.853981633974e+01
EMIXI_c008_0_00 (mix_i_src_c008_0_00 0 bpf_c008_0 0) vcvs gain=9.807852804032e-01
SMIXI_c008_0_00 (mix_i_src_c008_0_00 mix_i_c008_0 win_0_00 0) relay vt1=-1m vt2=1m ropen=ropen_mix rclosed=rclosed_mix
EMIXQ_c008_0_00 (mix_q_src_c008_0_00 0 bpf_c008_0 0) vcvs gain=1.950903220161e-01
SMIXQ_c008_0_00 (mix_q_src_c008_0_00 mix_q_c008_0 win_0_00 0) relay vt1=-1m vt2=1m ropen=ropen_mix rclosed=rclosed_mix
EMIXI_c008_0_01 (mix_i_src_c008_0_01 0 bpf_c008_0 0) vcvs gain=8.314696123025e-01
SMIXI_c008_0_01 (mix_i_src_c008_0_01 mix_i_c008_0 win_0_01 0) relay vt1=-1m vt2=1m ropen=ropen_mix rclosed=rclosed_mix
EMIXQ_c008_0_01 (mix_q_src_c008_0_01 0 bpf_c008_0 0) vcvs gain=5.555702330196e-01
SMIXQ_c008_0_01 (mix_q_src_c008_0_01 mix_q_c008_0 win_0_01 0) relay vt1=-1m vt2=1m ropen=ropen_mix rclosed=rclosed_mix
EMIXI_c008_0_02 (mix_i_src_c008_0_02 0 bpf_c008_0 0) vcvs gain=5.555702330196e-01
SMIXI_c008_0_02 (mix_i_src_c008_0_02 mix_i_c008_0 win_0_02 0) relay vt1=-1m vt2=1m ropen=ropen_mix rclosed=rclosed_mix
EMIXQ_c008_0_02 (mix_q_src_c008_0_02 0 bpf_c008_0 0) vcvs gain=8.314696123025e-01
SMIXQ_c008_0_02 (mix_q_src_c008_0_02 mix_q_c008_0 win_0_02 0) relay vt1=-1m vt2=1m ropen=ropen_mix rclosed=rclosed_mix
EMIXI_c008_0_03 (mix_i_src_c008_0_03 0 bpf_c008_0 0) vcvs gain=1.950903220161e-01
SMIXI_c008_0_03 (mix_i_src_c008_0_03 mix_i_c008_0 win_0_03 0) relay vt1=-1m vt2=1m ropen=ropen_mix rclosed=rclosed_mix
EMIXQ_c008_0_03 (mix_q_src_c008_0_03 0 bpf_c008_0 0) vcvs gain=9.807852804032e-01
SMIXQ_c008_0_03 (mix_q_src_c008_0_03 mix_q_c008_0 win_0_03 0) relay vt1=-1m vt2=1m ropen=ropen_mix rclosed=rclosed_mix
EMIXI_c008_0_04 (mix_i_src_c008_0_04 0 bpf_c008_0 0) vcvs gain=-1.950903220161e-01
SMIXI_c008_0_04 (mix_i_src_c008_0_04 mix_i_c008_0 win_0_04 0) relay vt1=-1m vt2=1m ropen=ropen_mix rclosed=rclosed_mix
EMIXQ_c008_0_04 (mix_q_src_c008_0_04 0 bpf_c008_0 0) vcvs gain=9.807852804032e-01
SMIXQ_c008_0_04 (mix_q_src_c008_0_04 mix_q_c008_0 win_0_04 0) relay vt1=-1m vt2=1m ropen=ropen_mix rclosed=rclosed_mix
EMIXI_c008_0_05 (mix_i_src_c008_0_05 0 bpf_c008_0 0) vcvs gain=-5.555702330196e-01
SMIXI_c008_0_05 (mix_i_src_c008_0_05 mix_i_c008_0 win_0_05 0) relay vt1=-1m vt2=1m ropen=ropen_mix rclosed=rclosed_mix
EMIXQ_c008_0_05 (mix_q_src_c008_0_05 0 bpf_c008_0 0) vcvs gain=8.314696123025e-01
SMIXQ_c008_0_05 (mix_q_src_c008_0_05 mix_q_c008_0 win_0_05 0) relay vt1=-1m vt2=1m ropen=ropen_mix rclosed=rclosed_mix
EMIXI_c008_0_06 (mix_i_src_c008_0_06 0 bpf_c008_0 0) vcvs gain=-8.314696123025e-01
SMIXI_c008_0_06 (mix_i_src_c008_0_06 mix_i_c008_0 win_0_06 0) relay vt1=-1m vt2=1m ropen=ropen_mix rclosed=rclosed_mix
EMIXQ_c008_0_06 (mix_q_src_c008_0_06 0 bpf_c008_0 0) vcvs gain=5.555702330196e-01
SMIXQ_c008_0_06 (mix_q_src_c008_0_06 mix_q_c008_0 win_0_06 0) relay vt1=-1m vt2=1m ropen=ropen_mix rclosed=rclosed_mix
EMIXI_c008_0_07 (mix_i_src_c008_0_07 0 bpf_c008_0 0) vcvs gain=-9.807852804032e-01
SMIXI_c008_0_07 (mix_i_src_c008_0_07 mix_i_c008_0 win_0_07 0) relay vt1=-1m vt2=1m ropen=ropen_mix rclosed=rclosed_mix
EMIXQ_c008_0_07 (mix_q_src_c008_0_07 0 bpf_c008_0 0) vcvs gain=1.950903220161e-01
SMIXQ_c008_0_07 (mix_q_src_c008_0_07 mix_q_c008_0 win_0_07 0) relay vt1=-1m vt2=1m ropen=ropen_mix rclosed=rclosed_mix
EMIXI_c008_0_08 (mix_i_src_c008_0_08 0 bpf_c008_0 0) vcvs gain=-9.807852804032e-01
SMIXI_c008_0_08 (mix_i_src_c008_0_08 mix_i_c008_0 win_0_08 0) relay vt1=-1m vt2=1m ropen=ropen_mix rclosed=rclosed_mix
EMIXQ_c008_0_08 (mix_q_src_c008_0_08 0 bpf_c008_0 0) vcvs gain=-1.950903220161e-01
SMIXQ_c008_0_08 (mix_q_src_c008_0_08 mix_q_c008_0 win_0_08 0) relay vt1=-1m vt2=1m ropen=ropen_mix rclosed=rclosed_mix
EMIXI_c008_0_09 (mix_i_src_c008_0_09 0 bpf_c008_0 0) vcvs gain=-8.314696123025e-01
SMIXI_c008_0_09 (mix_i_src_c008_0_09 mix_i_c008_0 win_0_09 0) relay vt1=-1m vt2=1m ropen=ropen_mix rclosed=rclosed_mix
EMIXQ_c008_0_09 (mix_q_src_c008_0_09 0 bpf_c008_0 0) vcvs gain=-5.555702330196e-01
SMIXQ_c008_0_09 (mix_q_src_c008_0_09 mix_q_c008_0 win_0_09 0) relay vt1=-1m vt2=1m ropen=ropen_mix rclosed=rclosed_mix
EMIXI_c008_0_10 (mix_i_src_c008_0_10 0 bpf_c008_0 0) vcvs gain=-5.555702330196e-01
SMIXI_c008_0_10 (mix_i_src_c008_0_10 mix_i_c008_0 win_0_10 0) relay vt1=-1m vt2=1m ropen=ropen_mix rclosed=rclosed_mix
EMIXQ_c008_0_10 (mix_q_src_c008_0_10 0 bpf_c008_0 0) vcvs gain=-8.314696123025e-01
SMIXQ_c008_0_10 (mix_q_src_c008_0_10 mix_q_c008_0 win_0_10 0) relay vt1=-1m vt2=1m ropen=ropen_mix rclosed=rclosed_mix
EMIXI_c008_0_11 (mix_i_src_c008_0_11 0 bpf_c008_0 0) vcvs gain=-1.950903220161e-01
SMIXI_c008_0_11 (mix_i_src_c008_0_11 mix_i_c008_0 win_0_11 0) relay vt1=-1m vt2=1m ropen=ropen_mix rclosed=rclosed_mix
EMIXQ_c008_0_11 (mix_q_src_c008_0_11 0 bpf_c008_0 0) vcvs gain=-9.807852804032e-01
SMIXQ_c008_0_11 (mix_q_src_c008_0_11 mix_q_c008_0 win_0_11 0) relay vt1=-1m vt2=1m ropen=ropen_mix rclosed=rclosed_mix
EMIXI_c008_0_12 (mix_i_src_c008_0_12 0 bpf_c008_0 0) vcvs gain=1.950903220161e-01
SMIXI_c008_0_12 (mix_i_src_c008_0_12 mix_i_c008_0 win_0_12 0) relay vt1=-1m vt2=1m ropen=ropen_mix rclosed=rclosed_mix
EMIXQ_c008_0_12 (mix_q_src_c008_0_12 0 bpf_c008_0 0) vcvs gain=-9.807852804032e-01
SMIXQ_c008_0_12 (mix_q_src_c008_0_12 mix_q_c008_0 win_0_12 0) relay vt1=-1m vt2=1m ropen=ropen_mix rclosed=rclosed_mix
EMIXI_c008_0_13 (mix_i_src_c008_0_13 0 bpf_c008_0 0) vcvs gain=5.555702330196e-01
SMIXI_c008_0_13 (mix_i_src_c008_0_13 mix_i_c008_0 win_0_13 0) relay vt1=-1m vt2=1m ropen=ropen_mix rclosed=rclosed_mix
EMIXQ_c008_0_13 (mix_q_src_c008_0_13 0 bpf_c008_0 0) vcvs gain=-8.314696123025e-01
SMIXQ_c008_0_13 (mix_q_src_c008_0_13 mix_q_c008_0 win_0_13 0) relay vt1=-1m vt2=1m ropen=ropen_mix rclosed=rclosed_mix
EMIXI_c008_0_14 (mix_i_src_c008_0_14 0 bpf_c008_0 0) vcvs gain=8.314696123025e-01
SMIXI_c008_0_14 (mix_i_src_c008_0_14 mix_i_c008_0 win_0_14 0) relay vt1=-1m vt2=1m ropen=ropen_mix rclosed=rclosed_mix
EMIXQ_c008_0_14 (mix_q_src_c008_0_14 0 bpf_c008_0 0) vcvs gain=-5.555702330196e-01
SMIXQ_c008_0_14 (mix_q_src_c008_0_14 mix_q_c008_0 win_0_14 0) relay vt1=-1m vt2=1m ropen=ropen_mix rclosed=rclosed_mix
EMIXI_c008_0_15 (mix_i_src_c008_0_15 0 bpf_c008_0 0) vcvs gain=9.807852804032e-01
SMIXI_c008_0_15 (mix_i_src_c008_0_15 mix_i_c008_0 win_0_15 0) relay vt1=-1m vt2=1m ropen=ropen_mix rclosed=rclosed_mix
EMIXQ_c008_0_15 (mix_q_src_c008_0_15 0 bpf_c008_0 0) vcvs gain=-1.950903220161e-01
SMIXQ_c008_0_15 (mix_q_src_c008_0_15 mix_q_c008_0 win_0_15 0) relay vt1=-1m vt2=1m ropen=ropen_mix rclosed=rclosed_mix
RMIXI_c008_0 (mix_i_c008_0 0) resistor r=1G
RMIXQ_c008_0 (mix_q_c008_0 0) resistor r=1G
RINTI_c008_0 (mix_i_c008_0 Icar_c008_0) resistor r=1k
CINTI_c008_0 (Icar_c008_0 0) capacitor c=80p
RINTQ_c008_0 (mix_q_c008_0 Qcar_c008_0) resistor r=1k
CINTQ_c008_0 (Qcar_c008_0 0) capacitor c=80p
save bpf_c008_0 Icar_c008_0 Qcar_c008_0

// bl008, carrier_1: 500000000 Hz coherent I/Q phase-window verification-demod path
CBPF_c008_1 (bl008 n_cbpf_c008_1) capacitor c=1.013211836423e-13
LBPF_c008_1 (n_cbpf_c008_1 bpf_c008_1) inductor l=1.000000000000e-06
RBPF_c008_1 (bpf_c008_1 0) resistor r=1.570796326795e+02
EMIXI_c008_1_00 (mix_i_src_c008_1_00 0 bpf_c008_1 0) vcvs gain=9.807852804032e-01
SMIXI_c008_1_00 (mix_i_src_c008_1_00 mix_i_c008_1 win_1_00 0) relay vt1=-1m vt2=1m ropen=ropen_mix rclosed=rclosed_mix
EMIXQ_c008_1_00 (mix_q_src_c008_1_00 0 bpf_c008_1 0) vcvs gain=1.950903220161e-01
SMIXQ_c008_1_00 (mix_q_src_c008_1_00 mix_q_c008_1 win_1_00 0) relay vt1=-1m vt2=1m ropen=ropen_mix rclosed=rclosed_mix
EMIXI_c008_1_01 (mix_i_src_c008_1_01 0 bpf_c008_1 0) vcvs gain=8.314696123025e-01
SMIXI_c008_1_01 (mix_i_src_c008_1_01 mix_i_c008_1 win_1_01 0) relay vt1=-1m vt2=1m ropen=ropen_mix rclosed=rclosed_mix
EMIXQ_c008_1_01 (mix_q_src_c008_1_01 0 bpf_c008_1 0) vcvs gain=5.555702330196e-01
SMIXQ_c008_1_01 (mix_q_src_c008_1_01 mix_q_c008_1 win_1_01 0) relay vt1=-1m vt2=1m ropen=ropen_mix rclosed=rclosed_mix
EMIXI_c008_1_02 (mix_i_src_c008_1_02 0 bpf_c008_1 0) vcvs gain=5.555702330196e-01
SMIXI_c008_1_02 (mix_i_src_c008_1_02 mix_i_c008_1 win_1_02 0) relay vt1=-1m vt2=1m ropen=ropen_mix rclosed=rclosed_mix
EMIXQ_c008_1_02 (mix_q_src_c008_1_02 0 bpf_c008_1 0) vcvs gain=8.314696123025e-01
SMIXQ_c008_1_02 (mix_q_src_c008_1_02 mix_q_c008_1 win_1_02 0) relay vt1=-1m vt2=1m ropen=ropen_mix rclosed=rclosed_mix
EMIXI_c008_1_03 (mix_i_src_c008_1_03 0 bpf_c008_1 0) vcvs gain=1.950903220161e-01
SMIXI_c008_1_03 (mix_i_src_c008_1_03 mix_i_c008_1 win_1_03 0) relay vt1=-1m vt2=1m ropen=ropen_mix rclosed=rclosed_mix
EMIXQ_c008_1_03 (mix_q_src_c008_1_03 0 bpf_c008_1 0) vcvs gain=9.807852804032e-01
SMIXQ_c008_1_03 (mix_q_src_c008_1_03 mix_q_c008_1 win_1_03 0) relay vt1=-1m vt2=1m ropen=ropen_mix rclosed=rclosed_mix
EMIXI_c008_1_04 (mix_i_src_c008_1_04 0 bpf_c008_1 0) vcvs gain=-1.950903220161e-01
SMIXI_c008_1_04 (mix_i_src_c008_1_04 mix_i_c008_1 win_1_04 0) relay vt1=-1m vt2=1m ropen=ropen_mix rclosed=rclosed_mix
EMIXQ_c008_1_04 (mix_q_src_c008_1_04 0 bpf_c008_1 0) vcvs gain=9.807852804032e-01
SMIXQ_c008_1_04 (mix_q_src_c008_1_04 mix_q_c008_1 win_1_04 0) relay vt1=-1m vt2=1m ropen=ropen_mix rclosed=rclosed_mix
EMIXI_c008_1_05 (mix_i_src_c008_1_05 0 bpf_c008_1 0) vcvs gain=-5.555702330196e-01
SMIXI_c008_1_05 (mix_i_src_c008_1_05 mix_i_c008_1 win_1_05 0) relay vt1=-1m vt2=1m ropen=ropen_mix rclosed=rclosed_mix
EMIXQ_c008_1_05 (mix_q_src_c008_1_05 0 bpf_c008_1 0) vcvs gain=8.314696123025e-01
SMIXQ_c008_1_05 (mix_q_src_c008_1_05 mix_q_c008_1 win_1_05 0) relay vt1=-1m vt2=1m ropen=ropen_mix rclosed=rclosed_mix
EMIXI_c008_1_06 (mix_i_src_c008_1_06 0 bpf_c008_1 0) vcvs gain=-8.314696123025e-01
SMIXI_c008_1_06 (mix_i_src_c008_1_06 mix_i_c008_1 win_1_06 0) relay vt1=-1m vt2=1m ropen=ropen_mix rclosed=rclosed_mix
EMIXQ_c008_1_06 (mix_q_src_c008_1_06 0 bpf_c008_1 0) vcvs gain=5.555702330196e-01
SMIXQ_c008_1_06 (mix_q_src_c008_1_06 mix_q_c008_1 win_1_06 0) relay vt1=-1m vt2=1m ropen=ropen_mix rclosed=rclosed_mix
EMIXI_c008_1_07 (mix_i_src_c008_1_07 0 bpf_c008_1 0) vcvs gain=-9.807852804032e-01
SMIXI_c008_1_07 (mix_i_src_c008_1_07 mix_i_c008_1 win_1_07 0) relay vt1=-1m vt2=1m ropen=ropen_mix rclosed=rclosed_mix
EMIXQ_c008_1_07 (mix_q_src_c008_1_07 0 bpf_c008_1 0) vcvs gain=1.950903220161e-01
SMIXQ_c008_1_07 (mix_q_src_c008_1_07 mix_q_c008_1 win_1_07 0) relay vt1=-1m vt2=1m ropen=ropen_mix rclosed=rclosed_mix
EMIXI_c008_1_08 (mix_i_src_c008_1_08 0 bpf_c008_1 0) vcvs gain=-9.807852804032e-01
SMIXI_c008_1_08 (mix_i_src_c008_1_08 mix_i_c008_1 win_1_08 0) relay vt1=-1m vt2=1m ropen=ropen_mix rclosed=rclosed_mix
EMIXQ_c008_1_08 (mix_q_src_c008_1_08 0 bpf_c008_1 0) vcvs gain=-1.950903220161e-01
SMIXQ_c008_1_08 (mix_q_src_c008_1_08 mix_q_c008_1 win_1_08 0) relay vt1=-1m vt2=1m ropen=ropen_mix rclosed=rclosed_mix
EMIXI_c008_1_09 (mix_i_src_c008_1_09 0 bpf_c008_1 0) vcvs gain=-8.314696123025e-01
SMIXI_c008_1_09 (mix_i_src_c008_1_09 mix_i_c008_1 win_1_09 0) relay vt1=-1m vt2=1m ropen=ropen_mix rclosed=rclosed_mix
EMIXQ_c008_1_09 (mix_q_src_c008_1_09 0 bpf_c008_1 0) vcvs gain=-5.555702330196e-01
SMIXQ_c008_1_09 (mix_q_src_c008_1_09 mix_q_c008_1 win_1_09 0) relay vt1=-1m vt2=1m ropen=ropen_mix rclosed=rclosed_mix
EMIXI_c008_1_10 (mix_i_src_c008_1_10 0 bpf_c008_1 0) vcvs gain=-5.555702330196e-01
SMIXI_c008_1_10 (mix_i_src_c008_1_10 mix_i_c008_1 win_1_10 0) relay vt1=-1m vt2=1m ropen=ropen_mix rclosed=rclosed_mix
EMIXQ_c008_1_10 (mix_q_src_c008_1_10 0 bpf_c008_1 0) vcvs gain=-8.314696123025e-01
SMIXQ_c008_1_10 (mix_q_src_c008_1_10 mix_q_c008_1 win_1_10 0) relay vt1=-1m vt2=1m ropen=ropen_mix rclosed=rclosed_mix
EMIXI_c008_1_11 (mix_i_src_c008_1_11 0 bpf_c008_1 0) vcvs gain=-1.950903220161e-01
SMIXI_c008_1_11 (mix_i_src_c008_1_11 mix_i_c008_1 win_1_11 0) relay vt1=-1m vt2=1m ropen=ropen_mix rclosed=rclosed_mix
EMIXQ_c008_1_11 (mix_q_src_c008_1_11 0 bpf_c008_1 0) vcvs gain=-9.807852804032e-01
SMIXQ_c008_1_11 (mix_q_src_c008_1_11 mix_q_c008_1 win_1_11 0) relay vt1=-1m vt2=1m ropen=ropen_mix rclosed=rclosed_mix
EMIXI_c008_1_12 (mix_i_src_c008_1_12 0 bpf_c008_1 0) vcvs gain=1.950903220161e-01
SMIXI_c008_1_12 (mix_i_src_c008_1_12 mix_i_c008_1 win_1_12 0) relay vt1=-1m vt2=1m ropen=ropen_mix rclosed=rclosed_mix
EMIXQ_c008_1_12 (mix_q_src_c008_1_12 0 bpf_c008_1 0) vcvs gain=-9.807852804032e-01
SMIXQ_c008_1_12 (mix_q_src_c008_1_12 mix_q_c008_1 win_1_12 0) relay vt1=-1m vt2=1m ropen=ropen_mix rclosed=rclosed_mix
EMIXI_c008_1_13 (mix_i_src_c008_1_13 0 bpf_c008_1 0) vcvs gain=5.555702330196e-01
SMIXI_c008_1_13 (mix_i_src_c008_1_13 mix_i_c008_1 win_1_13 0) relay vt1=-1m vt2=1m ropen=ropen_mix rclosed=rclosed_mix
EMIXQ_c008_1_13 (mix_q_src_c008_1_13 0 bpf_c008_1 0) vcvs gain=-8.314696123025e-01
SMIXQ_c008_1_13 (mix_q_src_c008_1_13 mix_q_c008_1 win_1_13 0) relay vt1=-1m vt2=1m ropen=ropen_mix rclosed=rclosed_mix
EMIXI_c008_1_14 (mix_i_src_c008_1_14 0 bpf_c008_1 0) vcvs gain=8.314696123025e-01
SMIXI_c008_1_14 (mix_i_src_c008_1_14 mix_i_c008_1 win_1_14 0) relay vt1=-1m vt2=1m ropen=ropen_mix rclosed=rclosed_mix
EMIXQ_c008_1_14 (mix_q_src_c008_1_14 0 bpf_c008_1 0) vcvs gain=-5.555702330196e-01
SMIXQ_c008_1_14 (mix_q_src_c008_1_14 mix_q_c008_1 win_1_14 0) relay vt1=-1m vt2=1m ropen=ropen_mix rclosed=rclosed_mix
EMIXI_c008_1_15 (mix_i_src_c008_1_15 0 bpf_c008_1 0) vcvs gain=9.807852804032e-01
SMIXI_c008_1_15 (mix_i_src_c008_1_15 mix_i_c008_1 win_1_15 0) relay vt1=-1m vt2=1m ropen=ropen_mix rclosed=rclosed_mix
EMIXQ_c008_1_15 (mix_q_src_c008_1_15 0 bpf_c008_1 0) vcvs gain=-1.950903220161e-01
SMIXQ_c008_1_15 (mix_q_src_c008_1_15 mix_q_c008_1 win_1_15 0) relay vt1=-1m vt2=1m ropen=ropen_mix rclosed=rclosed_mix
RMIXI_c008_1 (mix_i_c008_1 0) resistor r=1G
RMIXQ_c008_1 (mix_q_c008_1 0) resistor r=1G
RINTI_c008_1 (mix_i_c008_1 Icar_c008_1) resistor r=1k
CINTI_c008_1 (Icar_c008_1 0) capacitor c=80p
RINTQ_c008_1 (mix_q_c008_1 Qcar_c008_1) resistor r=1k
CINTQ_c008_1 (Qcar_c008_1 0) capacitor c=80p
save bpf_c008_1 Icar_c008_1 Qcar_c008_1

// bl008, carrier_2: 750000000 Hz coherent I/Q phase-window verification-demod path
CBPF_c008_2 (bl008 n_cbpf_c008_2) capacitor c=4.503163717437e-14
LBPF_c008_2 (n_cbpf_c008_2 bpf_c008_2) inductor l=1.000000000000e-06
RBPF_c008_2 (bpf_c008_2 0) resistor r=2.356194490192e+02
EMIXI_c008_2_00 (mix_i_src_c008_2_00 0 bpf_c008_2 0) vcvs gain=9.807852804032e-01
SMIXI_c008_2_00 (mix_i_src_c008_2_00 mix_i_c008_2 win_2_00 0) relay vt1=-1m vt2=1m ropen=ropen_mix rclosed=rclosed_mix
EMIXQ_c008_2_00 (mix_q_src_c008_2_00 0 bpf_c008_2 0) vcvs gain=1.950903220161e-01
SMIXQ_c008_2_00 (mix_q_src_c008_2_00 mix_q_c008_2 win_2_00 0) relay vt1=-1m vt2=1m ropen=ropen_mix rclosed=rclosed_mix
EMIXI_c008_2_01 (mix_i_src_c008_2_01 0 bpf_c008_2 0) vcvs gain=8.314696123025e-01
SMIXI_c008_2_01 (mix_i_src_c008_2_01 mix_i_c008_2 win_2_01 0) relay vt1=-1m vt2=1m ropen=ropen_mix rclosed=rclosed_mix
EMIXQ_c008_2_01 (mix_q_src_c008_2_01 0 bpf_c008_2 0) vcvs gain=5.555702330196e-01
SMIXQ_c008_2_01 (mix_q_src_c008_2_01 mix_q_c008_2 win_2_01 0) relay vt1=-1m vt2=1m ropen=ropen_mix rclosed=rclosed_mix
EMIXI_c008_2_02 (mix_i_src_c008_2_02 0 bpf_c008_2 0) vcvs gain=5.555702330196e-01
SMIXI_c008_2_02 (mix_i_src_c008_2_02 mix_i_c008_2 win_2_02 0) relay vt1=-1m vt2=1m ropen=ropen_mix rclosed=rclosed_mix
EMIXQ_c008_2_02 (mix_q_src_c008_2_02 0 bpf_c008_2 0) vcvs gain=8.314696123025e-01
SMIXQ_c008_2_02 (mix_q_src_c008_2_02 mix_q_c008_2 win_2_02 0) relay vt1=-1m vt2=1m ropen=ropen_mix rclosed=rclosed_mix
EMIXI_c008_2_03 (mix_i_src_c008_2_03 0 bpf_c008_2 0) vcvs gain=1.950903220161e-01
SMIXI_c008_2_03 (mix_i_src_c008_2_03 mix_i_c008_2 win_2_03 0) relay vt1=-1m vt2=1m ropen=ropen_mix rclosed=rclosed_mix
EMIXQ_c008_2_03 (mix_q_src_c008_2_03 0 bpf_c008_2 0) vcvs gain=9.807852804032e-01
SMIXQ_c008_2_03 (mix_q_src_c008_2_03 mix_q_c008_2 win_2_03 0) relay vt1=-1m vt2=1m ropen=ropen_mix rclosed=rclosed_mix
EMIXI_c008_2_04 (mix_i_src_c008_2_04 0 bpf_c008_2 0) vcvs gain=-1.950903220161e-01
SMIXI_c008_2_04 (mix_i_src_c008_2_04 mix_i_c008_2 win_2_04 0) relay vt1=-1m vt2=1m ropen=ropen_mix rclosed=rclosed_mix
EMIXQ_c008_2_04 (mix_q_src_c008_2_04 0 bpf_c008_2 0) vcvs gain=9.807852804032e-01
SMIXQ_c008_2_04 (mix_q_src_c008_2_04 mix_q_c008_2 win_2_04 0) relay vt1=-1m vt2=1m ropen=ropen_mix rclosed=rclosed_mix
EMIXI_c008_2_05 (mix_i_src_c008_2_05 0 bpf_c008_2 0) vcvs gain=-5.555702330196e-01
SMIXI_c008_2_05 (mix_i_src_c008_2_05 mix_i_c008_2 win_2_05 0) relay vt1=-1m vt2=1m ropen=ropen_mix rclosed=rclosed_mix
EMIXQ_c008_2_05 (mix_q_src_c008_2_05 0 bpf_c008_2 0) vcvs gain=8.314696123025e-01
SMIXQ_c008_2_05 (mix_q_src_c008_2_05 mix_q_c008_2 win_2_05 0) relay vt1=-1m vt2=1m ropen=ropen_mix rclosed=rclosed_mix
EMIXI_c008_2_06 (mix_i_src_c008_2_06 0 bpf_c008_2 0) vcvs gain=-8.314696123025e-01
SMIXI_c008_2_06 (mix_i_src_c008_2_06 mix_i_c008_2 win_2_06 0) relay vt1=-1m vt2=1m ropen=ropen_mix rclosed=rclosed_mix
EMIXQ_c008_2_06 (mix_q_src_c008_2_06 0 bpf_c008_2 0) vcvs gain=5.555702330196e-01
SMIXQ_c008_2_06 (mix_q_src_c008_2_06 mix_q_c008_2 win_2_06 0) relay vt1=-1m vt2=1m ropen=ropen_mix rclosed=rclosed_mix
EMIXI_c008_2_07 (mix_i_src_c008_2_07 0 bpf_c008_2 0) vcvs gain=-9.807852804032e-01
SMIXI_c008_2_07 (mix_i_src_c008_2_07 mix_i_c008_2 win_2_07 0) relay vt1=-1m vt2=1m ropen=ropen_mix rclosed=rclosed_mix
EMIXQ_c008_2_07 (mix_q_src_c008_2_07 0 bpf_c008_2 0) vcvs gain=1.950903220161e-01
SMIXQ_c008_2_07 (mix_q_src_c008_2_07 mix_q_c008_2 win_2_07 0) relay vt1=-1m vt2=1m ropen=ropen_mix rclosed=rclosed_mix
EMIXI_c008_2_08 (mix_i_src_c008_2_08 0 bpf_c008_2 0) vcvs gain=-9.807852804032e-01
SMIXI_c008_2_08 (mix_i_src_c008_2_08 mix_i_c008_2 win_2_08 0) relay vt1=-1m vt2=1m ropen=ropen_mix rclosed=rclosed_mix
EMIXQ_c008_2_08 (mix_q_src_c008_2_08 0 bpf_c008_2 0) vcvs gain=-1.950903220161e-01
SMIXQ_c008_2_08 (mix_q_src_c008_2_08 mix_q_c008_2 win_2_08 0) relay vt1=-1m vt2=1m ropen=ropen_mix rclosed=rclosed_mix
EMIXI_c008_2_09 (mix_i_src_c008_2_09 0 bpf_c008_2 0) vcvs gain=-8.314696123025e-01
SMIXI_c008_2_09 (mix_i_src_c008_2_09 mix_i_c008_2 win_2_09 0) relay vt1=-1m vt2=1m ropen=ropen_mix rclosed=rclosed_mix
EMIXQ_c008_2_09 (mix_q_src_c008_2_09 0 bpf_c008_2 0) vcvs gain=-5.555702330196e-01
SMIXQ_c008_2_09 (mix_q_src_c008_2_09 mix_q_c008_2 win_2_09 0) relay vt1=-1m vt2=1m ropen=ropen_mix rclosed=rclosed_mix
EMIXI_c008_2_10 (mix_i_src_c008_2_10 0 bpf_c008_2 0) vcvs gain=-5.555702330196e-01
SMIXI_c008_2_10 (mix_i_src_c008_2_10 mix_i_c008_2 win_2_10 0) relay vt1=-1m vt2=1m ropen=ropen_mix rclosed=rclosed_mix
EMIXQ_c008_2_10 (mix_q_src_c008_2_10 0 bpf_c008_2 0) vcvs gain=-8.314696123025e-01
SMIXQ_c008_2_10 (mix_q_src_c008_2_10 mix_q_c008_2 win_2_10 0) relay vt1=-1m vt2=1m ropen=ropen_mix rclosed=rclosed_mix
EMIXI_c008_2_11 (mix_i_src_c008_2_11 0 bpf_c008_2 0) vcvs gain=-1.950903220161e-01
SMIXI_c008_2_11 (mix_i_src_c008_2_11 mix_i_c008_2 win_2_11 0) relay vt1=-1m vt2=1m ropen=ropen_mix rclosed=rclosed_mix
EMIXQ_c008_2_11 (mix_q_src_c008_2_11 0 bpf_c008_2 0) vcvs gain=-9.807852804032e-01
SMIXQ_c008_2_11 (mix_q_src_c008_2_11 mix_q_c008_2 win_2_11 0) relay vt1=-1m vt2=1m ropen=ropen_mix rclosed=rclosed_mix
EMIXI_c008_2_12 (mix_i_src_c008_2_12 0 bpf_c008_2 0) vcvs gain=1.950903220161e-01
SMIXI_c008_2_12 (mix_i_src_c008_2_12 mix_i_c008_2 win_2_12 0) relay vt1=-1m vt2=1m ropen=ropen_mix rclosed=rclosed_mix
EMIXQ_c008_2_12 (mix_q_src_c008_2_12 0 bpf_c008_2 0) vcvs gain=-9.807852804032e-01
SMIXQ_c008_2_12 (mix_q_src_c008_2_12 mix_q_c008_2 win_2_12 0) relay vt1=-1m vt2=1m ropen=ropen_mix rclosed=rclosed_mix
EMIXI_c008_2_13 (mix_i_src_c008_2_13 0 bpf_c008_2 0) vcvs gain=5.555702330196e-01
SMIXI_c008_2_13 (mix_i_src_c008_2_13 mix_i_c008_2 win_2_13 0) relay vt1=-1m vt2=1m ropen=ropen_mix rclosed=rclosed_mix
EMIXQ_c008_2_13 (mix_q_src_c008_2_13 0 bpf_c008_2 0) vcvs gain=-8.314696123025e-01
SMIXQ_c008_2_13 (mix_q_src_c008_2_13 mix_q_c008_2 win_2_13 0) relay vt1=-1m vt2=1m ropen=ropen_mix rclosed=rclosed_mix
EMIXI_c008_2_14 (mix_i_src_c008_2_14 0 bpf_c008_2 0) vcvs gain=8.314696123025e-01
SMIXI_c008_2_14 (mix_i_src_c008_2_14 mix_i_c008_2 win_2_14 0) relay vt1=-1m vt2=1m ropen=ropen_mix rclosed=rclosed_mix
EMIXQ_c008_2_14 (mix_q_src_c008_2_14 0 bpf_c008_2 0) vcvs gain=-5.555702330196e-01
SMIXQ_c008_2_14 (mix_q_src_c008_2_14 mix_q_c008_2 win_2_14 0) relay vt1=-1m vt2=1m ropen=ropen_mix rclosed=rclosed_mix
EMIXI_c008_2_15 (mix_i_src_c008_2_15 0 bpf_c008_2 0) vcvs gain=9.807852804032e-01
SMIXI_c008_2_15 (mix_i_src_c008_2_15 mix_i_c008_2 win_2_15 0) relay vt1=-1m vt2=1m ropen=ropen_mix rclosed=rclosed_mix
EMIXQ_c008_2_15 (mix_q_src_c008_2_15 0 bpf_c008_2 0) vcvs gain=-1.950903220161e-01
SMIXQ_c008_2_15 (mix_q_src_c008_2_15 mix_q_c008_2 win_2_15 0) relay vt1=-1m vt2=1m ropen=ropen_mix rclosed=rclosed_mix
RMIXI_c008_2 (mix_i_c008_2 0) resistor r=1G
RMIXQ_c008_2 (mix_q_c008_2 0) resistor r=1G
RINTI_c008_2 (mix_i_c008_2 Icar_c008_2) resistor r=1k
CINTI_c008_2 (Icar_c008_2 0) capacitor c=80p
RINTQ_c008_2 (mix_q_c008_2 Qcar_c008_2) resistor r=1k
CINTQ_c008_2 (Qcar_c008_2 0) capacitor c=80p
save bpf_c008_2 Icar_c008_2 Qcar_c008_2

// bl008, carrier_3: 1000000000 Hz coherent I/Q phase-window verification-demod path
CBPF_c008_3 (bl008 n_cbpf_c008_3) capacitor c=2.533029591058e-14
LBPF_c008_3 (n_cbpf_c008_3 bpf_c008_3) inductor l=1.000000000000e-06
RBPF_c008_3 (bpf_c008_3 0) resistor r=3.141592653590e+02
EMIXI_c008_3_00 (mix_i_src_c008_3_00 0 bpf_c008_3 0) vcvs gain=9.807852804032e-01
SMIXI_c008_3_00 (mix_i_src_c008_3_00 mix_i_c008_3 win_3_00 0) relay vt1=-1m vt2=1m ropen=ropen_mix rclosed=rclosed_mix
EMIXQ_c008_3_00 (mix_q_src_c008_3_00 0 bpf_c008_3 0) vcvs gain=1.950903220161e-01
SMIXQ_c008_3_00 (mix_q_src_c008_3_00 mix_q_c008_3 win_3_00 0) relay vt1=-1m vt2=1m ropen=ropen_mix rclosed=rclosed_mix
EMIXI_c008_3_01 (mix_i_src_c008_3_01 0 bpf_c008_3 0) vcvs gain=8.314696123025e-01
SMIXI_c008_3_01 (mix_i_src_c008_3_01 mix_i_c008_3 win_3_01 0) relay vt1=-1m vt2=1m ropen=ropen_mix rclosed=rclosed_mix
EMIXQ_c008_3_01 (mix_q_src_c008_3_01 0 bpf_c008_3 0) vcvs gain=5.555702330196e-01
SMIXQ_c008_3_01 (mix_q_src_c008_3_01 mix_q_c008_3 win_3_01 0) relay vt1=-1m vt2=1m ropen=ropen_mix rclosed=rclosed_mix
EMIXI_c008_3_02 (mix_i_src_c008_3_02 0 bpf_c008_3 0) vcvs gain=5.555702330196e-01
SMIXI_c008_3_02 (mix_i_src_c008_3_02 mix_i_c008_3 win_3_02 0) relay vt1=-1m vt2=1m ropen=ropen_mix rclosed=rclosed_mix
EMIXQ_c008_3_02 (mix_q_src_c008_3_02 0 bpf_c008_3 0) vcvs gain=8.314696123025e-01
SMIXQ_c008_3_02 (mix_q_src_c008_3_02 mix_q_c008_3 win_3_02 0) relay vt1=-1m vt2=1m ropen=ropen_mix rclosed=rclosed_mix
EMIXI_c008_3_03 (mix_i_src_c008_3_03 0 bpf_c008_3 0) vcvs gain=1.950903220161e-01
SMIXI_c008_3_03 (mix_i_src_c008_3_03 mix_i_c008_3 win_3_03 0) relay vt1=-1m vt2=1m ropen=ropen_mix rclosed=rclosed_mix
EMIXQ_c008_3_03 (mix_q_src_c008_3_03 0 bpf_c008_3 0) vcvs gain=9.807852804032e-01
SMIXQ_c008_3_03 (mix_q_src_c008_3_03 mix_q_c008_3 win_3_03 0) relay vt1=-1m vt2=1m ropen=ropen_mix rclosed=rclosed_mix
EMIXI_c008_3_04 (mix_i_src_c008_3_04 0 bpf_c008_3 0) vcvs gain=-1.950903220161e-01
SMIXI_c008_3_04 (mix_i_src_c008_3_04 mix_i_c008_3 win_3_04 0) relay vt1=-1m vt2=1m ropen=ropen_mix rclosed=rclosed_mix
EMIXQ_c008_3_04 (mix_q_src_c008_3_04 0 bpf_c008_3 0) vcvs gain=9.807852804032e-01
SMIXQ_c008_3_04 (mix_q_src_c008_3_04 mix_q_c008_3 win_3_04 0) relay vt1=-1m vt2=1m ropen=ropen_mix rclosed=rclosed_mix
EMIXI_c008_3_05 (mix_i_src_c008_3_05 0 bpf_c008_3 0) vcvs gain=-5.555702330196e-01
SMIXI_c008_3_05 (mix_i_src_c008_3_05 mix_i_c008_3 win_3_05 0) relay vt1=-1m vt2=1m ropen=ropen_mix rclosed=rclosed_mix
EMIXQ_c008_3_05 (mix_q_src_c008_3_05 0 bpf_c008_3 0) vcvs gain=8.314696123025e-01
SMIXQ_c008_3_05 (mix_q_src_c008_3_05 mix_q_c008_3 win_3_05 0) relay vt1=-1m vt2=1m ropen=ropen_mix rclosed=rclosed_mix
EMIXI_c008_3_06 (mix_i_src_c008_3_06 0 bpf_c008_3 0) vcvs gain=-8.314696123025e-01
SMIXI_c008_3_06 (mix_i_src_c008_3_06 mix_i_c008_3 win_3_06 0) relay vt1=-1m vt2=1m ropen=ropen_mix rclosed=rclosed_mix
EMIXQ_c008_3_06 (mix_q_src_c008_3_06 0 bpf_c008_3 0) vcvs gain=5.555702330196e-01
SMIXQ_c008_3_06 (mix_q_src_c008_3_06 mix_q_c008_3 win_3_06 0) relay vt1=-1m vt2=1m ropen=ropen_mix rclosed=rclosed_mix
EMIXI_c008_3_07 (mix_i_src_c008_3_07 0 bpf_c008_3 0) vcvs gain=-9.807852804032e-01
SMIXI_c008_3_07 (mix_i_src_c008_3_07 mix_i_c008_3 win_3_07 0) relay vt1=-1m vt2=1m ropen=ropen_mix rclosed=rclosed_mix
EMIXQ_c008_3_07 (mix_q_src_c008_3_07 0 bpf_c008_3 0) vcvs gain=1.950903220161e-01
SMIXQ_c008_3_07 (mix_q_src_c008_3_07 mix_q_c008_3 win_3_07 0) relay vt1=-1m vt2=1m ropen=ropen_mix rclosed=rclosed_mix
EMIXI_c008_3_08 (mix_i_src_c008_3_08 0 bpf_c008_3 0) vcvs gain=-9.807852804032e-01
SMIXI_c008_3_08 (mix_i_src_c008_3_08 mix_i_c008_3 win_3_08 0) relay vt1=-1m vt2=1m ropen=ropen_mix rclosed=rclosed_mix
EMIXQ_c008_3_08 (mix_q_src_c008_3_08 0 bpf_c008_3 0) vcvs gain=-1.950903220161e-01
SMIXQ_c008_3_08 (mix_q_src_c008_3_08 mix_q_c008_3 win_3_08 0) relay vt1=-1m vt2=1m ropen=ropen_mix rclosed=rclosed_mix
EMIXI_c008_3_09 (mix_i_src_c008_3_09 0 bpf_c008_3 0) vcvs gain=-8.314696123025e-01
SMIXI_c008_3_09 (mix_i_src_c008_3_09 mix_i_c008_3 win_3_09 0) relay vt1=-1m vt2=1m ropen=ropen_mix rclosed=rclosed_mix
EMIXQ_c008_3_09 (mix_q_src_c008_3_09 0 bpf_c008_3 0) vcvs gain=-5.555702330196e-01
SMIXQ_c008_3_09 (mix_q_src_c008_3_09 mix_q_c008_3 win_3_09 0) relay vt1=-1m vt2=1m ropen=ropen_mix rclosed=rclosed_mix
EMIXI_c008_3_10 (mix_i_src_c008_3_10 0 bpf_c008_3 0) vcvs gain=-5.555702330196e-01
SMIXI_c008_3_10 (mix_i_src_c008_3_10 mix_i_c008_3 win_3_10 0) relay vt1=-1m vt2=1m ropen=ropen_mix rclosed=rclosed_mix
EMIXQ_c008_3_10 (mix_q_src_c008_3_10 0 bpf_c008_3 0) vcvs gain=-8.314696123025e-01
SMIXQ_c008_3_10 (mix_q_src_c008_3_10 mix_q_c008_3 win_3_10 0) relay vt1=-1m vt2=1m ropen=ropen_mix rclosed=rclosed_mix
EMIXI_c008_3_11 (mix_i_src_c008_3_11 0 bpf_c008_3 0) vcvs gain=-1.950903220161e-01
SMIXI_c008_3_11 (mix_i_src_c008_3_11 mix_i_c008_3 win_3_11 0) relay vt1=-1m vt2=1m ropen=ropen_mix rclosed=rclosed_mix
EMIXQ_c008_3_11 (mix_q_src_c008_3_11 0 bpf_c008_3 0) vcvs gain=-9.807852804032e-01
SMIXQ_c008_3_11 (mix_q_src_c008_3_11 mix_q_c008_3 win_3_11 0) relay vt1=-1m vt2=1m ropen=ropen_mix rclosed=rclosed_mix
EMIXI_c008_3_12 (mix_i_src_c008_3_12 0 bpf_c008_3 0) vcvs gain=1.950903220161e-01
SMIXI_c008_3_12 (mix_i_src_c008_3_12 mix_i_c008_3 win_3_12 0) relay vt1=-1m vt2=1m ropen=ropen_mix rclosed=rclosed_mix
EMIXQ_c008_3_12 (mix_q_src_c008_3_12 0 bpf_c008_3 0) vcvs gain=-9.807852804032e-01
SMIXQ_c008_3_12 (mix_q_src_c008_3_12 mix_q_c008_3 win_3_12 0) relay vt1=-1m vt2=1m ropen=ropen_mix rclosed=rclosed_mix
EMIXI_c008_3_13 (mix_i_src_c008_3_13 0 bpf_c008_3 0) vcvs gain=5.555702330196e-01
SMIXI_c008_3_13 (mix_i_src_c008_3_13 mix_i_c008_3 win_3_13 0) relay vt1=-1m vt2=1m ropen=ropen_mix rclosed=rclosed_mix
EMIXQ_c008_3_13 (mix_q_src_c008_3_13 0 bpf_c008_3 0) vcvs gain=-8.314696123025e-01
SMIXQ_c008_3_13 (mix_q_src_c008_3_13 mix_q_c008_3 win_3_13 0) relay vt1=-1m vt2=1m ropen=ropen_mix rclosed=rclosed_mix
EMIXI_c008_3_14 (mix_i_src_c008_3_14 0 bpf_c008_3 0) vcvs gain=8.314696123025e-01
SMIXI_c008_3_14 (mix_i_src_c008_3_14 mix_i_c008_3 win_3_14 0) relay vt1=-1m vt2=1m ropen=ropen_mix rclosed=rclosed_mix
EMIXQ_c008_3_14 (mix_q_src_c008_3_14 0 bpf_c008_3 0) vcvs gain=-5.555702330196e-01
SMIXQ_c008_3_14 (mix_q_src_c008_3_14 mix_q_c008_3 win_3_14 0) relay vt1=-1m vt2=1m ropen=ropen_mix rclosed=rclosed_mix
EMIXI_c008_3_15 (mix_i_src_c008_3_15 0 bpf_c008_3 0) vcvs gain=9.807852804032e-01
SMIXI_c008_3_15 (mix_i_src_c008_3_15 mix_i_c008_3 win_3_15 0) relay vt1=-1m vt2=1m ropen=ropen_mix rclosed=rclosed_mix
EMIXQ_c008_3_15 (mix_q_src_c008_3_15 0 bpf_c008_3 0) vcvs gain=-1.950903220161e-01
SMIXQ_c008_3_15 (mix_q_src_c008_3_15 mix_q_c008_3 win_3_15 0) relay vt1=-1m vt2=1m ropen=ropen_mix rclosed=rclosed_mix
RMIXI_c008_3 (mix_i_c008_3 0) resistor r=1G
RMIXQ_c008_3 (mix_q_c008_3 0) resistor r=1G
RINTI_c008_3 (mix_i_c008_3 Icar_c008_3) resistor r=1k
CINTI_c008_3 (Icar_c008_3 0) capacitor c=80p
RINTQ_c008_3 (mix_q_c008_3 Qcar_c008_3) resistor r=1k
CINTQ_c008_3 (Qcar_c008_3 0) capacitor c=80p
save bpf_c008_3 Icar_c008_3 Qcar_c008_3

// bl009, carrier_0: 250000000 Hz coherent I/Q phase-window verification-demod path
CBPF_c009_0 (bl009 n_cbpf_c009_0) capacitor c=4.052847345694e-13
LBPF_c009_0 (n_cbpf_c009_0 bpf_c009_0) inductor l=1.000000000000e-06
RBPF_c009_0 (bpf_c009_0 0) resistor r=7.853981633974e+01
EMIXI_c009_0_00 (mix_i_src_c009_0_00 0 bpf_c009_0 0) vcvs gain=9.807852804032e-01
SMIXI_c009_0_00 (mix_i_src_c009_0_00 mix_i_c009_0 win_0_00 0) relay vt1=-1m vt2=1m ropen=ropen_mix rclosed=rclosed_mix
EMIXQ_c009_0_00 (mix_q_src_c009_0_00 0 bpf_c009_0 0) vcvs gain=1.950903220161e-01
SMIXQ_c009_0_00 (mix_q_src_c009_0_00 mix_q_c009_0 win_0_00 0) relay vt1=-1m vt2=1m ropen=ropen_mix rclosed=rclosed_mix
EMIXI_c009_0_01 (mix_i_src_c009_0_01 0 bpf_c009_0 0) vcvs gain=8.314696123025e-01
SMIXI_c009_0_01 (mix_i_src_c009_0_01 mix_i_c009_0 win_0_01 0) relay vt1=-1m vt2=1m ropen=ropen_mix rclosed=rclosed_mix
EMIXQ_c009_0_01 (mix_q_src_c009_0_01 0 bpf_c009_0 0) vcvs gain=5.555702330196e-01
SMIXQ_c009_0_01 (mix_q_src_c009_0_01 mix_q_c009_0 win_0_01 0) relay vt1=-1m vt2=1m ropen=ropen_mix rclosed=rclosed_mix
EMIXI_c009_0_02 (mix_i_src_c009_0_02 0 bpf_c009_0 0) vcvs gain=5.555702330196e-01
SMIXI_c009_0_02 (mix_i_src_c009_0_02 mix_i_c009_0 win_0_02 0) relay vt1=-1m vt2=1m ropen=ropen_mix rclosed=rclosed_mix
EMIXQ_c009_0_02 (mix_q_src_c009_0_02 0 bpf_c009_0 0) vcvs gain=8.314696123025e-01
SMIXQ_c009_0_02 (mix_q_src_c009_0_02 mix_q_c009_0 win_0_02 0) relay vt1=-1m vt2=1m ropen=ropen_mix rclosed=rclosed_mix
EMIXI_c009_0_03 (mix_i_src_c009_0_03 0 bpf_c009_0 0) vcvs gain=1.950903220161e-01
SMIXI_c009_0_03 (mix_i_src_c009_0_03 mix_i_c009_0 win_0_03 0) relay vt1=-1m vt2=1m ropen=ropen_mix rclosed=rclosed_mix
EMIXQ_c009_0_03 (mix_q_src_c009_0_03 0 bpf_c009_0 0) vcvs gain=9.807852804032e-01
SMIXQ_c009_0_03 (mix_q_src_c009_0_03 mix_q_c009_0 win_0_03 0) relay vt1=-1m vt2=1m ropen=ropen_mix rclosed=rclosed_mix
EMIXI_c009_0_04 (mix_i_src_c009_0_04 0 bpf_c009_0 0) vcvs gain=-1.950903220161e-01
SMIXI_c009_0_04 (mix_i_src_c009_0_04 mix_i_c009_0 win_0_04 0) relay vt1=-1m vt2=1m ropen=ropen_mix rclosed=rclosed_mix
EMIXQ_c009_0_04 (mix_q_src_c009_0_04 0 bpf_c009_0 0) vcvs gain=9.807852804032e-01
SMIXQ_c009_0_04 (mix_q_src_c009_0_04 mix_q_c009_0 win_0_04 0) relay vt1=-1m vt2=1m ropen=ropen_mix rclosed=rclosed_mix
EMIXI_c009_0_05 (mix_i_src_c009_0_05 0 bpf_c009_0 0) vcvs gain=-5.555702330196e-01
SMIXI_c009_0_05 (mix_i_src_c009_0_05 mix_i_c009_0 win_0_05 0) relay vt1=-1m vt2=1m ropen=ropen_mix rclosed=rclosed_mix
EMIXQ_c009_0_05 (mix_q_src_c009_0_05 0 bpf_c009_0 0) vcvs gain=8.314696123025e-01
SMIXQ_c009_0_05 (mix_q_src_c009_0_05 mix_q_c009_0 win_0_05 0) relay vt1=-1m vt2=1m ropen=ropen_mix rclosed=rclosed_mix
EMIXI_c009_0_06 (mix_i_src_c009_0_06 0 bpf_c009_0 0) vcvs gain=-8.314696123025e-01
SMIXI_c009_0_06 (mix_i_src_c009_0_06 mix_i_c009_0 win_0_06 0) relay vt1=-1m vt2=1m ropen=ropen_mix rclosed=rclosed_mix
EMIXQ_c009_0_06 (mix_q_src_c009_0_06 0 bpf_c009_0 0) vcvs gain=5.555702330196e-01
SMIXQ_c009_0_06 (mix_q_src_c009_0_06 mix_q_c009_0 win_0_06 0) relay vt1=-1m vt2=1m ropen=ropen_mix rclosed=rclosed_mix
EMIXI_c009_0_07 (mix_i_src_c009_0_07 0 bpf_c009_0 0) vcvs gain=-9.807852804032e-01
SMIXI_c009_0_07 (mix_i_src_c009_0_07 mix_i_c009_0 win_0_07 0) relay vt1=-1m vt2=1m ropen=ropen_mix rclosed=rclosed_mix
EMIXQ_c009_0_07 (mix_q_src_c009_0_07 0 bpf_c009_0 0) vcvs gain=1.950903220161e-01
SMIXQ_c009_0_07 (mix_q_src_c009_0_07 mix_q_c009_0 win_0_07 0) relay vt1=-1m vt2=1m ropen=ropen_mix rclosed=rclosed_mix
EMIXI_c009_0_08 (mix_i_src_c009_0_08 0 bpf_c009_0 0) vcvs gain=-9.807852804032e-01
SMIXI_c009_0_08 (mix_i_src_c009_0_08 mix_i_c009_0 win_0_08 0) relay vt1=-1m vt2=1m ropen=ropen_mix rclosed=rclosed_mix
EMIXQ_c009_0_08 (mix_q_src_c009_0_08 0 bpf_c009_0 0) vcvs gain=-1.950903220161e-01
SMIXQ_c009_0_08 (mix_q_src_c009_0_08 mix_q_c009_0 win_0_08 0) relay vt1=-1m vt2=1m ropen=ropen_mix rclosed=rclosed_mix
EMIXI_c009_0_09 (mix_i_src_c009_0_09 0 bpf_c009_0 0) vcvs gain=-8.314696123025e-01
SMIXI_c009_0_09 (mix_i_src_c009_0_09 mix_i_c009_0 win_0_09 0) relay vt1=-1m vt2=1m ropen=ropen_mix rclosed=rclosed_mix
EMIXQ_c009_0_09 (mix_q_src_c009_0_09 0 bpf_c009_0 0) vcvs gain=-5.555702330196e-01
SMIXQ_c009_0_09 (mix_q_src_c009_0_09 mix_q_c009_0 win_0_09 0) relay vt1=-1m vt2=1m ropen=ropen_mix rclosed=rclosed_mix
EMIXI_c009_0_10 (mix_i_src_c009_0_10 0 bpf_c009_0 0) vcvs gain=-5.555702330196e-01
SMIXI_c009_0_10 (mix_i_src_c009_0_10 mix_i_c009_0 win_0_10 0) relay vt1=-1m vt2=1m ropen=ropen_mix rclosed=rclosed_mix
EMIXQ_c009_0_10 (mix_q_src_c009_0_10 0 bpf_c009_0 0) vcvs gain=-8.314696123025e-01
SMIXQ_c009_0_10 (mix_q_src_c009_0_10 mix_q_c009_0 win_0_10 0) relay vt1=-1m vt2=1m ropen=ropen_mix rclosed=rclosed_mix
EMIXI_c009_0_11 (mix_i_src_c009_0_11 0 bpf_c009_0 0) vcvs gain=-1.950903220161e-01
SMIXI_c009_0_11 (mix_i_src_c009_0_11 mix_i_c009_0 win_0_11 0) relay vt1=-1m vt2=1m ropen=ropen_mix rclosed=rclosed_mix
EMIXQ_c009_0_11 (mix_q_src_c009_0_11 0 bpf_c009_0 0) vcvs gain=-9.807852804032e-01
SMIXQ_c009_0_11 (mix_q_src_c009_0_11 mix_q_c009_0 win_0_11 0) relay vt1=-1m vt2=1m ropen=ropen_mix rclosed=rclosed_mix
EMIXI_c009_0_12 (mix_i_src_c009_0_12 0 bpf_c009_0 0) vcvs gain=1.950903220161e-01
SMIXI_c009_0_12 (mix_i_src_c009_0_12 mix_i_c009_0 win_0_12 0) relay vt1=-1m vt2=1m ropen=ropen_mix rclosed=rclosed_mix
EMIXQ_c009_0_12 (mix_q_src_c009_0_12 0 bpf_c009_0 0) vcvs gain=-9.807852804032e-01
SMIXQ_c009_0_12 (mix_q_src_c009_0_12 mix_q_c009_0 win_0_12 0) relay vt1=-1m vt2=1m ropen=ropen_mix rclosed=rclosed_mix
EMIXI_c009_0_13 (mix_i_src_c009_0_13 0 bpf_c009_0 0) vcvs gain=5.555702330196e-01
SMIXI_c009_0_13 (mix_i_src_c009_0_13 mix_i_c009_0 win_0_13 0) relay vt1=-1m vt2=1m ropen=ropen_mix rclosed=rclosed_mix
EMIXQ_c009_0_13 (mix_q_src_c009_0_13 0 bpf_c009_0 0) vcvs gain=-8.314696123025e-01
SMIXQ_c009_0_13 (mix_q_src_c009_0_13 mix_q_c009_0 win_0_13 0) relay vt1=-1m vt2=1m ropen=ropen_mix rclosed=rclosed_mix
EMIXI_c009_0_14 (mix_i_src_c009_0_14 0 bpf_c009_0 0) vcvs gain=8.314696123025e-01
SMIXI_c009_0_14 (mix_i_src_c009_0_14 mix_i_c009_0 win_0_14 0) relay vt1=-1m vt2=1m ropen=ropen_mix rclosed=rclosed_mix
EMIXQ_c009_0_14 (mix_q_src_c009_0_14 0 bpf_c009_0 0) vcvs gain=-5.555702330196e-01
SMIXQ_c009_0_14 (mix_q_src_c009_0_14 mix_q_c009_0 win_0_14 0) relay vt1=-1m vt2=1m ropen=ropen_mix rclosed=rclosed_mix
EMIXI_c009_0_15 (mix_i_src_c009_0_15 0 bpf_c009_0 0) vcvs gain=9.807852804032e-01
SMIXI_c009_0_15 (mix_i_src_c009_0_15 mix_i_c009_0 win_0_15 0) relay vt1=-1m vt2=1m ropen=ropen_mix rclosed=rclosed_mix
EMIXQ_c009_0_15 (mix_q_src_c009_0_15 0 bpf_c009_0 0) vcvs gain=-1.950903220161e-01
SMIXQ_c009_0_15 (mix_q_src_c009_0_15 mix_q_c009_0 win_0_15 0) relay vt1=-1m vt2=1m ropen=ropen_mix rclosed=rclosed_mix
RMIXI_c009_0 (mix_i_c009_0 0) resistor r=1G
RMIXQ_c009_0 (mix_q_c009_0 0) resistor r=1G
RINTI_c009_0 (mix_i_c009_0 Icar_c009_0) resistor r=1k
CINTI_c009_0 (Icar_c009_0 0) capacitor c=80p
RINTQ_c009_0 (mix_q_c009_0 Qcar_c009_0) resistor r=1k
CINTQ_c009_0 (Qcar_c009_0 0) capacitor c=80p
save bpf_c009_0 Icar_c009_0 Qcar_c009_0

// bl009, carrier_1: 500000000 Hz coherent I/Q phase-window verification-demod path
CBPF_c009_1 (bl009 n_cbpf_c009_1) capacitor c=1.013211836423e-13
LBPF_c009_1 (n_cbpf_c009_1 bpf_c009_1) inductor l=1.000000000000e-06
RBPF_c009_1 (bpf_c009_1 0) resistor r=1.570796326795e+02
EMIXI_c009_1_00 (mix_i_src_c009_1_00 0 bpf_c009_1 0) vcvs gain=9.807852804032e-01
SMIXI_c009_1_00 (mix_i_src_c009_1_00 mix_i_c009_1 win_1_00 0) relay vt1=-1m vt2=1m ropen=ropen_mix rclosed=rclosed_mix
EMIXQ_c009_1_00 (mix_q_src_c009_1_00 0 bpf_c009_1 0) vcvs gain=1.950903220161e-01
SMIXQ_c009_1_00 (mix_q_src_c009_1_00 mix_q_c009_1 win_1_00 0) relay vt1=-1m vt2=1m ropen=ropen_mix rclosed=rclosed_mix
EMIXI_c009_1_01 (mix_i_src_c009_1_01 0 bpf_c009_1 0) vcvs gain=8.314696123025e-01
SMIXI_c009_1_01 (mix_i_src_c009_1_01 mix_i_c009_1 win_1_01 0) relay vt1=-1m vt2=1m ropen=ropen_mix rclosed=rclosed_mix
EMIXQ_c009_1_01 (mix_q_src_c009_1_01 0 bpf_c009_1 0) vcvs gain=5.555702330196e-01
SMIXQ_c009_1_01 (mix_q_src_c009_1_01 mix_q_c009_1 win_1_01 0) relay vt1=-1m vt2=1m ropen=ropen_mix rclosed=rclosed_mix
EMIXI_c009_1_02 (mix_i_src_c009_1_02 0 bpf_c009_1 0) vcvs gain=5.555702330196e-01
SMIXI_c009_1_02 (mix_i_src_c009_1_02 mix_i_c009_1 win_1_02 0) relay vt1=-1m vt2=1m ropen=ropen_mix rclosed=rclosed_mix
EMIXQ_c009_1_02 (mix_q_src_c009_1_02 0 bpf_c009_1 0) vcvs gain=8.314696123025e-01
SMIXQ_c009_1_02 (mix_q_src_c009_1_02 mix_q_c009_1 win_1_02 0) relay vt1=-1m vt2=1m ropen=ropen_mix rclosed=rclosed_mix
EMIXI_c009_1_03 (mix_i_src_c009_1_03 0 bpf_c009_1 0) vcvs gain=1.950903220161e-01
SMIXI_c009_1_03 (mix_i_src_c009_1_03 mix_i_c009_1 win_1_03 0) relay vt1=-1m vt2=1m ropen=ropen_mix rclosed=rclosed_mix
EMIXQ_c009_1_03 (mix_q_src_c009_1_03 0 bpf_c009_1 0) vcvs gain=9.807852804032e-01
SMIXQ_c009_1_03 (mix_q_src_c009_1_03 mix_q_c009_1 win_1_03 0) relay vt1=-1m vt2=1m ropen=ropen_mix rclosed=rclosed_mix
EMIXI_c009_1_04 (mix_i_src_c009_1_04 0 bpf_c009_1 0) vcvs gain=-1.950903220161e-01
SMIXI_c009_1_04 (mix_i_src_c009_1_04 mix_i_c009_1 win_1_04 0) relay vt1=-1m vt2=1m ropen=ropen_mix rclosed=rclosed_mix
EMIXQ_c009_1_04 (mix_q_src_c009_1_04 0 bpf_c009_1 0) vcvs gain=9.807852804032e-01
SMIXQ_c009_1_04 (mix_q_src_c009_1_04 mix_q_c009_1 win_1_04 0) relay vt1=-1m vt2=1m ropen=ropen_mix rclosed=rclosed_mix
EMIXI_c009_1_05 (mix_i_src_c009_1_05 0 bpf_c009_1 0) vcvs gain=-5.555702330196e-01
SMIXI_c009_1_05 (mix_i_src_c009_1_05 mix_i_c009_1 win_1_05 0) relay vt1=-1m vt2=1m ropen=ropen_mix rclosed=rclosed_mix
EMIXQ_c009_1_05 (mix_q_src_c009_1_05 0 bpf_c009_1 0) vcvs gain=8.314696123025e-01
SMIXQ_c009_1_05 (mix_q_src_c009_1_05 mix_q_c009_1 win_1_05 0) relay vt1=-1m vt2=1m ropen=ropen_mix rclosed=rclosed_mix
EMIXI_c009_1_06 (mix_i_src_c009_1_06 0 bpf_c009_1 0) vcvs gain=-8.314696123025e-01
SMIXI_c009_1_06 (mix_i_src_c009_1_06 mix_i_c009_1 win_1_06 0) relay vt1=-1m vt2=1m ropen=ropen_mix rclosed=rclosed_mix
EMIXQ_c009_1_06 (mix_q_src_c009_1_06 0 bpf_c009_1 0) vcvs gain=5.555702330196e-01
SMIXQ_c009_1_06 (mix_q_src_c009_1_06 mix_q_c009_1 win_1_06 0) relay vt1=-1m vt2=1m ropen=ropen_mix rclosed=rclosed_mix
EMIXI_c009_1_07 (mix_i_src_c009_1_07 0 bpf_c009_1 0) vcvs gain=-9.807852804032e-01
SMIXI_c009_1_07 (mix_i_src_c009_1_07 mix_i_c009_1 win_1_07 0) relay vt1=-1m vt2=1m ropen=ropen_mix rclosed=rclosed_mix
EMIXQ_c009_1_07 (mix_q_src_c009_1_07 0 bpf_c009_1 0) vcvs gain=1.950903220161e-01
SMIXQ_c009_1_07 (mix_q_src_c009_1_07 mix_q_c009_1 win_1_07 0) relay vt1=-1m vt2=1m ropen=ropen_mix rclosed=rclosed_mix
EMIXI_c009_1_08 (mix_i_src_c009_1_08 0 bpf_c009_1 0) vcvs gain=-9.807852804032e-01
SMIXI_c009_1_08 (mix_i_src_c009_1_08 mix_i_c009_1 win_1_08 0) relay vt1=-1m vt2=1m ropen=ropen_mix rclosed=rclosed_mix
EMIXQ_c009_1_08 (mix_q_src_c009_1_08 0 bpf_c009_1 0) vcvs gain=-1.950903220161e-01
SMIXQ_c009_1_08 (mix_q_src_c009_1_08 mix_q_c009_1 win_1_08 0) relay vt1=-1m vt2=1m ropen=ropen_mix rclosed=rclosed_mix
EMIXI_c009_1_09 (mix_i_src_c009_1_09 0 bpf_c009_1 0) vcvs gain=-8.314696123025e-01
SMIXI_c009_1_09 (mix_i_src_c009_1_09 mix_i_c009_1 win_1_09 0) relay vt1=-1m vt2=1m ropen=ropen_mix rclosed=rclosed_mix
EMIXQ_c009_1_09 (mix_q_src_c009_1_09 0 bpf_c009_1 0) vcvs gain=-5.555702330196e-01
SMIXQ_c009_1_09 (mix_q_src_c009_1_09 mix_q_c009_1 win_1_09 0) relay vt1=-1m vt2=1m ropen=ropen_mix rclosed=rclosed_mix
EMIXI_c009_1_10 (mix_i_src_c009_1_10 0 bpf_c009_1 0) vcvs gain=-5.555702330196e-01
SMIXI_c009_1_10 (mix_i_src_c009_1_10 mix_i_c009_1 win_1_10 0) relay vt1=-1m vt2=1m ropen=ropen_mix rclosed=rclosed_mix
EMIXQ_c009_1_10 (mix_q_src_c009_1_10 0 bpf_c009_1 0) vcvs gain=-8.314696123025e-01
SMIXQ_c009_1_10 (mix_q_src_c009_1_10 mix_q_c009_1 win_1_10 0) relay vt1=-1m vt2=1m ropen=ropen_mix rclosed=rclosed_mix
EMIXI_c009_1_11 (mix_i_src_c009_1_11 0 bpf_c009_1 0) vcvs gain=-1.950903220161e-01
SMIXI_c009_1_11 (mix_i_src_c009_1_11 mix_i_c009_1 win_1_11 0) relay vt1=-1m vt2=1m ropen=ropen_mix rclosed=rclosed_mix
EMIXQ_c009_1_11 (mix_q_src_c009_1_11 0 bpf_c009_1 0) vcvs gain=-9.807852804032e-01
SMIXQ_c009_1_11 (mix_q_src_c009_1_11 mix_q_c009_1 win_1_11 0) relay vt1=-1m vt2=1m ropen=ropen_mix rclosed=rclosed_mix
EMIXI_c009_1_12 (mix_i_src_c009_1_12 0 bpf_c009_1 0) vcvs gain=1.950903220161e-01
SMIXI_c009_1_12 (mix_i_src_c009_1_12 mix_i_c009_1 win_1_12 0) relay vt1=-1m vt2=1m ropen=ropen_mix rclosed=rclosed_mix
EMIXQ_c009_1_12 (mix_q_src_c009_1_12 0 bpf_c009_1 0) vcvs gain=-9.807852804032e-01
SMIXQ_c009_1_12 (mix_q_src_c009_1_12 mix_q_c009_1 win_1_12 0) relay vt1=-1m vt2=1m ropen=ropen_mix rclosed=rclosed_mix
EMIXI_c009_1_13 (mix_i_src_c009_1_13 0 bpf_c009_1 0) vcvs gain=5.555702330196e-01
SMIXI_c009_1_13 (mix_i_src_c009_1_13 mix_i_c009_1 win_1_13 0) relay vt1=-1m vt2=1m ropen=ropen_mix rclosed=rclosed_mix
EMIXQ_c009_1_13 (mix_q_src_c009_1_13 0 bpf_c009_1 0) vcvs gain=-8.314696123025e-01
SMIXQ_c009_1_13 (mix_q_src_c009_1_13 mix_q_c009_1 win_1_13 0) relay vt1=-1m vt2=1m ropen=ropen_mix rclosed=rclosed_mix
EMIXI_c009_1_14 (mix_i_src_c009_1_14 0 bpf_c009_1 0) vcvs gain=8.314696123025e-01
SMIXI_c009_1_14 (mix_i_src_c009_1_14 mix_i_c009_1 win_1_14 0) relay vt1=-1m vt2=1m ropen=ropen_mix rclosed=rclosed_mix
EMIXQ_c009_1_14 (mix_q_src_c009_1_14 0 bpf_c009_1 0) vcvs gain=-5.555702330196e-01
SMIXQ_c009_1_14 (mix_q_src_c009_1_14 mix_q_c009_1 win_1_14 0) relay vt1=-1m vt2=1m ropen=ropen_mix rclosed=rclosed_mix
EMIXI_c009_1_15 (mix_i_src_c009_1_15 0 bpf_c009_1 0) vcvs gain=9.807852804032e-01
SMIXI_c009_1_15 (mix_i_src_c009_1_15 mix_i_c009_1 win_1_15 0) relay vt1=-1m vt2=1m ropen=ropen_mix rclosed=rclosed_mix
EMIXQ_c009_1_15 (mix_q_src_c009_1_15 0 bpf_c009_1 0) vcvs gain=-1.950903220161e-01
SMIXQ_c009_1_15 (mix_q_src_c009_1_15 mix_q_c009_1 win_1_15 0) relay vt1=-1m vt2=1m ropen=ropen_mix rclosed=rclosed_mix
RMIXI_c009_1 (mix_i_c009_1 0) resistor r=1G
RMIXQ_c009_1 (mix_q_c009_1 0) resistor r=1G
RINTI_c009_1 (mix_i_c009_1 Icar_c009_1) resistor r=1k
CINTI_c009_1 (Icar_c009_1 0) capacitor c=80p
RINTQ_c009_1 (mix_q_c009_1 Qcar_c009_1) resistor r=1k
CINTQ_c009_1 (Qcar_c009_1 0) capacitor c=80p
save bpf_c009_1 Icar_c009_1 Qcar_c009_1

// bl009, carrier_2: 750000000 Hz coherent I/Q phase-window verification-demod path
CBPF_c009_2 (bl009 n_cbpf_c009_2) capacitor c=4.503163717437e-14
LBPF_c009_2 (n_cbpf_c009_2 bpf_c009_2) inductor l=1.000000000000e-06
RBPF_c009_2 (bpf_c009_2 0) resistor r=2.356194490192e+02
EMIXI_c009_2_00 (mix_i_src_c009_2_00 0 bpf_c009_2 0) vcvs gain=9.807852804032e-01
SMIXI_c009_2_00 (mix_i_src_c009_2_00 mix_i_c009_2 win_2_00 0) relay vt1=-1m vt2=1m ropen=ropen_mix rclosed=rclosed_mix
EMIXQ_c009_2_00 (mix_q_src_c009_2_00 0 bpf_c009_2 0) vcvs gain=1.950903220161e-01
SMIXQ_c009_2_00 (mix_q_src_c009_2_00 mix_q_c009_2 win_2_00 0) relay vt1=-1m vt2=1m ropen=ropen_mix rclosed=rclosed_mix
EMIXI_c009_2_01 (mix_i_src_c009_2_01 0 bpf_c009_2 0) vcvs gain=8.314696123025e-01
SMIXI_c009_2_01 (mix_i_src_c009_2_01 mix_i_c009_2 win_2_01 0) relay vt1=-1m vt2=1m ropen=ropen_mix rclosed=rclosed_mix
EMIXQ_c009_2_01 (mix_q_src_c009_2_01 0 bpf_c009_2 0) vcvs gain=5.555702330196e-01
SMIXQ_c009_2_01 (mix_q_src_c009_2_01 mix_q_c009_2 win_2_01 0) relay vt1=-1m vt2=1m ropen=ropen_mix rclosed=rclosed_mix
EMIXI_c009_2_02 (mix_i_src_c009_2_02 0 bpf_c009_2 0) vcvs gain=5.555702330196e-01
SMIXI_c009_2_02 (mix_i_src_c009_2_02 mix_i_c009_2 win_2_02 0) relay vt1=-1m vt2=1m ropen=ropen_mix rclosed=rclosed_mix
EMIXQ_c009_2_02 (mix_q_src_c009_2_02 0 bpf_c009_2 0) vcvs gain=8.314696123025e-01
SMIXQ_c009_2_02 (mix_q_src_c009_2_02 mix_q_c009_2 win_2_02 0) relay vt1=-1m vt2=1m ropen=ropen_mix rclosed=rclosed_mix
EMIXI_c009_2_03 (mix_i_src_c009_2_03 0 bpf_c009_2 0) vcvs gain=1.950903220161e-01
SMIXI_c009_2_03 (mix_i_src_c009_2_03 mix_i_c009_2 win_2_03 0) relay vt1=-1m vt2=1m ropen=ropen_mix rclosed=rclosed_mix
EMIXQ_c009_2_03 (mix_q_src_c009_2_03 0 bpf_c009_2 0) vcvs gain=9.807852804032e-01
SMIXQ_c009_2_03 (mix_q_src_c009_2_03 mix_q_c009_2 win_2_03 0) relay vt1=-1m vt2=1m ropen=ropen_mix rclosed=rclosed_mix
EMIXI_c009_2_04 (mix_i_src_c009_2_04 0 bpf_c009_2 0) vcvs gain=-1.950903220161e-01
SMIXI_c009_2_04 (mix_i_src_c009_2_04 mix_i_c009_2 win_2_04 0) relay vt1=-1m vt2=1m ropen=ropen_mix rclosed=rclosed_mix
EMIXQ_c009_2_04 (mix_q_src_c009_2_04 0 bpf_c009_2 0) vcvs gain=9.807852804032e-01
SMIXQ_c009_2_04 (mix_q_src_c009_2_04 mix_q_c009_2 win_2_04 0) relay vt1=-1m vt2=1m ropen=ropen_mix rclosed=rclosed_mix
EMIXI_c009_2_05 (mix_i_src_c009_2_05 0 bpf_c009_2 0) vcvs gain=-5.555702330196e-01
SMIXI_c009_2_05 (mix_i_src_c009_2_05 mix_i_c009_2 win_2_05 0) relay vt1=-1m vt2=1m ropen=ropen_mix rclosed=rclosed_mix
EMIXQ_c009_2_05 (mix_q_src_c009_2_05 0 bpf_c009_2 0) vcvs gain=8.314696123025e-01
SMIXQ_c009_2_05 (mix_q_src_c009_2_05 mix_q_c009_2 win_2_05 0) relay vt1=-1m vt2=1m ropen=ropen_mix rclosed=rclosed_mix
EMIXI_c009_2_06 (mix_i_src_c009_2_06 0 bpf_c009_2 0) vcvs gain=-8.314696123025e-01
SMIXI_c009_2_06 (mix_i_src_c009_2_06 mix_i_c009_2 win_2_06 0) relay vt1=-1m vt2=1m ropen=ropen_mix rclosed=rclosed_mix
EMIXQ_c009_2_06 (mix_q_src_c009_2_06 0 bpf_c009_2 0) vcvs gain=5.555702330196e-01
SMIXQ_c009_2_06 (mix_q_src_c009_2_06 mix_q_c009_2 win_2_06 0) relay vt1=-1m vt2=1m ropen=ropen_mix rclosed=rclosed_mix
EMIXI_c009_2_07 (mix_i_src_c009_2_07 0 bpf_c009_2 0) vcvs gain=-9.807852804032e-01
SMIXI_c009_2_07 (mix_i_src_c009_2_07 mix_i_c009_2 win_2_07 0) relay vt1=-1m vt2=1m ropen=ropen_mix rclosed=rclosed_mix
EMIXQ_c009_2_07 (mix_q_src_c009_2_07 0 bpf_c009_2 0) vcvs gain=1.950903220161e-01
SMIXQ_c009_2_07 (mix_q_src_c009_2_07 mix_q_c009_2 win_2_07 0) relay vt1=-1m vt2=1m ropen=ropen_mix rclosed=rclosed_mix
EMIXI_c009_2_08 (mix_i_src_c009_2_08 0 bpf_c009_2 0) vcvs gain=-9.807852804032e-01
SMIXI_c009_2_08 (mix_i_src_c009_2_08 mix_i_c009_2 win_2_08 0) relay vt1=-1m vt2=1m ropen=ropen_mix rclosed=rclosed_mix
EMIXQ_c009_2_08 (mix_q_src_c009_2_08 0 bpf_c009_2 0) vcvs gain=-1.950903220161e-01
SMIXQ_c009_2_08 (mix_q_src_c009_2_08 mix_q_c009_2 win_2_08 0) relay vt1=-1m vt2=1m ropen=ropen_mix rclosed=rclosed_mix
EMIXI_c009_2_09 (mix_i_src_c009_2_09 0 bpf_c009_2 0) vcvs gain=-8.314696123025e-01
SMIXI_c009_2_09 (mix_i_src_c009_2_09 mix_i_c009_2 win_2_09 0) relay vt1=-1m vt2=1m ropen=ropen_mix rclosed=rclosed_mix
EMIXQ_c009_2_09 (mix_q_src_c009_2_09 0 bpf_c009_2 0) vcvs gain=-5.555702330196e-01
SMIXQ_c009_2_09 (mix_q_src_c009_2_09 mix_q_c009_2 win_2_09 0) relay vt1=-1m vt2=1m ropen=ropen_mix rclosed=rclosed_mix
EMIXI_c009_2_10 (mix_i_src_c009_2_10 0 bpf_c009_2 0) vcvs gain=-5.555702330196e-01
SMIXI_c009_2_10 (mix_i_src_c009_2_10 mix_i_c009_2 win_2_10 0) relay vt1=-1m vt2=1m ropen=ropen_mix rclosed=rclosed_mix
EMIXQ_c009_2_10 (mix_q_src_c009_2_10 0 bpf_c009_2 0) vcvs gain=-8.314696123025e-01
SMIXQ_c009_2_10 (mix_q_src_c009_2_10 mix_q_c009_2 win_2_10 0) relay vt1=-1m vt2=1m ropen=ropen_mix rclosed=rclosed_mix
EMIXI_c009_2_11 (mix_i_src_c009_2_11 0 bpf_c009_2 0) vcvs gain=-1.950903220161e-01
SMIXI_c009_2_11 (mix_i_src_c009_2_11 mix_i_c009_2 win_2_11 0) relay vt1=-1m vt2=1m ropen=ropen_mix rclosed=rclosed_mix
EMIXQ_c009_2_11 (mix_q_src_c009_2_11 0 bpf_c009_2 0) vcvs gain=-9.807852804032e-01
SMIXQ_c009_2_11 (mix_q_src_c009_2_11 mix_q_c009_2 win_2_11 0) relay vt1=-1m vt2=1m ropen=ropen_mix rclosed=rclosed_mix
EMIXI_c009_2_12 (mix_i_src_c009_2_12 0 bpf_c009_2 0) vcvs gain=1.950903220161e-01
SMIXI_c009_2_12 (mix_i_src_c009_2_12 mix_i_c009_2 win_2_12 0) relay vt1=-1m vt2=1m ropen=ropen_mix rclosed=rclosed_mix
EMIXQ_c009_2_12 (mix_q_src_c009_2_12 0 bpf_c009_2 0) vcvs gain=-9.807852804032e-01
SMIXQ_c009_2_12 (mix_q_src_c009_2_12 mix_q_c009_2 win_2_12 0) relay vt1=-1m vt2=1m ropen=ropen_mix rclosed=rclosed_mix
EMIXI_c009_2_13 (mix_i_src_c009_2_13 0 bpf_c009_2 0) vcvs gain=5.555702330196e-01
SMIXI_c009_2_13 (mix_i_src_c009_2_13 mix_i_c009_2 win_2_13 0) relay vt1=-1m vt2=1m ropen=ropen_mix rclosed=rclosed_mix
EMIXQ_c009_2_13 (mix_q_src_c009_2_13 0 bpf_c009_2 0) vcvs gain=-8.314696123025e-01
SMIXQ_c009_2_13 (mix_q_src_c009_2_13 mix_q_c009_2 win_2_13 0) relay vt1=-1m vt2=1m ropen=ropen_mix rclosed=rclosed_mix
EMIXI_c009_2_14 (mix_i_src_c009_2_14 0 bpf_c009_2 0) vcvs gain=8.314696123025e-01
SMIXI_c009_2_14 (mix_i_src_c009_2_14 mix_i_c009_2 win_2_14 0) relay vt1=-1m vt2=1m ropen=ropen_mix rclosed=rclosed_mix
EMIXQ_c009_2_14 (mix_q_src_c009_2_14 0 bpf_c009_2 0) vcvs gain=-5.555702330196e-01
SMIXQ_c009_2_14 (mix_q_src_c009_2_14 mix_q_c009_2 win_2_14 0) relay vt1=-1m vt2=1m ropen=ropen_mix rclosed=rclosed_mix
EMIXI_c009_2_15 (mix_i_src_c009_2_15 0 bpf_c009_2 0) vcvs gain=9.807852804032e-01
SMIXI_c009_2_15 (mix_i_src_c009_2_15 mix_i_c009_2 win_2_15 0) relay vt1=-1m vt2=1m ropen=ropen_mix rclosed=rclosed_mix
EMIXQ_c009_2_15 (mix_q_src_c009_2_15 0 bpf_c009_2 0) vcvs gain=-1.950903220161e-01
SMIXQ_c009_2_15 (mix_q_src_c009_2_15 mix_q_c009_2 win_2_15 0) relay vt1=-1m vt2=1m ropen=ropen_mix rclosed=rclosed_mix
RMIXI_c009_2 (mix_i_c009_2 0) resistor r=1G
RMIXQ_c009_2 (mix_q_c009_2 0) resistor r=1G
RINTI_c009_2 (mix_i_c009_2 Icar_c009_2) resistor r=1k
CINTI_c009_2 (Icar_c009_2 0) capacitor c=80p
RINTQ_c009_2 (mix_q_c009_2 Qcar_c009_2) resistor r=1k
CINTQ_c009_2 (Qcar_c009_2 0) capacitor c=80p
save bpf_c009_2 Icar_c009_2 Qcar_c009_2

// bl009, carrier_3: 1000000000 Hz coherent I/Q phase-window verification-demod path
CBPF_c009_3 (bl009 n_cbpf_c009_3) capacitor c=2.533029591058e-14
LBPF_c009_3 (n_cbpf_c009_3 bpf_c009_3) inductor l=1.000000000000e-06
RBPF_c009_3 (bpf_c009_3 0) resistor r=3.141592653590e+02
EMIXI_c009_3_00 (mix_i_src_c009_3_00 0 bpf_c009_3 0) vcvs gain=9.807852804032e-01
SMIXI_c009_3_00 (mix_i_src_c009_3_00 mix_i_c009_3 win_3_00 0) relay vt1=-1m vt2=1m ropen=ropen_mix rclosed=rclosed_mix
EMIXQ_c009_3_00 (mix_q_src_c009_3_00 0 bpf_c009_3 0) vcvs gain=1.950903220161e-01
SMIXQ_c009_3_00 (mix_q_src_c009_3_00 mix_q_c009_3 win_3_00 0) relay vt1=-1m vt2=1m ropen=ropen_mix rclosed=rclosed_mix
EMIXI_c009_3_01 (mix_i_src_c009_3_01 0 bpf_c009_3 0) vcvs gain=8.314696123025e-01
SMIXI_c009_3_01 (mix_i_src_c009_3_01 mix_i_c009_3 win_3_01 0) relay vt1=-1m vt2=1m ropen=ropen_mix rclosed=rclosed_mix
EMIXQ_c009_3_01 (mix_q_src_c009_3_01 0 bpf_c009_3 0) vcvs gain=5.555702330196e-01
SMIXQ_c009_3_01 (mix_q_src_c009_3_01 mix_q_c009_3 win_3_01 0) relay vt1=-1m vt2=1m ropen=ropen_mix rclosed=rclosed_mix
EMIXI_c009_3_02 (mix_i_src_c009_3_02 0 bpf_c009_3 0) vcvs gain=5.555702330196e-01
SMIXI_c009_3_02 (mix_i_src_c009_3_02 mix_i_c009_3 win_3_02 0) relay vt1=-1m vt2=1m ropen=ropen_mix rclosed=rclosed_mix
EMIXQ_c009_3_02 (mix_q_src_c009_3_02 0 bpf_c009_3 0) vcvs gain=8.314696123025e-01
SMIXQ_c009_3_02 (mix_q_src_c009_3_02 mix_q_c009_3 win_3_02 0) relay vt1=-1m vt2=1m ropen=ropen_mix rclosed=rclosed_mix
EMIXI_c009_3_03 (mix_i_src_c009_3_03 0 bpf_c009_3 0) vcvs gain=1.950903220161e-01
SMIXI_c009_3_03 (mix_i_src_c009_3_03 mix_i_c009_3 win_3_03 0) relay vt1=-1m vt2=1m ropen=ropen_mix rclosed=rclosed_mix
EMIXQ_c009_3_03 (mix_q_src_c009_3_03 0 bpf_c009_3 0) vcvs gain=9.807852804032e-01
SMIXQ_c009_3_03 (mix_q_src_c009_3_03 mix_q_c009_3 win_3_03 0) relay vt1=-1m vt2=1m ropen=ropen_mix rclosed=rclosed_mix
EMIXI_c009_3_04 (mix_i_src_c009_3_04 0 bpf_c009_3 0) vcvs gain=-1.950903220161e-01
SMIXI_c009_3_04 (mix_i_src_c009_3_04 mix_i_c009_3 win_3_04 0) relay vt1=-1m vt2=1m ropen=ropen_mix rclosed=rclosed_mix
EMIXQ_c009_3_04 (mix_q_src_c009_3_04 0 bpf_c009_3 0) vcvs gain=9.807852804032e-01
SMIXQ_c009_3_04 (mix_q_src_c009_3_04 mix_q_c009_3 win_3_04 0) relay vt1=-1m vt2=1m ropen=ropen_mix rclosed=rclosed_mix
EMIXI_c009_3_05 (mix_i_src_c009_3_05 0 bpf_c009_3 0) vcvs gain=-5.555702330196e-01
SMIXI_c009_3_05 (mix_i_src_c009_3_05 mix_i_c009_3 win_3_05 0) relay vt1=-1m vt2=1m ropen=ropen_mix rclosed=rclosed_mix
EMIXQ_c009_3_05 (mix_q_src_c009_3_05 0 bpf_c009_3 0) vcvs gain=8.314696123025e-01
SMIXQ_c009_3_05 (mix_q_src_c009_3_05 mix_q_c009_3 win_3_05 0) relay vt1=-1m vt2=1m ropen=ropen_mix rclosed=rclosed_mix
EMIXI_c009_3_06 (mix_i_src_c009_3_06 0 bpf_c009_3 0) vcvs gain=-8.314696123025e-01
SMIXI_c009_3_06 (mix_i_src_c009_3_06 mix_i_c009_3 win_3_06 0) relay vt1=-1m vt2=1m ropen=ropen_mix rclosed=rclosed_mix
EMIXQ_c009_3_06 (mix_q_src_c009_3_06 0 bpf_c009_3 0) vcvs gain=5.555702330196e-01
SMIXQ_c009_3_06 (mix_q_src_c009_3_06 mix_q_c009_3 win_3_06 0) relay vt1=-1m vt2=1m ropen=ropen_mix rclosed=rclosed_mix
EMIXI_c009_3_07 (mix_i_src_c009_3_07 0 bpf_c009_3 0) vcvs gain=-9.807852804032e-01
SMIXI_c009_3_07 (mix_i_src_c009_3_07 mix_i_c009_3 win_3_07 0) relay vt1=-1m vt2=1m ropen=ropen_mix rclosed=rclosed_mix
EMIXQ_c009_3_07 (mix_q_src_c009_3_07 0 bpf_c009_3 0) vcvs gain=1.950903220161e-01
SMIXQ_c009_3_07 (mix_q_src_c009_3_07 mix_q_c009_3 win_3_07 0) relay vt1=-1m vt2=1m ropen=ropen_mix rclosed=rclosed_mix
EMIXI_c009_3_08 (mix_i_src_c009_3_08 0 bpf_c009_3 0) vcvs gain=-9.807852804032e-01
SMIXI_c009_3_08 (mix_i_src_c009_3_08 mix_i_c009_3 win_3_08 0) relay vt1=-1m vt2=1m ropen=ropen_mix rclosed=rclosed_mix
EMIXQ_c009_3_08 (mix_q_src_c009_3_08 0 bpf_c009_3 0) vcvs gain=-1.950903220161e-01
SMIXQ_c009_3_08 (mix_q_src_c009_3_08 mix_q_c009_3 win_3_08 0) relay vt1=-1m vt2=1m ropen=ropen_mix rclosed=rclosed_mix
EMIXI_c009_3_09 (mix_i_src_c009_3_09 0 bpf_c009_3 0) vcvs gain=-8.314696123025e-01
SMIXI_c009_3_09 (mix_i_src_c009_3_09 mix_i_c009_3 win_3_09 0) relay vt1=-1m vt2=1m ropen=ropen_mix rclosed=rclosed_mix
EMIXQ_c009_3_09 (mix_q_src_c009_3_09 0 bpf_c009_3 0) vcvs gain=-5.555702330196e-01
SMIXQ_c009_3_09 (mix_q_src_c009_3_09 mix_q_c009_3 win_3_09 0) relay vt1=-1m vt2=1m ropen=ropen_mix rclosed=rclosed_mix
EMIXI_c009_3_10 (mix_i_src_c009_3_10 0 bpf_c009_3 0) vcvs gain=-5.555702330196e-01
SMIXI_c009_3_10 (mix_i_src_c009_3_10 mix_i_c009_3 win_3_10 0) relay vt1=-1m vt2=1m ropen=ropen_mix rclosed=rclosed_mix
EMIXQ_c009_3_10 (mix_q_src_c009_3_10 0 bpf_c009_3 0) vcvs gain=-8.314696123025e-01
SMIXQ_c009_3_10 (mix_q_src_c009_3_10 mix_q_c009_3 win_3_10 0) relay vt1=-1m vt2=1m ropen=ropen_mix rclosed=rclosed_mix
EMIXI_c009_3_11 (mix_i_src_c009_3_11 0 bpf_c009_3 0) vcvs gain=-1.950903220161e-01
SMIXI_c009_3_11 (mix_i_src_c009_3_11 mix_i_c009_3 win_3_11 0) relay vt1=-1m vt2=1m ropen=ropen_mix rclosed=rclosed_mix
EMIXQ_c009_3_11 (mix_q_src_c009_3_11 0 bpf_c009_3 0) vcvs gain=-9.807852804032e-01
SMIXQ_c009_3_11 (mix_q_src_c009_3_11 mix_q_c009_3 win_3_11 0) relay vt1=-1m vt2=1m ropen=ropen_mix rclosed=rclosed_mix
EMIXI_c009_3_12 (mix_i_src_c009_3_12 0 bpf_c009_3 0) vcvs gain=1.950903220161e-01
SMIXI_c009_3_12 (mix_i_src_c009_3_12 mix_i_c009_3 win_3_12 0) relay vt1=-1m vt2=1m ropen=ropen_mix rclosed=rclosed_mix
EMIXQ_c009_3_12 (mix_q_src_c009_3_12 0 bpf_c009_3 0) vcvs gain=-9.807852804032e-01
SMIXQ_c009_3_12 (mix_q_src_c009_3_12 mix_q_c009_3 win_3_12 0) relay vt1=-1m vt2=1m ropen=ropen_mix rclosed=rclosed_mix
EMIXI_c009_3_13 (mix_i_src_c009_3_13 0 bpf_c009_3 0) vcvs gain=5.555702330196e-01
SMIXI_c009_3_13 (mix_i_src_c009_3_13 mix_i_c009_3 win_3_13 0) relay vt1=-1m vt2=1m ropen=ropen_mix rclosed=rclosed_mix
EMIXQ_c009_3_13 (mix_q_src_c009_3_13 0 bpf_c009_3 0) vcvs gain=-8.314696123025e-01
SMIXQ_c009_3_13 (mix_q_src_c009_3_13 mix_q_c009_3 win_3_13 0) relay vt1=-1m vt2=1m ropen=ropen_mix rclosed=rclosed_mix
EMIXI_c009_3_14 (mix_i_src_c009_3_14 0 bpf_c009_3 0) vcvs gain=8.314696123025e-01
SMIXI_c009_3_14 (mix_i_src_c009_3_14 mix_i_c009_3 win_3_14 0) relay vt1=-1m vt2=1m ropen=ropen_mix rclosed=rclosed_mix
EMIXQ_c009_3_14 (mix_q_src_c009_3_14 0 bpf_c009_3 0) vcvs gain=-5.555702330196e-01
SMIXQ_c009_3_14 (mix_q_src_c009_3_14 mix_q_c009_3 win_3_14 0) relay vt1=-1m vt2=1m ropen=ropen_mix rclosed=rclosed_mix
EMIXI_c009_3_15 (mix_i_src_c009_3_15 0 bpf_c009_3 0) vcvs gain=9.807852804032e-01
SMIXI_c009_3_15 (mix_i_src_c009_3_15 mix_i_c009_3 win_3_15 0) relay vt1=-1m vt2=1m ropen=ropen_mix rclosed=rclosed_mix
EMIXQ_c009_3_15 (mix_q_src_c009_3_15 0 bpf_c009_3 0) vcvs gain=-1.950903220161e-01
SMIXQ_c009_3_15 (mix_q_src_c009_3_15 mix_q_c009_3 win_3_15 0) relay vt1=-1m vt2=1m ropen=ropen_mix rclosed=rclosed_mix
RMIXI_c009_3 (mix_i_c009_3 0) resistor r=1G
RMIXQ_c009_3 (mix_q_c009_3 0) resistor r=1G
RINTI_c009_3 (mix_i_c009_3 Icar_c009_3) resistor r=1k
CINTI_c009_3 (Icar_c009_3 0) capacitor c=80p
RINTQ_c009_3 (mix_q_c009_3 Qcar_c009_3) resistor r=1k
CINTQ_c009_3 (Qcar_c009_3 0) capacitor c=80p
save bpf_c009_3 Icar_c009_3 Qcar_c009_3

// bl010, carrier_0: 250000000 Hz coherent I/Q phase-window verification-demod path
CBPF_c010_0 (bl010 n_cbpf_c010_0) capacitor c=4.052847345694e-13
LBPF_c010_0 (n_cbpf_c010_0 bpf_c010_0) inductor l=1.000000000000e-06
RBPF_c010_0 (bpf_c010_0 0) resistor r=7.853981633974e+01
EMIXI_c010_0_00 (mix_i_src_c010_0_00 0 bpf_c010_0 0) vcvs gain=9.807852804032e-01
SMIXI_c010_0_00 (mix_i_src_c010_0_00 mix_i_c010_0 win_0_00 0) relay vt1=-1m vt2=1m ropen=ropen_mix rclosed=rclosed_mix
EMIXQ_c010_0_00 (mix_q_src_c010_0_00 0 bpf_c010_0 0) vcvs gain=1.950903220161e-01
SMIXQ_c010_0_00 (mix_q_src_c010_0_00 mix_q_c010_0 win_0_00 0) relay vt1=-1m vt2=1m ropen=ropen_mix rclosed=rclosed_mix
EMIXI_c010_0_01 (mix_i_src_c010_0_01 0 bpf_c010_0 0) vcvs gain=8.314696123025e-01
SMIXI_c010_0_01 (mix_i_src_c010_0_01 mix_i_c010_0 win_0_01 0) relay vt1=-1m vt2=1m ropen=ropen_mix rclosed=rclosed_mix
EMIXQ_c010_0_01 (mix_q_src_c010_0_01 0 bpf_c010_0 0) vcvs gain=5.555702330196e-01
SMIXQ_c010_0_01 (mix_q_src_c010_0_01 mix_q_c010_0 win_0_01 0) relay vt1=-1m vt2=1m ropen=ropen_mix rclosed=rclosed_mix
EMIXI_c010_0_02 (mix_i_src_c010_0_02 0 bpf_c010_0 0) vcvs gain=5.555702330196e-01
SMIXI_c010_0_02 (mix_i_src_c010_0_02 mix_i_c010_0 win_0_02 0) relay vt1=-1m vt2=1m ropen=ropen_mix rclosed=rclosed_mix
EMIXQ_c010_0_02 (mix_q_src_c010_0_02 0 bpf_c010_0 0) vcvs gain=8.314696123025e-01
SMIXQ_c010_0_02 (mix_q_src_c010_0_02 mix_q_c010_0 win_0_02 0) relay vt1=-1m vt2=1m ropen=ropen_mix rclosed=rclosed_mix
EMIXI_c010_0_03 (mix_i_src_c010_0_03 0 bpf_c010_0 0) vcvs gain=1.950903220161e-01
SMIXI_c010_0_03 (mix_i_src_c010_0_03 mix_i_c010_0 win_0_03 0) relay vt1=-1m vt2=1m ropen=ropen_mix rclosed=rclosed_mix
EMIXQ_c010_0_03 (mix_q_src_c010_0_03 0 bpf_c010_0 0) vcvs gain=9.807852804032e-01
SMIXQ_c010_0_03 (mix_q_src_c010_0_03 mix_q_c010_0 win_0_03 0) relay vt1=-1m vt2=1m ropen=ropen_mix rclosed=rclosed_mix
EMIXI_c010_0_04 (mix_i_src_c010_0_04 0 bpf_c010_0 0) vcvs gain=-1.950903220161e-01
SMIXI_c010_0_04 (mix_i_src_c010_0_04 mix_i_c010_0 win_0_04 0) relay vt1=-1m vt2=1m ropen=ropen_mix rclosed=rclosed_mix
EMIXQ_c010_0_04 (mix_q_src_c010_0_04 0 bpf_c010_0 0) vcvs gain=9.807852804032e-01
SMIXQ_c010_0_04 (mix_q_src_c010_0_04 mix_q_c010_0 win_0_04 0) relay vt1=-1m vt2=1m ropen=ropen_mix rclosed=rclosed_mix
EMIXI_c010_0_05 (mix_i_src_c010_0_05 0 bpf_c010_0 0) vcvs gain=-5.555702330196e-01
SMIXI_c010_0_05 (mix_i_src_c010_0_05 mix_i_c010_0 win_0_05 0) relay vt1=-1m vt2=1m ropen=ropen_mix rclosed=rclosed_mix
EMIXQ_c010_0_05 (mix_q_src_c010_0_05 0 bpf_c010_0 0) vcvs gain=8.314696123025e-01
SMIXQ_c010_0_05 (mix_q_src_c010_0_05 mix_q_c010_0 win_0_05 0) relay vt1=-1m vt2=1m ropen=ropen_mix rclosed=rclosed_mix
EMIXI_c010_0_06 (mix_i_src_c010_0_06 0 bpf_c010_0 0) vcvs gain=-8.314696123025e-01
SMIXI_c010_0_06 (mix_i_src_c010_0_06 mix_i_c010_0 win_0_06 0) relay vt1=-1m vt2=1m ropen=ropen_mix rclosed=rclosed_mix
EMIXQ_c010_0_06 (mix_q_src_c010_0_06 0 bpf_c010_0 0) vcvs gain=5.555702330196e-01
SMIXQ_c010_0_06 (mix_q_src_c010_0_06 mix_q_c010_0 win_0_06 0) relay vt1=-1m vt2=1m ropen=ropen_mix rclosed=rclosed_mix
EMIXI_c010_0_07 (mix_i_src_c010_0_07 0 bpf_c010_0 0) vcvs gain=-9.807852804032e-01
SMIXI_c010_0_07 (mix_i_src_c010_0_07 mix_i_c010_0 win_0_07 0) relay vt1=-1m vt2=1m ropen=ropen_mix rclosed=rclosed_mix
EMIXQ_c010_0_07 (mix_q_src_c010_0_07 0 bpf_c010_0 0) vcvs gain=1.950903220161e-01
SMIXQ_c010_0_07 (mix_q_src_c010_0_07 mix_q_c010_0 win_0_07 0) relay vt1=-1m vt2=1m ropen=ropen_mix rclosed=rclosed_mix
EMIXI_c010_0_08 (mix_i_src_c010_0_08 0 bpf_c010_0 0) vcvs gain=-9.807852804032e-01
SMIXI_c010_0_08 (mix_i_src_c010_0_08 mix_i_c010_0 win_0_08 0) relay vt1=-1m vt2=1m ropen=ropen_mix rclosed=rclosed_mix
EMIXQ_c010_0_08 (mix_q_src_c010_0_08 0 bpf_c010_0 0) vcvs gain=-1.950903220161e-01
SMIXQ_c010_0_08 (mix_q_src_c010_0_08 mix_q_c010_0 win_0_08 0) relay vt1=-1m vt2=1m ropen=ropen_mix rclosed=rclosed_mix
EMIXI_c010_0_09 (mix_i_src_c010_0_09 0 bpf_c010_0 0) vcvs gain=-8.314696123025e-01
SMIXI_c010_0_09 (mix_i_src_c010_0_09 mix_i_c010_0 win_0_09 0) relay vt1=-1m vt2=1m ropen=ropen_mix rclosed=rclosed_mix
EMIXQ_c010_0_09 (mix_q_src_c010_0_09 0 bpf_c010_0 0) vcvs gain=-5.555702330196e-01
SMIXQ_c010_0_09 (mix_q_src_c010_0_09 mix_q_c010_0 win_0_09 0) relay vt1=-1m vt2=1m ropen=ropen_mix rclosed=rclosed_mix
EMIXI_c010_0_10 (mix_i_src_c010_0_10 0 bpf_c010_0 0) vcvs gain=-5.555702330196e-01
SMIXI_c010_0_10 (mix_i_src_c010_0_10 mix_i_c010_0 win_0_10 0) relay vt1=-1m vt2=1m ropen=ropen_mix rclosed=rclosed_mix
EMIXQ_c010_0_10 (mix_q_src_c010_0_10 0 bpf_c010_0 0) vcvs gain=-8.314696123025e-01
SMIXQ_c010_0_10 (mix_q_src_c010_0_10 mix_q_c010_0 win_0_10 0) relay vt1=-1m vt2=1m ropen=ropen_mix rclosed=rclosed_mix
EMIXI_c010_0_11 (mix_i_src_c010_0_11 0 bpf_c010_0 0) vcvs gain=-1.950903220161e-01
SMIXI_c010_0_11 (mix_i_src_c010_0_11 mix_i_c010_0 win_0_11 0) relay vt1=-1m vt2=1m ropen=ropen_mix rclosed=rclosed_mix
EMIXQ_c010_0_11 (mix_q_src_c010_0_11 0 bpf_c010_0 0) vcvs gain=-9.807852804032e-01
SMIXQ_c010_0_11 (mix_q_src_c010_0_11 mix_q_c010_0 win_0_11 0) relay vt1=-1m vt2=1m ropen=ropen_mix rclosed=rclosed_mix
EMIXI_c010_0_12 (mix_i_src_c010_0_12 0 bpf_c010_0 0) vcvs gain=1.950903220161e-01
SMIXI_c010_0_12 (mix_i_src_c010_0_12 mix_i_c010_0 win_0_12 0) relay vt1=-1m vt2=1m ropen=ropen_mix rclosed=rclosed_mix
EMIXQ_c010_0_12 (mix_q_src_c010_0_12 0 bpf_c010_0 0) vcvs gain=-9.807852804032e-01
SMIXQ_c010_0_12 (mix_q_src_c010_0_12 mix_q_c010_0 win_0_12 0) relay vt1=-1m vt2=1m ropen=ropen_mix rclosed=rclosed_mix
EMIXI_c010_0_13 (mix_i_src_c010_0_13 0 bpf_c010_0 0) vcvs gain=5.555702330196e-01
SMIXI_c010_0_13 (mix_i_src_c010_0_13 mix_i_c010_0 win_0_13 0) relay vt1=-1m vt2=1m ropen=ropen_mix rclosed=rclosed_mix
EMIXQ_c010_0_13 (mix_q_src_c010_0_13 0 bpf_c010_0 0) vcvs gain=-8.314696123025e-01
SMIXQ_c010_0_13 (mix_q_src_c010_0_13 mix_q_c010_0 win_0_13 0) relay vt1=-1m vt2=1m ropen=ropen_mix rclosed=rclosed_mix
EMIXI_c010_0_14 (mix_i_src_c010_0_14 0 bpf_c010_0 0) vcvs gain=8.314696123025e-01
SMIXI_c010_0_14 (mix_i_src_c010_0_14 mix_i_c010_0 win_0_14 0) relay vt1=-1m vt2=1m ropen=ropen_mix rclosed=rclosed_mix
EMIXQ_c010_0_14 (mix_q_src_c010_0_14 0 bpf_c010_0 0) vcvs gain=-5.555702330196e-01
SMIXQ_c010_0_14 (mix_q_src_c010_0_14 mix_q_c010_0 win_0_14 0) relay vt1=-1m vt2=1m ropen=ropen_mix rclosed=rclosed_mix
EMIXI_c010_0_15 (mix_i_src_c010_0_15 0 bpf_c010_0 0) vcvs gain=9.807852804032e-01
SMIXI_c010_0_15 (mix_i_src_c010_0_15 mix_i_c010_0 win_0_15 0) relay vt1=-1m vt2=1m ropen=ropen_mix rclosed=rclosed_mix
EMIXQ_c010_0_15 (mix_q_src_c010_0_15 0 bpf_c010_0 0) vcvs gain=-1.950903220161e-01
SMIXQ_c010_0_15 (mix_q_src_c010_0_15 mix_q_c010_0 win_0_15 0) relay vt1=-1m vt2=1m ropen=ropen_mix rclosed=rclosed_mix
RMIXI_c010_0 (mix_i_c010_0 0) resistor r=1G
RMIXQ_c010_0 (mix_q_c010_0 0) resistor r=1G
RINTI_c010_0 (mix_i_c010_0 Icar_c010_0) resistor r=1k
CINTI_c010_0 (Icar_c010_0 0) capacitor c=80p
RINTQ_c010_0 (mix_q_c010_0 Qcar_c010_0) resistor r=1k
CINTQ_c010_0 (Qcar_c010_0 0) capacitor c=80p
save bpf_c010_0 Icar_c010_0 Qcar_c010_0

// bl010, carrier_1: 500000000 Hz coherent I/Q phase-window verification-demod path
CBPF_c010_1 (bl010 n_cbpf_c010_1) capacitor c=1.013211836423e-13
LBPF_c010_1 (n_cbpf_c010_1 bpf_c010_1) inductor l=1.000000000000e-06
RBPF_c010_1 (bpf_c010_1 0) resistor r=1.570796326795e+02
EMIXI_c010_1_00 (mix_i_src_c010_1_00 0 bpf_c010_1 0) vcvs gain=9.807852804032e-01
SMIXI_c010_1_00 (mix_i_src_c010_1_00 mix_i_c010_1 win_1_00 0) relay vt1=-1m vt2=1m ropen=ropen_mix rclosed=rclosed_mix
EMIXQ_c010_1_00 (mix_q_src_c010_1_00 0 bpf_c010_1 0) vcvs gain=1.950903220161e-01
SMIXQ_c010_1_00 (mix_q_src_c010_1_00 mix_q_c010_1 win_1_00 0) relay vt1=-1m vt2=1m ropen=ropen_mix rclosed=rclosed_mix
EMIXI_c010_1_01 (mix_i_src_c010_1_01 0 bpf_c010_1 0) vcvs gain=8.314696123025e-01
SMIXI_c010_1_01 (mix_i_src_c010_1_01 mix_i_c010_1 win_1_01 0) relay vt1=-1m vt2=1m ropen=ropen_mix rclosed=rclosed_mix
EMIXQ_c010_1_01 (mix_q_src_c010_1_01 0 bpf_c010_1 0) vcvs gain=5.555702330196e-01
SMIXQ_c010_1_01 (mix_q_src_c010_1_01 mix_q_c010_1 win_1_01 0) relay vt1=-1m vt2=1m ropen=ropen_mix rclosed=rclosed_mix
EMIXI_c010_1_02 (mix_i_src_c010_1_02 0 bpf_c010_1 0) vcvs gain=5.555702330196e-01
SMIXI_c010_1_02 (mix_i_src_c010_1_02 mix_i_c010_1 win_1_02 0) relay vt1=-1m vt2=1m ropen=ropen_mix rclosed=rclosed_mix
EMIXQ_c010_1_02 (mix_q_src_c010_1_02 0 bpf_c010_1 0) vcvs gain=8.314696123025e-01
SMIXQ_c010_1_02 (mix_q_src_c010_1_02 mix_q_c010_1 win_1_02 0) relay vt1=-1m vt2=1m ropen=ropen_mix rclosed=rclosed_mix
EMIXI_c010_1_03 (mix_i_src_c010_1_03 0 bpf_c010_1 0) vcvs gain=1.950903220161e-01
SMIXI_c010_1_03 (mix_i_src_c010_1_03 mix_i_c010_1 win_1_03 0) relay vt1=-1m vt2=1m ropen=ropen_mix rclosed=rclosed_mix
EMIXQ_c010_1_03 (mix_q_src_c010_1_03 0 bpf_c010_1 0) vcvs gain=9.807852804032e-01
SMIXQ_c010_1_03 (mix_q_src_c010_1_03 mix_q_c010_1 win_1_03 0) relay vt1=-1m vt2=1m ropen=ropen_mix rclosed=rclosed_mix
EMIXI_c010_1_04 (mix_i_src_c010_1_04 0 bpf_c010_1 0) vcvs gain=-1.950903220161e-01
SMIXI_c010_1_04 (mix_i_src_c010_1_04 mix_i_c010_1 win_1_04 0) relay vt1=-1m vt2=1m ropen=ropen_mix rclosed=rclosed_mix
EMIXQ_c010_1_04 (mix_q_src_c010_1_04 0 bpf_c010_1 0) vcvs gain=9.807852804032e-01
SMIXQ_c010_1_04 (mix_q_src_c010_1_04 mix_q_c010_1 win_1_04 0) relay vt1=-1m vt2=1m ropen=ropen_mix rclosed=rclosed_mix
EMIXI_c010_1_05 (mix_i_src_c010_1_05 0 bpf_c010_1 0) vcvs gain=-5.555702330196e-01
SMIXI_c010_1_05 (mix_i_src_c010_1_05 mix_i_c010_1 win_1_05 0) relay vt1=-1m vt2=1m ropen=ropen_mix rclosed=rclosed_mix
EMIXQ_c010_1_05 (mix_q_src_c010_1_05 0 bpf_c010_1 0) vcvs gain=8.314696123025e-01
SMIXQ_c010_1_05 (mix_q_src_c010_1_05 mix_q_c010_1 win_1_05 0) relay vt1=-1m vt2=1m ropen=ropen_mix rclosed=rclosed_mix
EMIXI_c010_1_06 (mix_i_src_c010_1_06 0 bpf_c010_1 0) vcvs gain=-8.314696123025e-01
SMIXI_c010_1_06 (mix_i_src_c010_1_06 mix_i_c010_1 win_1_06 0) relay vt1=-1m vt2=1m ropen=ropen_mix rclosed=rclosed_mix
EMIXQ_c010_1_06 (mix_q_src_c010_1_06 0 bpf_c010_1 0) vcvs gain=5.555702330196e-01
SMIXQ_c010_1_06 (mix_q_src_c010_1_06 mix_q_c010_1 win_1_06 0) relay vt1=-1m vt2=1m ropen=ropen_mix rclosed=rclosed_mix
EMIXI_c010_1_07 (mix_i_src_c010_1_07 0 bpf_c010_1 0) vcvs gain=-9.807852804032e-01
SMIXI_c010_1_07 (mix_i_src_c010_1_07 mix_i_c010_1 win_1_07 0) relay vt1=-1m vt2=1m ropen=ropen_mix rclosed=rclosed_mix
EMIXQ_c010_1_07 (mix_q_src_c010_1_07 0 bpf_c010_1 0) vcvs gain=1.950903220161e-01
SMIXQ_c010_1_07 (mix_q_src_c010_1_07 mix_q_c010_1 win_1_07 0) relay vt1=-1m vt2=1m ropen=ropen_mix rclosed=rclosed_mix
EMIXI_c010_1_08 (mix_i_src_c010_1_08 0 bpf_c010_1 0) vcvs gain=-9.807852804032e-01
SMIXI_c010_1_08 (mix_i_src_c010_1_08 mix_i_c010_1 win_1_08 0) relay vt1=-1m vt2=1m ropen=ropen_mix rclosed=rclosed_mix
EMIXQ_c010_1_08 (mix_q_src_c010_1_08 0 bpf_c010_1 0) vcvs gain=-1.950903220161e-01
SMIXQ_c010_1_08 (mix_q_src_c010_1_08 mix_q_c010_1 win_1_08 0) relay vt1=-1m vt2=1m ropen=ropen_mix rclosed=rclosed_mix
EMIXI_c010_1_09 (mix_i_src_c010_1_09 0 bpf_c010_1 0) vcvs gain=-8.314696123025e-01
SMIXI_c010_1_09 (mix_i_src_c010_1_09 mix_i_c010_1 win_1_09 0) relay vt1=-1m vt2=1m ropen=ropen_mix rclosed=rclosed_mix
EMIXQ_c010_1_09 (mix_q_src_c010_1_09 0 bpf_c010_1 0) vcvs gain=-5.555702330196e-01
SMIXQ_c010_1_09 (mix_q_src_c010_1_09 mix_q_c010_1 win_1_09 0) relay vt1=-1m vt2=1m ropen=ropen_mix rclosed=rclosed_mix
EMIXI_c010_1_10 (mix_i_src_c010_1_10 0 bpf_c010_1 0) vcvs gain=-5.555702330196e-01
SMIXI_c010_1_10 (mix_i_src_c010_1_10 mix_i_c010_1 win_1_10 0) relay vt1=-1m vt2=1m ropen=ropen_mix rclosed=rclosed_mix
EMIXQ_c010_1_10 (mix_q_src_c010_1_10 0 bpf_c010_1 0) vcvs gain=-8.314696123025e-01
SMIXQ_c010_1_10 (mix_q_src_c010_1_10 mix_q_c010_1 win_1_10 0) relay vt1=-1m vt2=1m ropen=ropen_mix rclosed=rclosed_mix
EMIXI_c010_1_11 (mix_i_src_c010_1_11 0 bpf_c010_1 0) vcvs gain=-1.950903220161e-01
SMIXI_c010_1_11 (mix_i_src_c010_1_11 mix_i_c010_1 win_1_11 0) relay vt1=-1m vt2=1m ropen=ropen_mix rclosed=rclosed_mix
EMIXQ_c010_1_11 (mix_q_src_c010_1_11 0 bpf_c010_1 0) vcvs gain=-9.807852804032e-01
SMIXQ_c010_1_11 (mix_q_src_c010_1_11 mix_q_c010_1 win_1_11 0) relay vt1=-1m vt2=1m ropen=ropen_mix rclosed=rclosed_mix
EMIXI_c010_1_12 (mix_i_src_c010_1_12 0 bpf_c010_1 0) vcvs gain=1.950903220161e-01
SMIXI_c010_1_12 (mix_i_src_c010_1_12 mix_i_c010_1 win_1_12 0) relay vt1=-1m vt2=1m ropen=ropen_mix rclosed=rclosed_mix
EMIXQ_c010_1_12 (mix_q_src_c010_1_12 0 bpf_c010_1 0) vcvs gain=-9.807852804032e-01
SMIXQ_c010_1_12 (mix_q_src_c010_1_12 mix_q_c010_1 win_1_12 0) relay vt1=-1m vt2=1m ropen=ropen_mix rclosed=rclosed_mix
EMIXI_c010_1_13 (mix_i_src_c010_1_13 0 bpf_c010_1 0) vcvs gain=5.555702330196e-01
SMIXI_c010_1_13 (mix_i_src_c010_1_13 mix_i_c010_1 win_1_13 0) relay vt1=-1m vt2=1m ropen=ropen_mix rclosed=rclosed_mix
EMIXQ_c010_1_13 (mix_q_src_c010_1_13 0 bpf_c010_1 0) vcvs gain=-8.314696123025e-01
SMIXQ_c010_1_13 (mix_q_src_c010_1_13 mix_q_c010_1 win_1_13 0) relay vt1=-1m vt2=1m ropen=ropen_mix rclosed=rclosed_mix
EMIXI_c010_1_14 (mix_i_src_c010_1_14 0 bpf_c010_1 0) vcvs gain=8.314696123025e-01
SMIXI_c010_1_14 (mix_i_src_c010_1_14 mix_i_c010_1 win_1_14 0) relay vt1=-1m vt2=1m ropen=ropen_mix rclosed=rclosed_mix
EMIXQ_c010_1_14 (mix_q_src_c010_1_14 0 bpf_c010_1 0) vcvs gain=-5.555702330196e-01
SMIXQ_c010_1_14 (mix_q_src_c010_1_14 mix_q_c010_1 win_1_14 0) relay vt1=-1m vt2=1m ropen=ropen_mix rclosed=rclosed_mix
EMIXI_c010_1_15 (mix_i_src_c010_1_15 0 bpf_c010_1 0) vcvs gain=9.807852804032e-01
SMIXI_c010_1_15 (mix_i_src_c010_1_15 mix_i_c010_1 win_1_15 0) relay vt1=-1m vt2=1m ropen=ropen_mix rclosed=rclosed_mix
EMIXQ_c010_1_15 (mix_q_src_c010_1_15 0 bpf_c010_1 0) vcvs gain=-1.950903220161e-01
SMIXQ_c010_1_15 (mix_q_src_c010_1_15 mix_q_c010_1 win_1_15 0) relay vt1=-1m vt2=1m ropen=ropen_mix rclosed=rclosed_mix
RMIXI_c010_1 (mix_i_c010_1 0) resistor r=1G
RMIXQ_c010_1 (mix_q_c010_1 0) resistor r=1G
RINTI_c010_1 (mix_i_c010_1 Icar_c010_1) resistor r=1k
CINTI_c010_1 (Icar_c010_1 0) capacitor c=80p
RINTQ_c010_1 (mix_q_c010_1 Qcar_c010_1) resistor r=1k
CINTQ_c010_1 (Qcar_c010_1 0) capacitor c=80p
save bpf_c010_1 Icar_c010_1 Qcar_c010_1

// bl010, carrier_2: 750000000 Hz coherent I/Q phase-window verification-demod path
CBPF_c010_2 (bl010 n_cbpf_c010_2) capacitor c=4.503163717437e-14
LBPF_c010_2 (n_cbpf_c010_2 bpf_c010_2) inductor l=1.000000000000e-06
RBPF_c010_2 (bpf_c010_2 0) resistor r=2.356194490192e+02
EMIXI_c010_2_00 (mix_i_src_c010_2_00 0 bpf_c010_2 0) vcvs gain=9.807852804032e-01
SMIXI_c010_2_00 (mix_i_src_c010_2_00 mix_i_c010_2 win_2_00 0) relay vt1=-1m vt2=1m ropen=ropen_mix rclosed=rclosed_mix
EMIXQ_c010_2_00 (mix_q_src_c010_2_00 0 bpf_c010_2 0) vcvs gain=1.950903220161e-01
SMIXQ_c010_2_00 (mix_q_src_c010_2_00 mix_q_c010_2 win_2_00 0) relay vt1=-1m vt2=1m ropen=ropen_mix rclosed=rclosed_mix
EMIXI_c010_2_01 (mix_i_src_c010_2_01 0 bpf_c010_2 0) vcvs gain=8.314696123025e-01
SMIXI_c010_2_01 (mix_i_src_c010_2_01 mix_i_c010_2 win_2_01 0) relay vt1=-1m vt2=1m ropen=ropen_mix rclosed=rclosed_mix
EMIXQ_c010_2_01 (mix_q_src_c010_2_01 0 bpf_c010_2 0) vcvs gain=5.555702330196e-01
SMIXQ_c010_2_01 (mix_q_src_c010_2_01 mix_q_c010_2 win_2_01 0) relay vt1=-1m vt2=1m ropen=ropen_mix rclosed=rclosed_mix
EMIXI_c010_2_02 (mix_i_src_c010_2_02 0 bpf_c010_2 0) vcvs gain=5.555702330196e-01
SMIXI_c010_2_02 (mix_i_src_c010_2_02 mix_i_c010_2 win_2_02 0) relay vt1=-1m vt2=1m ropen=ropen_mix rclosed=rclosed_mix
EMIXQ_c010_2_02 (mix_q_src_c010_2_02 0 bpf_c010_2 0) vcvs gain=8.314696123025e-01
SMIXQ_c010_2_02 (mix_q_src_c010_2_02 mix_q_c010_2 win_2_02 0) relay vt1=-1m vt2=1m ropen=ropen_mix rclosed=rclosed_mix
EMIXI_c010_2_03 (mix_i_src_c010_2_03 0 bpf_c010_2 0) vcvs gain=1.950903220161e-01
SMIXI_c010_2_03 (mix_i_src_c010_2_03 mix_i_c010_2 win_2_03 0) relay vt1=-1m vt2=1m ropen=ropen_mix rclosed=rclosed_mix
EMIXQ_c010_2_03 (mix_q_src_c010_2_03 0 bpf_c010_2 0) vcvs gain=9.807852804032e-01
SMIXQ_c010_2_03 (mix_q_src_c010_2_03 mix_q_c010_2 win_2_03 0) relay vt1=-1m vt2=1m ropen=ropen_mix rclosed=rclosed_mix
EMIXI_c010_2_04 (mix_i_src_c010_2_04 0 bpf_c010_2 0) vcvs gain=-1.950903220161e-01
SMIXI_c010_2_04 (mix_i_src_c010_2_04 mix_i_c010_2 win_2_04 0) relay vt1=-1m vt2=1m ropen=ropen_mix rclosed=rclosed_mix
EMIXQ_c010_2_04 (mix_q_src_c010_2_04 0 bpf_c010_2 0) vcvs gain=9.807852804032e-01
SMIXQ_c010_2_04 (mix_q_src_c010_2_04 mix_q_c010_2 win_2_04 0) relay vt1=-1m vt2=1m ropen=ropen_mix rclosed=rclosed_mix
EMIXI_c010_2_05 (mix_i_src_c010_2_05 0 bpf_c010_2 0) vcvs gain=-5.555702330196e-01
SMIXI_c010_2_05 (mix_i_src_c010_2_05 mix_i_c010_2 win_2_05 0) relay vt1=-1m vt2=1m ropen=ropen_mix rclosed=rclosed_mix
EMIXQ_c010_2_05 (mix_q_src_c010_2_05 0 bpf_c010_2 0) vcvs gain=8.314696123025e-01
SMIXQ_c010_2_05 (mix_q_src_c010_2_05 mix_q_c010_2 win_2_05 0) relay vt1=-1m vt2=1m ropen=ropen_mix rclosed=rclosed_mix
EMIXI_c010_2_06 (mix_i_src_c010_2_06 0 bpf_c010_2 0) vcvs gain=-8.314696123025e-01
SMIXI_c010_2_06 (mix_i_src_c010_2_06 mix_i_c010_2 win_2_06 0) relay vt1=-1m vt2=1m ropen=ropen_mix rclosed=rclosed_mix
EMIXQ_c010_2_06 (mix_q_src_c010_2_06 0 bpf_c010_2 0) vcvs gain=5.555702330196e-01
SMIXQ_c010_2_06 (mix_q_src_c010_2_06 mix_q_c010_2 win_2_06 0) relay vt1=-1m vt2=1m ropen=ropen_mix rclosed=rclosed_mix
EMIXI_c010_2_07 (mix_i_src_c010_2_07 0 bpf_c010_2 0) vcvs gain=-9.807852804032e-01
SMIXI_c010_2_07 (mix_i_src_c010_2_07 mix_i_c010_2 win_2_07 0) relay vt1=-1m vt2=1m ropen=ropen_mix rclosed=rclosed_mix
EMIXQ_c010_2_07 (mix_q_src_c010_2_07 0 bpf_c010_2 0) vcvs gain=1.950903220161e-01
SMIXQ_c010_2_07 (mix_q_src_c010_2_07 mix_q_c010_2 win_2_07 0) relay vt1=-1m vt2=1m ropen=ropen_mix rclosed=rclosed_mix
EMIXI_c010_2_08 (mix_i_src_c010_2_08 0 bpf_c010_2 0) vcvs gain=-9.807852804032e-01
SMIXI_c010_2_08 (mix_i_src_c010_2_08 mix_i_c010_2 win_2_08 0) relay vt1=-1m vt2=1m ropen=ropen_mix rclosed=rclosed_mix
EMIXQ_c010_2_08 (mix_q_src_c010_2_08 0 bpf_c010_2 0) vcvs gain=-1.950903220161e-01
SMIXQ_c010_2_08 (mix_q_src_c010_2_08 mix_q_c010_2 win_2_08 0) relay vt1=-1m vt2=1m ropen=ropen_mix rclosed=rclosed_mix
EMIXI_c010_2_09 (mix_i_src_c010_2_09 0 bpf_c010_2 0) vcvs gain=-8.314696123025e-01
SMIXI_c010_2_09 (mix_i_src_c010_2_09 mix_i_c010_2 win_2_09 0) relay vt1=-1m vt2=1m ropen=ropen_mix rclosed=rclosed_mix
EMIXQ_c010_2_09 (mix_q_src_c010_2_09 0 bpf_c010_2 0) vcvs gain=-5.555702330196e-01
SMIXQ_c010_2_09 (mix_q_src_c010_2_09 mix_q_c010_2 win_2_09 0) relay vt1=-1m vt2=1m ropen=ropen_mix rclosed=rclosed_mix
EMIXI_c010_2_10 (mix_i_src_c010_2_10 0 bpf_c010_2 0) vcvs gain=-5.555702330196e-01
SMIXI_c010_2_10 (mix_i_src_c010_2_10 mix_i_c010_2 win_2_10 0) relay vt1=-1m vt2=1m ropen=ropen_mix rclosed=rclosed_mix
EMIXQ_c010_2_10 (mix_q_src_c010_2_10 0 bpf_c010_2 0) vcvs gain=-8.314696123025e-01
SMIXQ_c010_2_10 (mix_q_src_c010_2_10 mix_q_c010_2 win_2_10 0) relay vt1=-1m vt2=1m ropen=ropen_mix rclosed=rclosed_mix
EMIXI_c010_2_11 (mix_i_src_c010_2_11 0 bpf_c010_2 0) vcvs gain=-1.950903220161e-01
SMIXI_c010_2_11 (mix_i_src_c010_2_11 mix_i_c010_2 win_2_11 0) relay vt1=-1m vt2=1m ropen=ropen_mix rclosed=rclosed_mix
EMIXQ_c010_2_11 (mix_q_src_c010_2_11 0 bpf_c010_2 0) vcvs gain=-9.807852804032e-01
SMIXQ_c010_2_11 (mix_q_src_c010_2_11 mix_q_c010_2 win_2_11 0) relay vt1=-1m vt2=1m ropen=ropen_mix rclosed=rclosed_mix
EMIXI_c010_2_12 (mix_i_src_c010_2_12 0 bpf_c010_2 0) vcvs gain=1.950903220161e-01
SMIXI_c010_2_12 (mix_i_src_c010_2_12 mix_i_c010_2 win_2_12 0) relay vt1=-1m vt2=1m ropen=ropen_mix rclosed=rclosed_mix
EMIXQ_c010_2_12 (mix_q_src_c010_2_12 0 bpf_c010_2 0) vcvs gain=-9.807852804032e-01
SMIXQ_c010_2_12 (mix_q_src_c010_2_12 mix_q_c010_2 win_2_12 0) relay vt1=-1m vt2=1m ropen=ropen_mix rclosed=rclosed_mix
EMIXI_c010_2_13 (mix_i_src_c010_2_13 0 bpf_c010_2 0) vcvs gain=5.555702330196e-01
SMIXI_c010_2_13 (mix_i_src_c010_2_13 mix_i_c010_2 win_2_13 0) relay vt1=-1m vt2=1m ropen=ropen_mix rclosed=rclosed_mix
EMIXQ_c010_2_13 (mix_q_src_c010_2_13 0 bpf_c010_2 0) vcvs gain=-8.314696123025e-01
SMIXQ_c010_2_13 (mix_q_src_c010_2_13 mix_q_c010_2 win_2_13 0) relay vt1=-1m vt2=1m ropen=ropen_mix rclosed=rclosed_mix
EMIXI_c010_2_14 (mix_i_src_c010_2_14 0 bpf_c010_2 0) vcvs gain=8.314696123025e-01
SMIXI_c010_2_14 (mix_i_src_c010_2_14 mix_i_c010_2 win_2_14 0) relay vt1=-1m vt2=1m ropen=ropen_mix rclosed=rclosed_mix
EMIXQ_c010_2_14 (mix_q_src_c010_2_14 0 bpf_c010_2 0) vcvs gain=-5.555702330196e-01
SMIXQ_c010_2_14 (mix_q_src_c010_2_14 mix_q_c010_2 win_2_14 0) relay vt1=-1m vt2=1m ropen=ropen_mix rclosed=rclosed_mix
EMIXI_c010_2_15 (mix_i_src_c010_2_15 0 bpf_c010_2 0) vcvs gain=9.807852804032e-01
SMIXI_c010_2_15 (mix_i_src_c010_2_15 mix_i_c010_2 win_2_15 0) relay vt1=-1m vt2=1m ropen=ropen_mix rclosed=rclosed_mix
EMIXQ_c010_2_15 (mix_q_src_c010_2_15 0 bpf_c010_2 0) vcvs gain=-1.950903220161e-01
SMIXQ_c010_2_15 (mix_q_src_c010_2_15 mix_q_c010_2 win_2_15 0) relay vt1=-1m vt2=1m ropen=ropen_mix rclosed=rclosed_mix
RMIXI_c010_2 (mix_i_c010_2 0) resistor r=1G
RMIXQ_c010_2 (mix_q_c010_2 0) resistor r=1G
RINTI_c010_2 (mix_i_c010_2 Icar_c010_2) resistor r=1k
CINTI_c010_2 (Icar_c010_2 0) capacitor c=80p
RINTQ_c010_2 (mix_q_c010_2 Qcar_c010_2) resistor r=1k
CINTQ_c010_2 (Qcar_c010_2 0) capacitor c=80p
save bpf_c010_2 Icar_c010_2 Qcar_c010_2

// bl010, carrier_3: 1000000000 Hz coherent I/Q phase-window verification-demod path
CBPF_c010_3 (bl010 n_cbpf_c010_3) capacitor c=2.533029591058e-14
LBPF_c010_3 (n_cbpf_c010_3 bpf_c010_3) inductor l=1.000000000000e-06
RBPF_c010_3 (bpf_c010_3 0) resistor r=3.141592653590e+02
EMIXI_c010_3_00 (mix_i_src_c010_3_00 0 bpf_c010_3 0) vcvs gain=9.807852804032e-01
SMIXI_c010_3_00 (mix_i_src_c010_3_00 mix_i_c010_3 win_3_00 0) relay vt1=-1m vt2=1m ropen=ropen_mix rclosed=rclosed_mix
EMIXQ_c010_3_00 (mix_q_src_c010_3_00 0 bpf_c010_3 0) vcvs gain=1.950903220161e-01
SMIXQ_c010_3_00 (mix_q_src_c010_3_00 mix_q_c010_3 win_3_00 0) relay vt1=-1m vt2=1m ropen=ropen_mix rclosed=rclosed_mix
EMIXI_c010_3_01 (mix_i_src_c010_3_01 0 bpf_c010_3 0) vcvs gain=8.314696123025e-01
SMIXI_c010_3_01 (mix_i_src_c010_3_01 mix_i_c010_3 win_3_01 0) relay vt1=-1m vt2=1m ropen=ropen_mix rclosed=rclosed_mix
EMIXQ_c010_3_01 (mix_q_src_c010_3_01 0 bpf_c010_3 0) vcvs gain=5.555702330196e-01
SMIXQ_c010_3_01 (mix_q_src_c010_3_01 mix_q_c010_3 win_3_01 0) relay vt1=-1m vt2=1m ropen=ropen_mix rclosed=rclosed_mix
EMIXI_c010_3_02 (mix_i_src_c010_3_02 0 bpf_c010_3 0) vcvs gain=5.555702330196e-01
SMIXI_c010_3_02 (mix_i_src_c010_3_02 mix_i_c010_3 win_3_02 0) relay vt1=-1m vt2=1m ropen=ropen_mix rclosed=rclosed_mix
EMIXQ_c010_3_02 (mix_q_src_c010_3_02 0 bpf_c010_3 0) vcvs gain=8.314696123025e-01
SMIXQ_c010_3_02 (mix_q_src_c010_3_02 mix_q_c010_3 win_3_02 0) relay vt1=-1m vt2=1m ropen=ropen_mix rclosed=rclosed_mix
EMIXI_c010_3_03 (mix_i_src_c010_3_03 0 bpf_c010_3 0) vcvs gain=1.950903220161e-01
SMIXI_c010_3_03 (mix_i_src_c010_3_03 mix_i_c010_3 win_3_03 0) relay vt1=-1m vt2=1m ropen=ropen_mix rclosed=rclosed_mix
EMIXQ_c010_3_03 (mix_q_src_c010_3_03 0 bpf_c010_3 0) vcvs gain=9.807852804032e-01
SMIXQ_c010_3_03 (mix_q_src_c010_3_03 mix_q_c010_3 win_3_03 0) relay vt1=-1m vt2=1m ropen=ropen_mix rclosed=rclosed_mix
EMIXI_c010_3_04 (mix_i_src_c010_3_04 0 bpf_c010_3 0) vcvs gain=-1.950903220161e-01
SMIXI_c010_3_04 (mix_i_src_c010_3_04 mix_i_c010_3 win_3_04 0) relay vt1=-1m vt2=1m ropen=ropen_mix rclosed=rclosed_mix
EMIXQ_c010_3_04 (mix_q_src_c010_3_04 0 bpf_c010_3 0) vcvs gain=9.807852804032e-01
SMIXQ_c010_3_04 (mix_q_src_c010_3_04 mix_q_c010_3 win_3_04 0) relay vt1=-1m vt2=1m ropen=ropen_mix rclosed=rclosed_mix
EMIXI_c010_3_05 (mix_i_src_c010_3_05 0 bpf_c010_3 0) vcvs gain=-5.555702330196e-01
SMIXI_c010_3_05 (mix_i_src_c010_3_05 mix_i_c010_3 win_3_05 0) relay vt1=-1m vt2=1m ropen=ropen_mix rclosed=rclosed_mix
EMIXQ_c010_3_05 (mix_q_src_c010_3_05 0 bpf_c010_3 0) vcvs gain=8.314696123025e-01
SMIXQ_c010_3_05 (mix_q_src_c010_3_05 mix_q_c010_3 win_3_05 0) relay vt1=-1m vt2=1m ropen=ropen_mix rclosed=rclosed_mix
EMIXI_c010_3_06 (mix_i_src_c010_3_06 0 bpf_c010_3 0) vcvs gain=-8.314696123025e-01
SMIXI_c010_3_06 (mix_i_src_c010_3_06 mix_i_c010_3 win_3_06 0) relay vt1=-1m vt2=1m ropen=ropen_mix rclosed=rclosed_mix
EMIXQ_c010_3_06 (mix_q_src_c010_3_06 0 bpf_c010_3 0) vcvs gain=5.555702330196e-01
SMIXQ_c010_3_06 (mix_q_src_c010_3_06 mix_q_c010_3 win_3_06 0) relay vt1=-1m vt2=1m ropen=ropen_mix rclosed=rclosed_mix
EMIXI_c010_3_07 (mix_i_src_c010_3_07 0 bpf_c010_3 0) vcvs gain=-9.807852804032e-01
SMIXI_c010_3_07 (mix_i_src_c010_3_07 mix_i_c010_3 win_3_07 0) relay vt1=-1m vt2=1m ropen=ropen_mix rclosed=rclosed_mix
EMIXQ_c010_3_07 (mix_q_src_c010_3_07 0 bpf_c010_3 0) vcvs gain=1.950903220161e-01
SMIXQ_c010_3_07 (mix_q_src_c010_3_07 mix_q_c010_3 win_3_07 0) relay vt1=-1m vt2=1m ropen=ropen_mix rclosed=rclosed_mix
EMIXI_c010_3_08 (mix_i_src_c010_3_08 0 bpf_c010_3 0) vcvs gain=-9.807852804032e-01
SMIXI_c010_3_08 (mix_i_src_c010_3_08 mix_i_c010_3 win_3_08 0) relay vt1=-1m vt2=1m ropen=ropen_mix rclosed=rclosed_mix
EMIXQ_c010_3_08 (mix_q_src_c010_3_08 0 bpf_c010_3 0) vcvs gain=-1.950903220161e-01
SMIXQ_c010_3_08 (mix_q_src_c010_3_08 mix_q_c010_3 win_3_08 0) relay vt1=-1m vt2=1m ropen=ropen_mix rclosed=rclosed_mix
EMIXI_c010_3_09 (mix_i_src_c010_3_09 0 bpf_c010_3 0) vcvs gain=-8.314696123025e-01
SMIXI_c010_3_09 (mix_i_src_c010_3_09 mix_i_c010_3 win_3_09 0) relay vt1=-1m vt2=1m ropen=ropen_mix rclosed=rclosed_mix
EMIXQ_c010_3_09 (mix_q_src_c010_3_09 0 bpf_c010_3 0) vcvs gain=-5.555702330196e-01
SMIXQ_c010_3_09 (mix_q_src_c010_3_09 mix_q_c010_3 win_3_09 0) relay vt1=-1m vt2=1m ropen=ropen_mix rclosed=rclosed_mix
EMIXI_c010_3_10 (mix_i_src_c010_3_10 0 bpf_c010_3 0) vcvs gain=-5.555702330196e-01
SMIXI_c010_3_10 (mix_i_src_c010_3_10 mix_i_c010_3 win_3_10 0) relay vt1=-1m vt2=1m ropen=ropen_mix rclosed=rclosed_mix
EMIXQ_c010_3_10 (mix_q_src_c010_3_10 0 bpf_c010_3 0) vcvs gain=-8.314696123025e-01
SMIXQ_c010_3_10 (mix_q_src_c010_3_10 mix_q_c010_3 win_3_10 0) relay vt1=-1m vt2=1m ropen=ropen_mix rclosed=rclosed_mix
EMIXI_c010_3_11 (mix_i_src_c010_3_11 0 bpf_c010_3 0) vcvs gain=-1.950903220161e-01
SMIXI_c010_3_11 (mix_i_src_c010_3_11 mix_i_c010_3 win_3_11 0) relay vt1=-1m vt2=1m ropen=ropen_mix rclosed=rclosed_mix
EMIXQ_c010_3_11 (mix_q_src_c010_3_11 0 bpf_c010_3 0) vcvs gain=-9.807852804032e-01
SMIXQ_c010_3_11 (mix_q_src_c010_3_11 mix_q_c010_3 win_3_11 0) relay vt1=-1m vt2=1m ropen=ropen_mix rclosed=rclosed_mix
EMIXI_c010_3_12 (mix_i_src_c010_3_12 0 bpf_c010_3 0) vcvs gain=1.950903220161e-01
SMIXI_c010_3_12 (mix_i_src_c010_3_12 mix_i_c010_3 win_3_12 0) relay vt1=-1m vt2=1m ropen=ropen_mix rclosed=rclosed_mix
EMIXQ_c010_3_12 (mix_q_src_c010_3_12 0 bpf_c010_3 0) vcvs gain=-9.807852804032e-01
SMIXQ_c010_3_12 (mix_q_src_c010_3_12 mix_q_c010_3 win_3_12 0) relay vt1=-1m vt2=1m ropen=ropen_mix rclosed=rclosed_mix
EMIXI_c010_3_13 (mix_i_src_c010_3_13 0 bpf_c010_3 0) vcvs gain=5.555702330196e-01
SMIXI_c010_3_13 (mix_i_src_c010_3_13 mix_i_c010_3 win_3_13 0) relay vt1=-1m vt2=1m ropen=ropen_mix rclosed=rclosed_mix
EMIXQ_c010_3_13 (mix_q_src_c010_3_13 0 bpf_c010_3 0) vcvs gain=-8.314696123025e-01
SMIXQ_c010_3_13 (mix_q_src_c010_3_13 mix_q_c010_3 win_3_13 0) relay vt1=-1m vt2=1m ropen=ropen_mix rclosed=rclosed_mix
EMIXI_c010_3_14 (mix_i_src_c010_3_14 0 bpf_c010_3 0) vcvs gain=8.314696123025e-01
SMIXI_c010_3_14 (mix_i_src_c010_3_14 mix_i_c010_3 win_3_14 0) relay vt1=-1m vt2=1m ropen=ropen_mix rclosed=rclosed_mix
EMIXQ_c010_3_14 (mix_q_src_c010_3_14 0 bpf_c010_3 0) vcvs gain=-5.555702330196e-01
SMIXQ_c010_3_14 (mix_q_src_c010_3_14 mix_q_c010_3 win_3_14 0) relay vt1=-1m vt2=1m ropen=ropen_mix rclosed=rclosed_mix
EMIXI_c010_3_15 (mix_i_src_c010_3_15 0 bpf_c010_3 0) vcvs gain=9.807852804032e-01
SMIXI_c010_3_15 (mix_i_src_c010_3_15 mix_i_c010_3 win_3_15 0) relay vt1=-1m vt2=1m ropen=ropen_mix rclosed=rclosed_mix
EMIXQ_c010_3_15 (mix_q_src_c010_3_15 0 bpf_c010_3 0) vcvs gain=-1.950903220161e-01
SMIXQ_c010_3_15 (mix_q_src_c010_3_15 mix_q_c010_3 win_3_15 0) relay vt1=-1m vt2=1m ropen=ropen_mix rclosed=rclosed_mix
RMIXI_c010_3 (mix_i_c010_3 0) resistor r=1G
RMIXQ_c010_3 (mix_q_c010_3 0) resistor r=1G
RINTI_c010_3 (mix_i_c010_3 Icar_c010_3) resistor r=1k
CINTI_c010_3 (Icar_c010_3 0) capacitor c=80p
RINTQ_c010_3 (mix_q_c010_3 Qcar_c010_3) resistor r=1k
CINTQ_c010_3 (Qcar_c010_3 0) capacitor c=80p
save bpf_c010_3 Icar_c010_3 Qcar_c010_3

// bl011, carrier_0: 250000000 Hz coherent I/Q phase-window verification-demod path
CBPF_c011_0 (bl011 n_cbpf_c011_0) capacitor c=4.052847345694e-13
LBPF_c011_0 (n_cbpf_c011_0 bpf_c011_0) inductor l=1.000000000000e-06
RBPF_c011_0 (bpf_c011_0 0) resistor r=7.853981633974e+01
EMIXI_c011_0_00 (mix_i_src_c011_0_00 0 bpf_c011_0 0) vcvs gain=9.807852804032e-01
SMIXI_c011_0_00 (mix_i_src_c011_0_00 mix_i_c011_0 win_0_00 0) relay vt1=-1m vt2=1m ropen=ropen_mix rclosed=rclosed_mix
EMIXQ_c011_0_00 (mix_q_src_c011_0_00 0 bpf_c011_0 0) vcvs gain=1.950903220161e-01
SMIXQ_c011_0_00 (mix_q_src_c011_0_00 mix_q_c011_0 win_0_00 0) relay vt1=-1m vt2=1m ropen=ropen_mix rclosed=rclosed_mix
EMIXI_c011_0_01 (mix_i_src_c011_0_01 0 bpf_c011_0 0) vcvs gain=8.314696123025e-01
SMIXI_c011_0_01 (mix_i_src_c011_0_01 mix_i_c011_0 win_0_01 0) relay vt1=-1m vt2=1m ropen=ropen_mix rclosed=rclosed_mix
EMIXQ_c011_0_01 (mix_q_src_c011_0_01 0 bpf_c011_0 0) vcvs gain=5.555702330196e-01
SMIXQ_c011_0_01 (mix_q_src_c011_0_01 mix_q_c011_0 win_0_01 0) relay vt1=-1m vt2=1m ropen=ropen_mix rclosed=rclosed_mix
EMIXI_c011_0_02 (mix_i_src_c011_0_02 0 bpf_c011_0 0) vcvs gain=5.555702330196e-01
SMIXI_c011_0_02 (mix_i_src_c011_0_02 mix_i_c011_0 win_0_02 0) relay vt1=-1m vt2=1m ropen=ropen_mix rclosed=rclosed_mix
EMIXQ_c011_0_02 (mix_q_src_c011_0_02 0 bpf_c011_0 0) vcvs gain=8.314696123025e-01
SMIXQ_c011_0_02 (mix_q_src_c011_0_02 mix_q_c011_0 win_0_02 0) relay vt1=-1m vt2=1m ropen=ropen_mix rclosed=rclosed_mix
EMIXI_c011_0_03 (mix_i_src_c011_0_03 0 bpf_c011_0 0) vcvs gain=1.950903220161e-01
SMIXI_c011_0_03 (mix_i_src_c011_0_03 mix_i_c011_0 win_0_03 0) relay vt1=-1m vt2=1m ropen=ropen_mix rclosed=rclosed_mix
EMIXQ_c011_0_03 (mix_q_src_c011_0_03 0 bpf_c011_0 0) vcvs gain=9.807852804032e-01
SMIXQ_c011_0_03 (mix_q_src_c011_0_03 mix_q_c011_0 win_0_03 0) relay vt1=-1m vt2=1m ropen=ropen_mix rclosed=rclosed_mix
EMIXI_c011_0_04 (mix_i_src_c011_0_04 0 bpf_c011_0 0) vcvs gain=-1.950903220161e-01
SMIXI_c011_0_04 (mix_i_src_c011_0_04 mix_i_c011_0 win_0_04 0) relay vt1=-1m vt2=1m ropen=ropen_mix rclosed=rclosed_mix
EMIXQ_c011_0_04 (mix_q_src_c011_0_04 0 bpf_c011_0 0) vcvs gain=9.807852804032e-01
SMIXQ_c011_0_04 (mix_q_src_c011_0_04 mix_q_c011_0 win_0_04 0) relay vt1=-1m vt2=1m ropen=ropen_mix rclosed=rclosed_mix
EMIXI_c011_0_05 (mix_i_src_c011_0_05 0 bpf_c011_0 0) vcvs gain=-5.555702330196e-01
SMIXI_c011_0_05 (mix_i_src_c011_0_05 mix_i_c011_0 win_0_05 0) relay vt1=-1m vt2=1m ropen=ropen_mix rclosed=rclosed_mix
EMIXQ_c011_0_05 (mix_q_src_c011_0_05 0 bpf_c011_0 0) vcvs gain=8.314696123025e-01
SMIXQ_c011_0_05 (mix_q_src_c011_0_05 mix_q_c011_0 win_0_05 0) relay vt1=-1m vt2=1m ropen=ropen_mix rclosed=rclosed_mix
EMIXI_c011_0_06 (mix_i_src_c011_0_06 0 bpf_c011_0 0) vcvs gain=-8.314696123025e-01
SMIXI_c011_0_06 (mix_i_src_c011_0_06 mix_i_c011_0 win_0_06 0) relay vt1=-1m vt2=1m ropen=ropen_mix rclosed=rclosed_mix
EMIXQ_c011_0_06 (mix_q_src_c011_0_06 0 bpf_c011_0 0) vcvs gain=5.555702330196e-01
SMIXQ_c011_0_06 (mix_q_src_c011_0_06 mix_q_c011_0 win_0_06 0) relay vt1=-1m vt2=1m ropen=ropen_mix rclosed=rclosed_mix
EMIXI_c011_0_07 (mix_i_src_c011_0_07 0 bpf_c011_0 0) vcvs gain=-9.807852804032e-01
SMIXI_c011_0_07 (mix_i_src_c011_0_07 mix_i_c011_0 win_0_07 0) relay vt1=-1m vt2=1m ropen=ropen_mix rclosed=rclosed_mix
EMIXQ_c011_0_07 (mix_q_src_c011_0_07 0 bpf_c011_0 0) vcvs gain=1.950903220161e-01
SMIXQ_c011_0_07 (mix_q_src_c011_0_07 mix_q_c011_0 win_0_07 0) relay vt1=-1m vt2=1m ropen=ropen_mix rclosed=rclosed_mix
EMIXI_c011_0_08 (mix_i_src_c011_0_08 0 bpf_c011_0 0) vcvs gain=-9.807852804032e-01
SMIXI_c011_0_08 (mix_i_src_c011_0_08 mix_i_c011_0 win_0_08 0) relay vt1=-1m vt2=1m ropen=ropen_mix rclosed=rclosed_mix
EMIXQ_c011_0_08 (mix_q_src_c011_0_08 0 bpf_c011_0 0) vcvs gain=-1.950903220161e-01
SMIXQ_c011_0_08 (mix_q_src_c011_0_08 mix_q_c011_0 win_0_08 0) relay vt1=-1m vt2=1m ropen=ropen_mix rclosed=rclosed_mix
EMIXI_c011_0_09 (mix_i_src_c011_0_09 0 bpf_c011_0 0) vcvs gain=-8.314696123025e-01
SMIXI_c011_0_09 (mix_i_src_c011_0_09 mix_i_c011_0 win_0_09 0) relay vt1=-1m vt2=1m ropen=ropen_mix rclosed=rclosed_mix
EMIXQ_c011_0_09 (mix_q_src_c011_0_09 0 bpf_c011_0 0) vcvs gain=-5.555702330196e-01
SMIXQ_c011_0_09 (mix_q_src_c011_0_09 mix_q_c011_0 win_0_09 0) relay vt1=-1m vt2=1m ropen=ropen_mix rclosed=rclosed_mix
EMIXI_c011_0_10 (mix_i_src_c011_0_10 0 bpf_c011_0 0) vcvs gain=-5.555702330196e-01
SMIXI_c011_0_10 (mix_i_src_c011_0_10 mix_i_c011_0 win_0_10 0) relay vt1=-1m vt2=1m ropen=ropen_mix rclosed=rclosed_mix
EMIXQ_c011_0_10 (mix_q_src_c011_0_10 0 bpf_c011_0 0) vcvs gain=-8.314696123025e-01
SMIXQ_c011_0_10 (mix_q_src_c011_0_10 mix_q_c011_0 win_0_10 0) relay vt1=-1m vt2=1m ropen=ropen_mix rclosed=rclosed_mix
EMIXI_c011_0_11 (mix_i_src_c011_0_11 0 bpf_c011_0 0) vcvs gain=-1.950903220161e-01
SMIXI_c011_0_11 (mix_i_src_c011_0_11 mix_i_c011_0 win_0_11 0) relay vt1=-1m vt2=1m ropen=ropen_mix rclosed=rclosed_mix
EMIXQ_c011_0_11 (mix_q_src_c011_0_11 0 bpf_c011_0 0) vcvs gain=-9.807852804032e-01
SMIXQ_c011_0_11 (mix_q_src_c011_0_11 mix_q_c011_0 win_0_11 0) relay vt1=-1m vt2=1m ropen=ropen_mix rclosed=rclosed_mix
EMIXI_c011_0_12 (mix_i_src_c011_0_12 0 bpf_c011_0 0) vcvs gain=1.950903220161e-01
SMIXI_c011_0_12 (mix_i_src_c011_0_12 mix_i_c011_0 win_0_12 0) relay vt1=-1m vt2=1m ropen=ropen_mix rclosed=rclosed_mix
EMIXQ_c011_0_12 (mix_q_src_c011_0_12 0 bpf_c011_0 0) vcvs gain=-9.807852804032e-01
SMIXQ_c011_0_12 (mix_q_src_c011_0_12 mix_q_c011_0 win_0_12 0) relay vt1=-1m vt2=1m ropen=ropen_mix rclosed=rclosed_mix
EMIXI_c011_0_13 (mix_i_src_c011_0_13 0 bpf_c011_0 0) vcvs gain=5.555702330196e-01
SMIXI_c011_0_13 (mix_i_src_c011_0_13 mix_i_c011_0 win_0_13 0) relay vt1=-1m vt2=1m ropen=ropen_mix rclosed=rclosed_mix
EMIXQ_c011_0_13 (mix_q_src_c011_0_13 0 bpf_c011_0 0) vcvs gain=-8.314696123025e-01
SMIXQ_c011_0_13 (mix_q_src_c011_0_13 mix_q_c011_0 win_0_13 0) relay vt1=-1m vt2=1m ropen=ropen_mix rclosed=rclosed_mix
EMIXI_c011_0_14 (mix_i_src_c011_0_14 0 bpf_c011_0 0) vcvs gain=8.314696123025e-01
SMIXI_c011_0_14 (mix_i_src_c011_0_14 mix_i_c011_0 win_0_14 0) relay vt1=-1m vt2=1m ropen=ropen_mix rclosed=rclosed_mix
EMIXQ_c011_0_14 (mix_q_src_c011_0_14 0 bpf_c011_0 0) vcvs gain=-5.555702330196e-01
SMIXQ_c011_0_14 (mix_q_src_c011_0_14 mix_q_c011_0 win_0_14 0) relay vt1=-1m vt2=1m ropen=ropen_mix rclosed=rclosed_mix
EMIXI_c011_0_15 (mix_i_src_c011_0_15 0 bpf_c011_0 0) vcvs gain=9.807852804032e-01
SMIXI_c011_0_15 (mix_i_src_c011_0_15 mix_i_c011_0 win_0_15 0) relay vt1=-1m vt2=1m ropen=ropen_mix rclosed=rclosed_mix
EMIXQ_c011_0_15 (mix_q_src_c011_0_15 0 bpf_c011_0 0) vcvs gain=-1.950903220161e-01
SMIXQ_c011_0_15 (mix_q_src_c011_0_15 mix_q_c011_0 win_0_15 0) relay vt1=-1m vt2=1m ropen=ropen_mix rclosed=rclosed_mix
RMIXI_c011_0 (mix_i_c011_0 0) resistor r=1G
RMIXQ_c011_0 (mix_q_c011_0 0) resistor r=1G
RINTI_c011_0 (mix_i_c011_0 Icar_c011_0) resistor r=1k
CINTI_c011_0 (Icar_c011_0 0) capacitor c=80p
RINTQ_c011_0 (mix_q_c011_0 Qcar_c011_0) resistor r=1k
CINTQ_c011_0 (Qcar_c011_0 0) capacitor c=80p
save bpf_c011_0 Icar_c011_0 Qcar_c011_0

// bl011, carrier_1: 500000000 Hz coherent I/Q phase-window verification-demod path
CBPF_c011_1 (bl011 n_cbpf_c011_1) capacitor c=1.013211836423e-13
LBPF_c011_1 (n_cbpf_c011_1 bpf_c011_1) inductor l=1.000000000000e-06
RBPF_c011_1 (bpf_c011_1 0) resistor r=1.570796326795e+02
EMIXI_c011_1_00 (mix_i_src_c011_1_00 0 bpf_c011_1 0) vcvs gain=9.807852804032e-01
SMIXI_c011_1_00 (mix_i_src_c011_1_00 mix_i_c011_1 win_1_00 0) relay vt1=-1m vt2=1m ropen=ropen_mix rclosed=rclosed_mix
EMIXQ_c011_1_00 (mix_q_src_c011_1_00 0 bpf_c011_1 0) vcvs gain=1.950903220161e-01
SMIXQ_c011_1_00 (mix_q_src_c011_1_00 mix_q_c011_1 win_1_00 0) relay vt1=-1m vt2=1m ropen=ropen_mix rclosed=rclosed_mix
EMIXI_c011_1_01 (mix_i_src_c011_1_01 0 bpf_c011_1 0) vcvs gain=8.314696123025e-01
SMIXI_c011_1_01 (mix_i_src_c011_1_01 mix_i_c011_1 win_1_01 0) relay vt1=-1m vt2=1m ropen=ropen_mix rclosed=rclosed_mix
EMIXQ_c011_1_01 (mix_q_src_c011_1_01 0 bpf_c011_1 0) vcvs gain=5.555702330196e-01
SMIXQ_c011_1_01 (mix_q_src_c011_1_01 mix_q_c011_1 win_1_01 0) relay vt1=-1m vt2=1m ropen=ropen_mix rclosed=rclosed_mix
EMIXI_c011_1_02 (mix_i_src_c011_1_02 0 bpf_c011_1 0) vcvs gain=5.555702330196e-01
SMIXI_c011_1_02 (mix_i_src_c011_1_02 mix_i_c011_1 win_1_02 0) relay vt1=-1m vt2=1m ropen=ropen_mix rclosed=rclosed_mix
EMIXQ_c011_1_02 (mix_q_src_c011_1_02 0 bpf_c011_1 0) vcvs gain=8.314696123025e-01
SMIXQ_c011_1_02 (mix_q_src_c011_1_02 mix_q_c011_1 win_1_02 0) relay vt1=-1m vt2=1m ropen=ropen_mix rclosed=rclosed_mix
EMIXI_c011_1_03 (mix_i_src_c011_1_03 0 bpf_c011_1 0) vcvs gain=1.950903220161e-01
SMIXI_c011_1_03 (mix_i_src_c011_1_03 mix_i_c011_1 win_1_03 0) relay vt1=-1m vt2=1m ropen=ropen_mix rclosed=rclosed_mix
EMIXQ_c011_1_03 (mix_q_src_c011_1_03 0 bpf_c011_1 0) vcvs gain=9.807852804032e-01
SMIXQ_c011_1_03 (mix_q_src_c011_1_03 mix_q_c011_1 win_1_03 0) relay vt1=-1m vt2=1m ropen=ropen_mix rclosed=rclosed_mix
EMIXI_c011_1_04 (mix_i_src_c011_1_04 0 bpf_c011_1 0) vcvs gain=-1.950903220161e-01
SMIXI_c011_1_04 (mix_i_src_c011_1_04 mix_i_c011_1 win_1_04 0) relay vt1=-1m vt2=1m ropen=ropen_mix rclosed=rclosed_mix
EMIXQ_c011_1_04 (mix_q_src_c011_1_04 0 bpf_c011_1 0) vcvs gain=9.807852804032e-01
SMIXQ_c011_1_04 (mix_q_src_c011_1_04 mix_q_c011_1 win_1_04 0) relay vt1=-1m vt2=1m ropen=ropen_mix rclosed=rclosed_mix
EMIXI_c011_1_05 (mix_i_src_c011_1_05 0 bpf_c011_1 0) vcvs gain=-5.555702330196e-01
SMIXI_c011_1_05 (mix_i_src_c011_1_05 mix_i_c011_1 win_1_05 0) relay vt1=-1m vt2=1m ropen=ropen_mix rclosed=rclosed_mix
EMIXQ_c011_1_05 (mix_q_src_c011_1_05 0 bpf_c011_1 0) vcvs gain=8.314696123025e-01
SMIXQ_c011_1_05 (mix_q_src_c011_1_05 mix_q_c011_1 win_1_05 0) relay vt1=-1m vt2=1m ropen=ropen_mix rclosed=rclosed_mix
EMIXI_c011_1_06 (mix_i_src_c011_1_06 0 bpf_c011_1 0) vcvs gain=-8.314696123025e-01
SMIXI_c011_1_06 (mix_i_src_c011_1_06 mix_i_c011_1 win_1_06 0) relay vt1=-1m vt2=1m ropen=ropen_mix rclosed=rclosed_mix
EMIXQ_c011_1_06 (mix_q_src_c011_1_06 0 bpf_c011_1 0) vcvs gain=5.555702330196e-01
SMIXQ_c011_1_06 (mix_q_src_c011_1_06 mix_q_c011_1 win_1_06 0) relay vt1=-1m vt2=1m ropen=ropen_mix rclosed=rclosed_mix
EMIXI_c011_1_07 (mix_i_src_c011_1_07 0 bpf_c011_1 0) vcvs gain=-9.807852804032e-01
SMIXI_c011_1_07 (mix_i_src_c011_1_07 mix_i_c011_1 win_1_07 0) relay vt1=-1m vt2=1m ropen=ropen_mix rclosed=rclosed_mix
EMIXQ_c011_1_07 (mix_q_src_c011_1_07 0 bpf_c011_1 0) vcvs gain=1.950903220161e-01
SMIXQ_c011_1_07 (mix_q_src_c011_1_07 mix_q_c011_1 win_1_07 0) relay vt1=-1m vt2=1m ropen=ropen_mix rclosed=rclosed_mix
EMIXI_c011_1_08 (mix_i_src_c011_1_08 0 bpf_c011_1 0) vcvs gain=-9.807852804032e-01
SMIXI_c011_1_08 (mix_i_src_c011_1_08 mix_i_c011_1 win_1_08 0) relay vt1=-1m vt2=1m ropen=ropen_mix rclosed=rclosed_mix
EMIXQ_c011_1_08 (mix_q_src_c011_1_08 0 bpf_c011_1 0) vcvs gain=-1.950903220161e-01
SMIXQ_c011_1_08 (mix_q_src_c011_1_08 mix_q_c011_1 win_1_08 0) relay vt1=-1m vt2=1m ropen=ropen_mix rclosed=rclosed_mix
EMIXI_c011_1_09 (mix_i_src_c011_1_09 0 bpf_c011_1 0) vcvs gain=-8.314696123025e-01
SMIXI_c011_1_09 (mix_i_src_c011_1_09 mix_i_c011_1 win_1_09 0) relay vt1=-1m vt2=1m ropen=ropen_mix rclosed=rclosed_mix
EMIXQ_c011_1_09 (mix_q_src_c011_1_09 0 bpf_c011_1 0) vcvs gain=-5.555702330196e-01
SMIXQ_c011_1_09 (mix_q_src_c011_1_09 mix_q_c011_1 win_1_09 0) relay vt1=-1m vt2=1m ropen=ropen_mix rclosed=rclosed_mix
EMIXI_c011_1_10 (mix_i_src_c011_1_10 0 bpf_c011_1 0) vcvs gain=-5.555702330196e-01
SMIXI_c011_1_10 (mix_i_src_c011_1_10 mix_i_c011_1 win_1_10 0) relay vt1=-1m vt2=1m ropen=ropen_mix rclosed=rclosed_mix
EMIXQ_c011_1_10 (mix_q_src_c011_1_10 0 bpf_c011_1 0) vcvs gain=-8.314696123025e-01
SMIXQ_c011_1_10 (mix_q_src_c011_1_10 mix_q_c011_1 win_1_10 0) relay vt1=-1m vt2=1m ropen=ropen_mix rclosed=rclosed_mix
EMIXI_c011_1_11 (mix_i_src_c011_1_11 0 bpf_c011_1 0) vcvs gain=-1.950903220161e-01
SMIXI_c011_1_11 (mix_i_src_c011_1_11 mix_i_c011_1 win_1_11 0) relay vt1=-1m vt2=1m ropen=ropen_mix rclosed=rclosed_mix
EMIXQ_c011_1_11 (mix_q_src_c011_1_11 0 bpf_c011_1 0) vcvs gain=-9.807852804032e-01
SMIXQ_c011_1_11 (mix_q_src_c011_1_11 mix_q_c011_1 win_1_11 0) relay vt1=-1m vt2=1m ropen=ropen_mix rclosed=rclosed_mix
EMIXI_c011_1_12 (mix_i_src_c011_1_12 0 bpf_c011_1 0) vcvs gain=1.950903220161e-01
SMIXI_c011_1_12 (mix_i_src_c011_1_12 mix_i_c011_1 win_1_12 0) relay vt1=-1m vt2=1m ropen=ropen_mix rclosed=rclosed_mix
EMIXQ_c011_1_12 (mix_q_src_c011_1_12 0 bpf_c011_1 0) vcvs gain=-9.807852804032e-01
SMIXQ_c011_1_12 (mix_q_src_c011_1_12 mix_q_c011_1 win_1_12 0) relay vt1=-1m vt2=1m ropen=ropen_mix rclosed=rclosed_mix
EMIXI_c011_1_13 (mix_i_src_c011_1_13 0 bpf_c011_1 0) vcvs gain=5.555702330196e-01
SMIXI_c011_1_13 (mix_i_src_c011_1_13 mix_i_c011_1 win_1_13 0) relay vt1=-1m vt2=1m ropen=ropen_mix rclosed=rclosed_mix
EMIXQ_c011_1_13 (mix_q_src_c011_1_13 0 bpf_c011_1 0) vcvs gain=-8.314696123025e-01
SMIXQ_c011_1_13 (mix_q_src_c011_1_13 mix_q_c011_1 win_1_13 0) relay vt1=-1m vt2=1m ropen=ropen_mix rclosed=rclosed_mix
EMIXI_c011_1_14 (mix_i_src_c011_1_14 0 bpf_c011_1 0) vcvs gain=8.314696123025e-01
SMIXI_c011_1_14 (mix_i_src_c011_1_14 mix_i_c011_1 win_1_14 0) relay vt1=-1m vt2=1m ropen=ropen_mix rclosed=rclosed_mix
EMIXQ_c011_1_14 (mix_q_src_c011_1_14 0 bpf_c011_1 0) vcvs gain=-5.555702330196e-01
SMIXQ_c011_1_14 (mix_q_src_c011_1_14 mix_q_c011_1 win_1_14 0) relay vt1=-1m vt2=1m ropen=ropen_mix rclosed=rclosed_mix
EMIXI_c011_1_15 (mix_i_src_c011_1_15 0 bpf_c011_1 0) vcvs gain=9.807852804032e-01
SMIXI_c011_1_15 (mix_i_src_c011_1_15 mix_i_c011_1 win_1_15 0) relay vt1=-1m vt2=1m ropen=ropen_mix rclosed=rclosed_mix
EMIXQ_c011_1_15 (mix_q_src_c011_1_15 0 bpf_c011_1 0) vcvs gain=-1.950903220161e-01
SMIXQ_c011_1_15 (mix_q_src_c011_1_15 mix_q_c011_1 win_1_15 0) relay vt1=-1m vt2=1m ropen=ropen_mix rclosed=rclosed_mix
RMIXI_c011_1 (mix_i_c011_1 0) resistor r=1G
RMIXQ_c011_1 (mix_q_c011_1 0) resistor r=1G
RINTI_c011_1 (mix_i_c011_1 Icar_c011_1) resistor r=1k
CINTI_c011_1 (Icar_c011_1 0) capacitor c=80p
RINTQ_c011_1 (mix_q_c011_1 Qcar_c011_1) resistor r=1k
CINTQ_c011_1 (Qcar_c011_1 0) capacitor c=80p
save bpf_c011_1 Icar_c011_1 Qcar_c011_1

// bl011, carrier_2: 750000000 Hz coherent I/Q phase-window verification-demod path
CBPF_c011_2 (bl011 n_cbpf_c011_2) capacitor c=4.503163717437e-14
LBPF_c011_2 (n_cbpf_c011_2 bpf_c011_2) inductor l=1.000000000000e-06
RBPF_c011_2 (bpf_c011_2 0) resistor r=2.356194490192e+02
EMIXI_c011_2_00 (mix_i_src_c011_2_00 0 bpf_c011_2 0) vcvs gain=9.807852804032e-01
SMIXI_c011_2_00 (mix_i_src_c011_2_00 mix_i_c011_2 win_2_00 0) relay vt1=-1m vt2=1m ropen=ropen_mix rclosed=rclosed_mix
EMIXQ_c011_2_00 (mix_q_src_c011_2_00 0 bpf_c011_2 0) vcvs gain=1.950903220161e-01
SMIXQ_c011_2_00 (mix_q_src_c011_2_00 mix_q_c011_2 win_2_00 0) relay vt1=-1m vt2=1m ropen=ropen_mix rclosed=rclosed_mix
EMIXI_c011_2_01 (mix_i_src_c011_2_01 0 bpf_c011_2 0) vcvs gain=8.314696123025e-01
SMIXI_c011_2_01 (mix_i_src_c011_2_01 mix_i_c011_2 win_2_01 0) relay vt1=-1m vt2=1m ropen=ropen_mix rclosed=rclosed_mix
EMIXQ_c011_2_01 (mix_q_src_c011_2_01 0 bpf_c011_2 0) vcvs gain=5.555702330196e-01
SMIXQ_c011_2_01 (mix_q_src_c011_2_01 mix_q_c011_2 win_2_01 0) relay vt1=-1m vt2=1m ropen=ropen_mix rclosed=rclosed_mix
EMIXI_c011_2_02 (mix_i_src_c011_2_02 0 bpf_c011_2 0) vcvs gain=5.555702330196e-01
SMIXI_c011_2_02 (mix_i_src_c011_2_02 mix_i_c011_2 win_2_02 0) relay vt1=-1m vt2=1m ropen=ropen_mix rclosed=rclosed_mix
EMIXQ_c011_2_02 (mix_q_src_c011_2_02 0 bpf_c011_2 0) vcvs gain=8.314696123025e-01
SMIXQ_c011_2_02 (mix_q_src_c011_2_02 mix_q_c011_2 win_2_02 0) relay vt1=-1m vt2=1m ropen=ropen_mix rclosed=rclosed_mix
EMIXI_c011_2_03 (mix_i_src_c011_2_03 0 bpf_c011_2 0) vcvs gain=1.950903220161e-01
SMIXI_c011_2_03 (mix_i_src_c011_2_03 mix_i_c011_2 win_2_03 0) relay vt1=-1m vt2=1m ropen=ropen_mix rclosed=rclosed_mix
EMIXQ_c011_2_03 (mix_q_src_c011_2_03 0 bpf_c011_2 0) vcvs gain=9.807852804032e-01
SMIXQ_c011_2_03 (mix_q_src_c011_2_03 mix_q_c011_2 win_2_03 0) relay vt1=-1m vt2=1m ropen=ropen_mix rclosed=rclosed_mix
EMIXI_c011_2_04 (mix_i_src_c011_2_04 0 bpf_c011_2 0) vcvs gain=-1.950903220161e-01
SMIXI_c011_2_04 (mix_i_src_c011_2_04 mix_i_c011_2 win_2_04 0) relay vt1=-1m vt2=1m ropen=ropen_mix rclosed=rclosed_mix
EMIXQ_c011_2_04 (mix_q_src_c011_2_04 0 bpf_c011_2 0) vcvs gain=9.807852804032e-01
SMIXQ_c011_2_04 (mix_q_src_c011_2_04 mix_q_c011_2 win_2_04 0) relay vt1=-1m vt2=1m ropen=ropen_mix rclosed=rclosed_mix
EMIXI_c011_2_05 (mix_i_src_c011_2_05 0 bpf_c011_2 0) vcvs gain=-5.555702330196e-01
SMIXI_c011_2_05 (mix_i_src_c011_2_05 mix_i_c011_2 win_2_05 0) relay vt1=-1m vt2=1m ropen=ropen_mix rclosed=rclosed_mix
EMIXQ_c011_2_05 (mix_q_src_c011_2_05 0 bpf_c011_2 0) vcvs gain=8.314696123025e-01
SMIXQ_c011_2_05 (mix_q_src_c011_2_05 mix_q_c011_2 win_2_05 0) relay vt1=-1m vt2=1m ropen=ropen_mix rclosed=rclosed_mix
EMIXI_c011_2_06 (mix_i_src_c011_2_06 0 bpf_c011_2 0) vcvs gain=-8.314696123025e-01
SMIXI_c011_2_06 (mix_i_src_c011_2_06 mix_i_c011_2 win_2_06 0) relay vt1=-1m vt2=1m ropen=ropen_mix rclosed=rclosed_mix
EMIXQ_c011_2_06 (mix_q_src_c011_2_06 0 bpf_c011_2 0) vcvs gain=5.555702330196e-01
SMIXQ_c011_2_06 (mix_q_src_c011_2_06 mix_q_c011_2 win_2_06 0) relay vt1=-1m vt2=1m ropen=ropen_mix rclosed=rclosed_mix
EMIXI_c011_2_07 (mix_i_src_c011_2_07 0 bpf_c011_2 0) vcvs gain=-9.807852804032e-01
SMIXI_c011_2_07 (mix_i_src_c011_2_07 mix_i_c011_2 win_2_07 0) relay vt1=-1m vt2=1m ropen=ropen_mix rclosed=rclosed_mix
EMIXQ_c011_2_07 (mix_q_src_c011_2_07 0 bpf_c011_2 0) vcvs gain=1.950903220161e-01
SMIXQ_c011_2_07 (mix_q_src_c011_2_07 mix_q_c011_2 win_2_07 0) relay vt1=-1m vt2=1m ropen=ropen_mix rclosed=rclosed_mix
EMIXI_c011_2_08 (mix_i_src_c011_2_08 0 bpf_c011_2 0) vcvs gain=-9.807852804032e-01
SMIXI_c011_2_08 (mix_i_src_c011_2_08 mix_i_c011_2 win_2_08 0) relay vt1=-1m vt2=1m ropen=ropen_mix rclosed=rclosed_mix
EMIXQ_c011_2_08 (mix_q_src_c011_2_08 0 bpf_c011_2 0) vcvs gain=-1.950903220161e-01
SMIXQ_c011_2_08 (mix_q_src_c011_2_08 mix_q_c011_2 win_2_08 0) relay vt1=-1m vt2=1m ropen=ropen_mix rclosed=rclosed_mix
EMIXI_c011_2_09 (mix_i_src_c011_2_09 0 bpf_c011_2 0) vcvs gain=-8.314696123025e-01
SMIXI_c011_2_09 (mix_i_src_c011_2_09 mix_i_c011_2 win_2_09 0) relay vt1=-1m vt2=1m ropen=ropen_mix rclosed=rclosed_mix
EMIXQ_c011_2_09 (mix_q_src_c011_2_09 0 bpf_c011_2 0) vcvs gain=-5.555702330196e-01
SMIXQ_c011_2_09 (mix_q_src_c011_2_09 mix_q_c011_2 win_2_09 0) relay vt1=-1m vt2=1m ropen=ropen_mix rclosed=rclosed_mix
EMIXI_c011_2_10 (mix_i_src_c011_2_10 0 bpf_c011_2 0) vcvs gain=-5.555702330196e-01
SMIXI_c011_2_10 (mix_i_src_c011_2_10 mix_i_c011_2 win_2_10 0) relay vt1=-1m vt2=1m ropen=ropen_mix rclosed=rclosed_mix
EMIXQ_c011_2_10 (mix_q_src_c011_2_10 0 bpf_c011_2 0) vcvs gain=-8.314696123025e-01
SMIXQ_c011_2_10 (mix_q_src_c011_2_10 mix_q_c011_2 win_2_10 0) relay vt1=-1m vt2=1m ropen=ropen_mix rclosed=rclosed_mix
EMIXI_c011_2_11 (mix_i_src_c011_2_11 0 bpf_c011_2 0) vcvs gain=-1.950903220161e-01
SMIXI_c011_2_11 (mix_i_src_c011_2_11 mix_i_c011_2 win_2_11 0) relay vt1=-1m vt2=1m ropen=ropen_mix rclosed=rclosed_mix
EMIXQ_c011_2_11 (mix_q_src_c011_2_11 0 bpf_c011_2 0) vcvs gain=-9.807852804032e-01
SMIXQ_c011_2_11 (mix_q_src_c011_2_11 mix_q_c011_2 win_2_11 0) relay vt1=-1m vt2=1m ropen=ropen_mix rclosed=rclosed_mix
EMIXI_c011_2_12 (mix_i_src_c011_2_12 0 bpf_c011_2 0) vcvs gain=1.950903220161e-01
SMIXI_c011_2_12 (mix_i_src_c011_2_12 mix_i_c011_2 win_2_12 0) relay vt1=-1m vt2=1m ropen=ropen_mix rclosed=rclosed_mix
EMIXQ_c011_2_12 (mix_q_src_c011_2_12 0 bpf_c011_2 0) vcvs gain=-9.807852804032e-01
SMIXQ_c011_2_12 (mix_q_src_c011_2_12 mix_q_c011_2 win_2_12 0) relay vt1=-1m vt2=1m ropen=ropen_mix rclosed=rclosed_mix
EMIXI_c011_2_13 (mix_i_src_c011_2_13 0 bpf_c011_2 0) vcvs gain=5.555702330196e-01
SMIXI_c011_2_13 (mix_i_src_c011_2_13 mix_i_c011_2 win_2_13 0) relay vt1=-1m vt2=1m ropen=ropen_mix rclosed=rclosed_mix
EMIXQ_c011_2_13 (mix_q_src_c011_2_13 0 bpf_c011_2 0) vcvs gain=-8.314696123025e-01
SMIXQ_c011_2_13 (mix_q_src_c011_2_13 mix_q_c011_2 win_2_13 0) relay vt1=-1m vt2=1m ropen=ropen_mix rclosed=rclosed_mix
EMIXI_c011_2_14 (mix_i_src_c011_2_14 0 bpf_c011_2 0) vcvs gain=8.314696123025e-01
SMIXI_c011_2_14 (mix_i_src_c011_2_14 mix_i_c011_2 win_2_14 0) relay vt1=-1m vt2=1m ropen=ropen_mix rclosed=rclosed_mix
EMIXQ_c011_2_14 (mix_q_src_c011_2_14 0 bpf_c011_2 0) vcvs gain=-5.555702330196e-01
SMIXQ_c011_2_14 (mix_q_src_c011_2_14 mix_q_c011_2 win_2_14 0) relay vt1=-1m vt2=1m ropen=ropen_mix rclosed=rclosed_mix
EMIXI_c011_2_15 (mix_i_src_c011_2_15 0 bpf_c011_2 0) vcvs gain=9.807852804032e-01
SMIXI_c011_2_15 (mix_i_src_c011_2_15 mix_i_c011_2 win_2_15 0) relay vt1=-1m vt2=1m ropen=ropen_mix rclosed=rclosed_mix
EMIXQ_c011_2_15 (mix_q_src_c011_2_15 0 bpf_c011_2 0) vcvs gain=-1.950903220161e-01
SMIXQ_c011_2_15 (mix_q_src_c011_2_15 mix_q_c011_2 win_2_15 0) relay vt1=-1m vt2=1m ropen=ropen_mix rclosed=rclosed_mix
RMIXI_c011_2 (mix_i_c011_2 0) resistor r=1G
RMIXQ_c011_2 (mix_q_c011_2 0) resistor r=1G
RINTI_c011_2 (mix_i_c011_2 Icar_c011_2) resistor r=1k
CINTI_c011_2 (Icar_c011_2 0) capacitor c=80p
RINTQ_c011_2 (mix_q_c011_2 Qcar_c011_2) resistor r=1k
CINTQ_c011_2 (Qcar_c011_2 0) capacitor c=80p
save bpf_c011_2 Icar_c011_2 Qcar_c011_2

// bl011, carrier_3: 1000000000 Hz coherent I/Q phase-window verification-demod path
CBPF_c011_3 (bl011 n_cbpf_c011_3) capacitor c=2.533029591058e-14
LBPF_c011_3 (n_cbpf_c011_3 bpf_c011_3) inductor l=1.000000000000e-06
RBPF_c011_3 (bpf_c011_3 0) resistor r=3.141592653590e+02
EMIXI_c011_3_00 (mix_i_src_c011_3_00 0 bpf_c011_3 0) vcvs gain=9.807852804032e-01
SMIXI_c011_3_00 (mix_i_src_c011_3_00 mix_i_c011_3 win_3_00 0) relay vt1=-1m vt2=1m ropen=ropen_mix rclosed=rclosed_mix
EMIXQ_c011_3_00 (mix_q_src_c011_3_00 0 bpf_c011_3 0) vcvs gain=1.950903220161e-01
SMIXQ_c011_3_00 (mix_q_src_c011_3_00 mix_q_c011_3 win_3_00 0) relay vt1=-1m vt2=1m ropen=ropen_mix rclosed=rclosed_mix
EMIXI_c011_3_01 (mix_i_src_c011_3_01 0 bpf_c011_3 0) vcvs gain=8.314696123025e-01
SMIXI_c011_3_01 (mix_i_src_c011_3_01 mix_i_c011_3 win_3_01 0) relay vt1=-1m vt2=1m ropen=ropen_mix rclosed=rclosed_mix
EMIXQ_c011_3_01 (mix_q_src_c011_3_01 0 bpf_c011_3 0) vcvs gain=5.555702330196e-01
SMIXQ_c011_3_01 (mix_q_src_c011_3_01 mix_q_c011_3 win_3_01 0) relay vt1=-1m vt2=1m ropen=ropen_mix rclosed=rclosed_mix
EMIXI_c011_3_02 (mix_i_src_c011_3_02 0 bpf_c011_3 0) vcvs gain=5.555702330196e-01
SMIXI_c011_3_02 (mix_i_src_c011_3_02 mix_i_c011_3 win_3_02 0) relay vt1=-1m vt2=1m ropen=ropen_mix rclosed=rclosed_mix
EMIXQ_c011_3_02 (mix_q_src_c011_3_02 0 bpf_c011_3 0) vcvs gain=8.314696123025e-01
SMIXQ_c011_3_02 (mix_q_src_c011_3_02 mix_q_c011_3 win_3_02 0) relay vt1=-1m vt2=1m ropen=ropen_mix rclosed=rclosed_mix
EMIXI_c011_3_03 (mix_i_src_c011_3_03 0 bpf_c011_3 0) vcvs gain=1.950903220161e-01
SMIXI_c011_3_03 (mix_i_src_c011_3_03 mix_i_c011_3 win_3_03 0) relay vt1=-1m vt2=1m ropen=ropen_mix rclosed=rclosed_mix
EMIXQ_c011_3_03 (mix_q_src_c011_3_03 0 bpf_c011_3 0) vcvs gain=9.807852804032e-01
SMIXQ_c011_3_03 (mix_q_src_c011_3_03 mix_q_c011_3 win_3_03 0) relay vt1=-1m vt2=1m ropen=ropen_mix rclosed=rclosed_mix
EMIXI_c011_3_04 (mix_i_src_c011_3_04 0 bpf_c011_3 0) vcvs gain=-1.950903220161e-01
SMIXI_c011_3_04 (mix_i_src_c011_3_04 mix_i_c011_3 win_3_04 0) relay vt1=-1m vt2=1m ropen=ropen_mix rclosed=rclosed_mix
EMIXQ_c011_3_04 (mix_q_src_c011_3_04 0 bpf_c011_3 0) vcvs gain=9.807852804032e-01
SMIXQ_c011_3_04 (mix_q_src_c011_3_04 mix_q_c011_3 win_3_04 0) relay vt1=-1m vt2=1m ropen=ropen_mix rclosed=rclosed_mix
EMIXI_c011_3_05 (mix_i_src_c011_3_05 0 bpf_c011_3 0) vcvs gain=-5.555702330196e-01
SMIXI_c011_3_05 (mix_i_src_c011_3_05 mix_i_c011_3 win_3_05 0) relay vt1=-1m vt2=1m ropen=ropen_mix rclosed=rclosed_mix
EMIXQ_c011_3_05 (mix_q_src_c011_3_05 0 bpf_c011_3 0) vcvs gain=8.314696123025e-01
SMIXQ_c011_3_05 (mix_q_src_c011_3_05 mix_q_c011_3 win_3_05 0) relay vt1=-1m vt2=1m ropen=ropen_mix rclosed=rclosed_mix
EMIXI_c011_3_06 (mix_i_src_c011_3_06 0 bpf_c011_3 0) vcvs gain=-8.314696123025e-01
SMIXI_c011_3_06 (mix_i_src_c011_3_06 mix_i_c011_3 win_3_06 0) relay vt1=-1m vt2=1m ropen=ropen_mix rclosed=rclosed_mix
EMIXQ_c011_3_06 (mix_q_src_c011_3_06 0 bpf_c011_3 0) vcvs gain=5.555702330196e-01
SMIXQ_c011_3_06 (mix_q_src_c011_3_06 mix_q_c011_3 win_3_06 0) relay vt1=-1m vt2=1m ropen=ropen_mix rclosed=rclosed_mix
EMIXI_c011_3_07 (mix_i_src_c011_3_07 0 bpf_c011_3 0) vcvs gain=-9.807852804032e-01
SMIXI_c011_3_07 (mix_i_src_c011_3_07 mix_i_c011_3 win_3_07 0) relay vt1=-1m vt2=1m ropen=ropen_mix rclosed=rclosed_mix
EMIXQ_c011_3_07 (mix_q_src_c011_3_07 0 bpf_c011_3 0) vcvs gain=1.950903220161e-01
SMIXQ_c011_3_07 (mix_q_src_c011_3_07 mix_q_c011_3 win_3_07 0) relay vt1=-1m vt2=1m ropen=ropen_mix rclosed=rclosed_mix
EMIXI_c011_3_08 (mix_i_src_c011_3_08 0 bpf_c011_3 0) vcvs gain=-9.807852804032e-01
SMIXI_c011_3_08 (mix_i_src_c011_3_08 mix_i_c011_3 win_3_08 0) relay vt1=-1m vt2=1m ropen=ropen_mix rclosed=rclosed_mix
EMIXQ_c011_3_08 (mix_q_src_c011_3_08 0 bpf_c011_3 0) vcvs gain=-1.950903220161e-01
SMIXQ_c011_3_08 (mix_q_src_c011_3_08 mix_q_c011_3 win_3_08 0) relay vt1=-1m vt2=1m ropen=ropen_mix rclosed=rclosed_mix
EMIXI_c011_3_09 (mix_i_src_c011_3_09 0 bpf_c011_3 0) vcvs gain=-8.314696123025e-01
SMIXI_c011_3_09 (mix_i_src_c011_3_09 mix_i_c011_3 win_3_09 0) relay vt1=-1m vt2=1m ropen=ropen_mix rclosed=rclosed_mix
EMIXQ_c011_3_09 (mix_q_src_c011_3_09 0 bpf_c011_3 0) vcvs gain=-5.555702330196e-01
SMIXQ_c011_3_09 (mix_q_src_c011_3_09 mix_q_c011_3 win_3_09 0) relay vt1=-1m vt2=1m ropen=ropen_mix rclosed=rclosed_mix
EMIXI_c011_3_10 (mix_i_src_c011_3_10 0 bpf_c011_3 0) vcvs gain=-5.555702330196e-01
SMIXI_c011_3_10 (mix_i_src_c011_3_10 mix_i_c011_3 win_3_10 0) relay vt1=-1m vt2=1m ropen=ropen_mix rclosed=rclosed_mix
EMIXQ_c011_3_10 (mix_q_src_c011_3_10 0 bpf_c011_3 0) vcvs gain=-8.314696123025e-01
SMIXQ_c011_3_10 (mix_q_src_c011_3_10 mix_q_c011_3 win_3_10 0) relay vt1=-1m vt2=1m ropen=ropen_mix rclosed=rclosed_mix
EMIXI_c011_3_11 (mix_i_src_c011_3_11 0 bpf_c011_3 0) vcvs gain=-1.950903220161e-01
SMIXI_c011_3_11 (mix_i_src_c011_3_11 mix_i_c011_3 win_3_11 0) relay vt1=-1m vt2=1m ropen=ropen_mix rclosed=rclosed_mix
EMIXQ_c011_3_11 (mix_q_src_c011_3_11 0 bpf_c011_3 0) vcvs gain=-9.807852804032e-01
SMIXQ_c011_3_11 (mix_q_src_c011_3_11 mix_q_c011_3 win_3_11 0) relay vt1=-1m vt2=1m ropen=ropen_mix rclosed=rclosed_mix
EMIXI_c011_3_12 (mix_i_src_c011_3_12 0 bpf_c011_3 0) vcvs gain=1.950903220161e-01
SMIXI_c011_3_12 (mix_i_src_c011_3_12 mix_i_c011_3 win_3_12 0) relay vt1=-1m vt2=1m ropen=ropen_mix rclosed=rclosed_mix
EMIXQ_c011_3_12 (mix_q_src_c011_3_12 0 bpf_c011_3 0) vcvs gain=-9.807852804032e-01
SMIXQ_c011_3_12 (mix_q_src_c011_3_12 mix_q_c011_3 win_3_12 0) relay vt1=-1m vt2=1m ropen=ropen_mix rclosed=rclosed_mix
EMIXI_c011_3_13 (mix_i_src_c011_3_13 0 bpf_c011_3 0) vcvs gain=5.555702330196e-01
SMIXI_c011_3_13 (mix_i_src_c011_3_13 mix_i_c011_3 win_3_13 0) relay vt1=-1m vt2=1m ropen=ropen_mix rclosed=rclosed_mix
EMIXQ_c011_3_13 (mix_q_src_c011_3_13 0 bpf_c011_3 0) vcvs gain=-8.314696123025e-01
SMIXQ_c011_3_13 (mix_q_src_c011_3_13 mix_q_c011_3 win_3_13 0) relay vt1=-1m vt2=1m ropen=ropen_mix rclosed=rclosed_mix
EMIXI_c011_3_14 (mix_i_src_c011_3_14 0 bpf_c011_3 0) vcvs gain=8.314696123025e-01
SMIXI_c011_3_14 (mix_i_src_c011_3_14 mix_i_c011_3 win_3_14 0) relay vt1=-1m vt2=1m ropen=ropen_mix rclosed=rclosed_mix
EMIXQ_c011_3_14 (mix_q_src_c011_3_14 0 bpf_c011_3 0) vcvs gain=-5.555702330196e-01
SMIXQ_c011_3_14 (mix_q_src_c011_3_14 mix_q_c011_3 win_3_14 0) relay vt1=-1m vt2=1m ropen=ropen_mix rclosed=rclosed_mix
EMIXI_c011_3_15 (mix_i_src_c011_3_15 0 bpf_c011_3 0) vcvs gain=9.807852804032e-01
SMIXI_c011_3_15 (mix_i_src_c011_3_15 mix_i_c011_3 win_3_15 0) relay vt1=-1m vt2=1m ropen=ropen_mix rclosed=rclosed_mix
EMIXQ_c011_3_15 (mix_q_src_c011_3_15 0 bpf_c011_3 0) vcvs gain=-1.950903220161e-01
SMIXQ_c011_3_15 (mix_q_src_c011_3_15 mix_q_c011_3 win_3_15 0) relay vt1=-1m vt2=1m ropen=ropen_mix rclosed=rclosed_mix
RMIXI_c011_3 (mix_i_c011_3 0) resistor r=1G
RMIXQ_c011_3 (mix_q_c011_3 0) resistor r=1G
RINTI_c011_3 (mix_i_c011_3 Icar_c011_3) resistor r=1k
CINTI_c011_3 (Icar_c011_3 0) capacitor c=80p
RINTQ_c011_3 (mix_q_c011_3 Qcar_c011_3) resistor r=1k
CINTQ_c011_3 (Qcar_c011_3 0) capacitor c=80p
save bpf_c011_3 Icar_c011_3 Qcar_c011_3

// bl012, carrier_0: 250000000 Hz coherent I/Q phase-window verification-demod path
CBPF_c012_0 (bl012 n_cbpf_c012_0) capacitor c=4.052847345694e-13
LBPF_c012_0 (n_cbpf_c012_0 bpf_c012_0) inductor l=1.000000000000e-06
RBPF_c012_0 (bpf_c012_0 0) resistor r=7.853981633974e+01
EMIXI_c012_0_00 (mix_i_src_c012_0_00 0 bpf_c012_0 0) vcvs gain=9.807852804032e-01
SMIXI_c012_0_00 (mix_i_src_c012_0_00 mix_i_c012_0 win_0_00 0) relay vt1=-1m vt2=1m ropen=ropen_mix rclosed=rclosed_mix
EMIXQ_c012_0_00 (mix_q_src_c012_0_00 0 bpf_c012_0 0) vcvs gain=1.950903220161e-01
SMIXQ_c012_0_00 (mix_q_src_c012_0_00 mix_q_c012_0 win_0_00 0) relay vt1=-1m vt2=1m ropen=ropen_mix rclosed=rclosed_mix
EMIXI_c012_0_01 (mix_i_src_c012_0_01 0 bpf_c012_0 0) vcvs gain=8.314696123025e-01
SMIXI_c012_0_01 (mix_i_src_c012_0_01 mix_i_c012_0 win_0_01 0) relay vt1=-1m vt2=1m ropen=ropen_mix rclosed=rclosed_mix
EMIXQ_c012_0_01 (mix_q_src_c012_0_01 0 bpf_c012_0 0) vcvs gain=5.555702330196e-01
SMIXQ_c012_0_01 (mix_q_src_c012_0_01 mix_q_c012_0 win_0_01 0) relay vt1=-1m vt2=1m ropen=ropen_mix rclosed=rclosed_mix
EMIXI_c012_0_02 (mix_i_src_c012_0_02 0 bpf_c012_0 0) vcvs gain=5.555702330196e-01
SMIXI_c012_0_02 (mix_i_src_c012_0_02 mix_i_c012_0 win_0_02 0) relay vt1=-1m vt2=1m ropen=ropen_mix rclosed=rclosed_mix
EMIXQ_c012_0_02 (mix_q_src_c012_0_02 0 bpf_c012_0 0) vcvs gain=8.314696123025e-01
SMIXQ_c012_0_02 (mix_q_src_c012_0_02 mix_q_c012_0 win_0_02 0) relay vt1=-1m vt2=1m ropen=ropen_mix rclosed=rclosed_mix
EMIXI_c012_0_03 (mix_i_src_c012_0_03 0 bpf_c012_0 0) vcvs gain=1.950903220161e-01
SMIXI_c012_0_03 (mix_i_src_c012_0_03 mix_i_c012_0 win_0_03 0) relay vt1=-1m vt2=1m ropen=ropen_mix rclosed=rclosed_mix
EMIXQ_c012_0_03 (mix_q_src_c012_0_03 0 bpf_c012_0 0) vcvs gain=9.807852804032e-01
SMIXQ_c012_0_03 (mix_q_src_c012_0_03 mix_q_c012_0 win_0_03 0) relay vt1=-1m vt2=1m ropen=ropen_mix rclosed=rclosed_mix
EMIXI_c012_0_04 (mix_i_src_c012_0_04 0 bpf_c012_0 0) vcvs gain=-1.950903220161e-01
SMIXI_c012_0_04 (mix_i_src_c012_0_04 mix_i_c012_0 win_0_04 0) relay vt1=-1m vt2=1m ropen=ropen_mix rclosed=rclosed_mix
EMIXQ_c012_0_04 (mix_q_src_c012_0_04 0 bpf_c012_0 0) vcvs gain=9.807852804032e-01
SMIXQ_c012_0_04 (mix_q_src_c012_0_04 mix_q_c012_0 win_0_04 0) relay vt1=-1m vt2=1m ropen=ropen_mix rclosed=rclosed_mix
EMIXI_c012_0_05 (mix_i_src_c012_0_05 0 bpf_c012_0 0) vcvs gain=-5.555702330196e-01
SMIXI_c012_0_05 (mix_i_src_c012_0_05 mix_i_c012_0 win_0_05 0) relay vt1=-1m vt2=1m ropen=ropen_mix rclosed=rclosed_mix
EMIXQ_c012_0_05 (mix_q_src_c012_0_05 0 bpf_c012_0 0) vcvs gain=8.314696123025e-01
SMIXQ_c012_0_05 (mix_q_src_c012_0_05 mix_q_c012_0 win_0_05 0) relay vt1=-1m vt2=1m ropen=ropen_mix rclosed=rclosed_mix
EMIXI_c012_0_06 (mix_i_src_c012_0_06 0 bpf_c012_0 0) vcvs gain=-8.314696123025e-01
SMIXI_c012_0_06 (mix_i_src_c012_0_06 mix_i_c012_0 win_0_06 0) relay vt1=-1m vt2=1m ropen=ropen_mix rclosed=rclosed_mix
EMIXQ_c012_0_06 (mix_q_src_c012_0_06 0 bpf_c012_0 0) vcvs gain=5.555702330196e-01
SMIXQ_c012_0_06 (mix_q_src_c012_0_06 mix_q_c012_0 win_0_06 0) relay vt1=-1m vt2=1m ropen=ropen_mix rclosed=rclosed_mix
EMIXI_c012_0_07 (mix_i_src_c012_0_07 0 bpf_c012_0 0) vcvs gain=-9.807852804032e-01
SMIXI_c012_0_07 (mix_i_src_c012_0_07 mix_i_c012_0 win_0_07 0) relay vt1=-1m vt2=1m ropen=ropen_mix rclosed=rclosed_mix
EMIXQ_c012_0_07 (mix_q_src_c012_0_07 0 bpf_c012_0 0) vcvs gain=1.950903220161e-01
SMIXQ_c012_0_07 (mix_q_src_c012_0_07 mix_q_c012_0 win_0_07 0) relay vt1=-1m vt2=1m ropen=ropen_mix rclosed=rclosed_mix
EMIXI_c012_0_08 (mix_i_src_c012_0_08 0 bpf_c012_0 0) vcvs gain=-9.807852804032e-01
SMIXI_c012_0_08 (mix_i_src_c012_0_08 mix_i_c012_0 win_0_08 0) relay vt1=-1m vt2=1m ropen=ropen_mix rclosed=rclosed_mix
EMIXQ_c012_0_08 (mix_q_src_c012_0_08 0 bpf_c012_0 0) vcvs gain=-1.950903220161e-01
SMIXQ_c012_0_08 (mix_q_src_c012_0_08 mix_q_c012_0 win_0_08 0) relay vt1=-1m vt2=1m ropen=ropen_mix rclosed=rclosed_mix
EMIXI_c012_0_09 (mix_i_src_c012_0_09 0 bpf_c012_0 0) vcvs gain=-8.314696123025e-01
SMIXI_c012_0_09 (mix_i_src_c012_0_09 mix_i_c012_0 win_0_09 0) relay vt1=-1m vt2=1m ropen=ropen_mix rclosed=rclosed_mix
EMIXQ_c012_0_09 (mix_q_src_c012_0_09 0 bpf_c012_0 0) vcvs gain=-5.555702330196e-01
SMIXQ_c012_0_09 (mix_q_src_c012_0_09 mix_q_c012_0 win_0_09 0) relay vt1=-1m vt2=1m ropen=ropen_mix rclosed=rclosed_mix
EMIXI_c012_0_10 (mix_i_src_c012_0_10 0 bpf_c012_0 0) vcvs gain=-5.555702330196e-01
SMIXI_c012_0_10 (mix_i_src_c012_0_10 mix_i_c012_0 win_0_10 0) relay vt1=-1m vt2=1m ropen=ropen_mix rclosed=rclosed_mix
EMIXQ_c012_0_10 (mix_q_src_c012_0_10 0 bpf_c012_0 0) vcvs gain=-8.314696123025e-01
SMIXQ_c012_0_10 (mix_q_src_c012_0_10 mix_q_c012_0 win_0_10 0) relay vt1=-1m vt2=1m ropen=ropen_mix rclosed=rclosed_mix
EMIXI_c012_0_11 (mix_i_src_c012_0_11 0 bpf_c012_0 0) vcvs gain=-1.950903220161e-01
SMIXI_c012_0_11 (mix_i_src_c012_0_11 mix_i_c012_0 win_0_11 0) relay vt1=-1m vt2=1m ropen=ropen_mix rclosed=rclosed_mix
EMIXQ_c012_0_11 (mix_q_src_c012_0_11 0 bpf_c012_0 0) vcvs gain=-9.807852804032e-01
SMIXQ_c012_0_11 (mix_q_src_c012_0_11 mix_q_c012_0 win_0_11 0) relay vt1=-1m vt2=1m ropen=ropen_mix rclosed=rclosed_mix
EMIXI_c012_0_12 (mix_i_src_c012_0_12 0 bpf_c012_0 0) vcvs gain=1.950903220161e-01
SMIXI_c012_0_12 (mix_i_src_c012_0_12 mix_i_c012_0 win_0_12 0) relay vt1=-1m vt2=1m ropen=ropen_mix rclosed=rclosed_mix
EMIXQ_c012_0_12 (mix_q_src_c012_0_12 0 bpf_c012_0 0) vcvs gain=-9.807852804032e-01
SMIXQ_c012_0_12 (mix_q_src_c012_0_12 mix_q_c012_0 win_0_12 0) relay vt1=-1m vt2=1m ropen=ropen_mix rclosed=rclosed_mix
EMIXI_c012_0_13 (mix_i_src_c012_0_13 0 bpf_c012_0 0) vcvs gain=5.555702330196e-01
SMIXI_c012_0_13 (mix_i_src_c012_0_13 mix_i_c012_0 win_0_13 0) relay vt1=-1m vt2=1m ropen=ropen_mix rclosed=rclosed_mix
EMIXQ_c012_0_13 (mix_q_src_c012_0_13 0 bpf_c012_0 0) vcvs gain=-8.314696123025e-01
SMIXQ_c012_0_13 (mix_q_src_c012_0_13 mix_q_c012_0 win_0_13 0) relay vt1=-1m vt2=1m ropen=ropen_mix rclosed=rclosed_mix
EMIXI_c012_0_14 (mix_i_src_c012_0_14 0 bpf_c012_0 0) vcvs gain=8.314696123025e-01
SMIXI_c012_0_14 (mix_i_src_c012_0_14 mix_i_c012_0 win_0_14 0) relay vt1=-1m vt2=1m ropen=ropen_mix rclosed=rclosed_mix
EMIXQ_c012_0_14 (mix_q_src_c012_0_14 0 bpf_c012_0 0) vcvs gain=-5.555702330196e-01
SMIXQ_c012_0_14 (mix_q_src_c012_0_14 mix_q_c012_0 win_0_14 0) relay vt1=-1m vt2=1m ropen=ropen_mix rclosed=rclosed_mix
EMIXI_c012_0_15 (mix_i_src_c012_0_15 0 bpf_c012_0 0) vcvs gain=9.807852804032e-01
SMIXI_c012_0_15 (mix_i_src_c012_0_15 mix_i_c012_0 win_0_15 0) relay vt1=-1m vt2=1m ropen=ropen_mix rclosed=rclosed_mix
EMIXQ_c012_0_15 (mix_q_src_c012_0_15 0 bpf_c012_0 0) vcvs gain=-1.950903220161e-01
SMIXQ_c012_0_15 (mix_q_src_c012_0_15 mix_q_c012_0 win_0_15 0) relay vt1=-1m vt2=1m ropen=ropen_mix rclosed=rclosed_mix
RMIXI_c012_0 (mix_i_c012_0 0) resistor r=1G
RMIXQ_c012_0 (mix_q_c012_0 0) resistor r=1G
RINTI_c012_0 (mix_i_c012_0 Icar_c012_0) resistor r=1k
CINTI_c012_0 (Icar_c012_0 0) capacitor c=80p
RINTQ_c012_0 (mix_q_c012_0 Qcar_c012_0) resistor r=1k
CINTQ_c012_0 (Qcar_c012_0 0) capacitor c=80p
save bpf_c012_0 Icar_c012_0 Qcar_c012_0

// bl012, carrier_1: 500000000 Hz coherent I/Q phase-window verification-demod path
CBPF_c012_1 (bl012 n_cbpf_c012_1) capacitor c=1.013211836423e-13
LBPF_c012_1 (n_cbpf_c012_1 bpf_c012_1) inductor l=1.000000000000e-06
RBPF_c012_1 (bpf_c012_1 0) resistor r=1.570796326795e+02
EMIXI_c012_1_00 (mix_i_src_c012_1_00 0 bpf_c012_1 0) vcvs gain=9.807852804032e-01
SMIXI_c012_1_00 (mix_i_src_c012_1_00 mix_i_c012_1 win_1_00 0) relay vt1=-1m vt2=1m ropen=ropen_mix rclosed=rclosed_mix
EMIXQ_c012_1_00 (mix_q_src_c012_1_00 0 bpf_c012_1 0) vcvs gain=1.950903220161e-01
SMIXQ_c012_1_00 (mix_q_src_c012_1_00 mix_q_c012_1 win_1_00 0) relay vt1=-1m vt2=1m ropen=ropen_mix rclosed=rclosed_mix
EMIXI_c012_1_01 (mix_i_src_c012_1_01 0 bpf_c012_1 0) vcvs gain=8.314696123025e-01
SMIXI_c012_1_01 (mix_i_src_c012_1_01 mix_i_c012_1 win_1_01 0) relay vt1=-1m vt2=1m ropen=ropen_mix rclosed=rclosed_mix
EMIXQ_c012_1_01 (mix_q_src_c012_1_01 0 bpf_c012_1 0) vcvs gain=5.555702330196e-01
SMIXQ_c012_1_01 (mix_q_src_c012_1_01 mix_q_c012_1 win_1_01 0) relay vt1=-1m vt2=1m ropen=ropen_mix rclosed=rclosed_mix
EMIXI_c012_1_02 (mix_i_src_c012_1_02 0 bpf_c012_1 0) vcvs gain=5.555702330196e-01
SMIXI_c012_1_02 (mix_i_src_c012_1_02 mix_i_c012_1 win_1_02 0) relay vt1=-1m vt2=1m ropen=ropen_mix rclosed=rclosed_mix
EMIXQ_c012_1_02 (mix_q_src_c012_1_02 0 bpf_c012_1 0) vcvs gain=8.314696123025e-01
SMIXQ_c012_1_02 (mix_q_src_c012_1_02 mix_q_c012_1 win_1_02 0) relay vt1=-1m vt2=1m ropen=ropen_mix rclosed=rclosed_mix
EMIXI_c012_1_03 (mix_i_src_c012_1_03 0 bpf_c012_1 0) vcvs gain=1.950903220161e-01
SMIXI_c012_1_03 (mix_i_src_c012_1_03 mix_i_c012_1 win_1_03 0) relay vt1=-1m vt2=1m ropen=ropen_mix rclosed=rclosed_mix
EMIXQ_c012_1_03 (mix_q_src_c012_1_03 0 bpf_c012_1 0) vcvs gain=9.807852804032e-01
SMIXQ_c012_1_03 (mix_q_src_c012_1_03 mix_q_c012_1 win_1_03 0) relay vt1=-1m vt2=1m ropen=ropen_mix rclosed=rclosed_mix
EMIXI_c012_1_04 (mix_i_src_c012_1_04 0 bpf_c012_1 0) vcvs gain=-1.950903220161e-01
SMIXI_c012_1_04 (mix_i_src_c012_1_04 mix_i_c012_1 win_1_04 0) relay vt1=-1m vt2=1m ropen=ropen_mix rclosed=rclosed_mix
EMIXQ_c012_1_04 (mix_q_src_c012_1_04 0 bpf_c012_1 0) vcvs gain=9.807852804032e-01
SMIXQ_c012_1_04 (mix_q_src_c012_1_04 mix_q_c012_1 win_1_04 0) relay vt1=-1m vt2=1m ropen=ropen_mix rclosed=rclosed_mix
EMIXI_c012_1_05 (mix_i_src_c012_1_05 0 bpf_c012_1 0) vcvs gain=-5.555702330196e-01
SMIXI_c012_1_05 (mix_i_src_c012_1_05 mix_i_c012_1 win_1_05 0) relay vt1=-1m vt2=1m ropen=ropen_mix rclosed=rclosed_mix
EMIXQ_c012_1_05 (mix_q_src_c012_1_05 0 bpf_c012_1 0) vcvs gain=8.314696123025e-01
SMIXQ_c012_1_05 (mix_q_src_c012_1_05 mix_q_c012_1 win_1_05 0) relay vt1=-1m vt2=1m ropen=ropen_mix rclosed=rclosed_mix
EMIXI_c012_1_06 (mix_i_src_c012_1_06 0 bpf_c012_1 0) vcvs gain=-8.314696123025e-01
SMIXI_c012_1_06 (mix_i_src_c012_1_06 mix_i_c012_1 win_1_06 0) relay vt1=-1m vt2=1m ropen=ropen_mix rclosed=rclosed_mix
EMIXQ_c012_1_06 (mix_q_src_c012_1_06 0 bpf_c012_1 0) vcvs gain=5.555702330196e-01
SMIXQ_c012_1_06 (mix_q_src_c012_1_06 mix_q_c012_1 win_1_06 0) relay vt1=-1m vt2=1m ropen=ropen_mix rclosed=rclosed_mix
EMIXI_c012_1_07 (mix_i_src_c012_1_07 0 bpf_c012_1 0) vcvs gain=-9.807852804032e-01
SMIXI_c012_1_07 (mix_i_src_c012_1_07 mix_i_c012_1 win_1_07 0) relay vt1=-1m vt2=1m ropen=ropen_mix rclosed=rclosed_mix
EMIXQ_c012_1_07 (mix_q_src_c012_1_07 0 bpf_c012_1 0) vcvs gain=1.950903220161e-01
SMIXQ_c012_1_07 (mix_q_src_c012_1_07 mix_q_c012_1 win_1_07 0) relay vt1=-1m vt2=1m ropen=ropen_mix rclosed=rclosed_mix
EMIXI_c012_1_08 (mix_i_src_c012_1_08 0 bpf_c012_1 0) vcvs gain=-9.807852804032e-01
SMIXI_c012_1_08 (mix_i_src_c012_1_08 mix_i_c012_1 win_1_08 0) relay vt1=-1m vt2=1m ropen=ropen_mix rclosed=rclosed_mix
EMIXQ_c012_1_08 (mix_q_src_c012_1_08 0 bpf_c012_1 0) vcvs gain=-1.950903220161e-01
SMIXQ_c012_1_08 (mix_q_src_c012_1_08 mix_q_c012_1 win_1_08 0) relay vt1=-1m vt2=1m ropen=ropen_mix rclosed=rclosed_mix
EMIXI_c012_1_09 (mix_i_src_c012_1_09 0 bpf_c012_1 0) vcvs gain=-8.314696123025e-01
SMIXI_c012_1_09 (mix_i_src_c012_1_09 mix_i_c012_1 win_1_09 0) relay vt1=-1m vt2=1m ropen=ropen_mix rclosed=rclosed_mix
EMIXQ_c012_1_09 (mix_q_src_c012_1_09 0 bpf_c012_1 0) vcvs gain=-5.555702330196e-01
SMIXQ_c012_1_09 (mix_q_src_c012_1_09 mix_q_c012_1 win_1_09 0) relay vt1=-1m vt2=1m ropen=ropen_mix rclosed=rclosed_mix
EMIXI_c012_1_10 (mix_i_src_c012_1_10 0 bpf_c012_1 0) vcvs gain=-5.555702330196e-01
SMIXI_c012_1_10 (mix_i_src_c012_1_10 mix_i_c012_1 win_1_10 0) relay vt1=-1m vt2=1m ropen=ropen_mix rclosed=rclosed_mix
EMIXQ_c012_1_10 (mix_q_src_c012_1_10 0 bpf_c012_1 0) vcvs gain=-8.314696123025e-01
SMIXQ_c012_1_10 (mix_q_src_c012_1_10 mix_q_c012_1 win_1_10 0) relay vt1=-1m vt2=1m ropen=ropen_mix rclosed=rclosed_mix
EMIXI_c012_1_11 (mix_i_src_c012_1_11 0 bpf_c012_1 0) vcvs gain=-1.950903220161e-01
SMIXI_c012_1_11 (mix_i_src_c012_1_11 mix_i_c012_1 win_1_11 0) relay vt1=-1m vt2=1m ropen=ropen_mix rclosed=rclosed_mix
EMIXQ_c012_1_11 (mix_q_src_c012_1_11 0 bpf_c012_1 0) vcvs gain=-9.807852804032e-01
SMIXQ_c012_1_11 (mix_q_src_c012_1_11 mix_q_c012_1 win_1_11 0) relay vt1=-1m vt2=1m ropen=ropen_mix rclosed=rclosed_mix
EMIXI_c012_1_12 (mix_i_src_c012_1_12 0 bpf_c012_1 0) vcvs gain=1.950903220161e-01
SMIXI_c012_1_12 (mix_i_src_c012_1_12 mix_i_c012_1 win_1_12 0) relay vt1=-1m vt2=1m ropen=ropen_mix rclosed=rclosed_mix
EMIXQ_c012_1_12 (mix_q_src_c012_1_12 0 bpf_c012_1 0) vcvs gain=-9.807852804032e-01
SMIXQ_c012_1_12 (mix_q_src_c012_1_12 mix_q_c012_1 win_1_12 0) relay vt1=-1m vt2=1m ropen=ropen_mix rclosed=rclosed_mix
EMIXI_c012_1_13 (mix_i_src_c012_1_13 0 bpf_c012_1 0) vcvs gain=5.555702330196e-01
SMIXI_c012_1_13 (mix_i_src_c012_1_13 mix_i_c012_1 win_1_13 0) relay vt1=-1m vt2=1m ropen=ropen_mix rclosed=rclosed_mix
EMIXQ_c012_1_13 (mix_q_src_c012_1_13 0 bpf_c012_1 0) vcvs gain=-8.314696123025e-01
SMIXQ_c012_1_13 (mix_q_src_c012_1_13 mix_q_c012_1 win_1_13 0) relay vt1=-1m vt2=1m ropen=ropen_mix rclosed=rclosed_mix
EMIXI_c012_1_14 (mix_i_src_c012_1_14 0 bpf_c012_1 0) vcvs gain=8.314696123025e-01
SMIXI_c012_1_14 (mix_i_src_c012_1_14 mix_i_c012_1 win_1_14 0) relay vt1=-1m vt2=1m ropen=ropen_mix rclosed=rclosed_mix
EMIXQ_c012_1_14 (mix_q_src_c012_1_14 0 bpf_c012_1 0) vcvs gain=-5.555702330196e-01
SMIXQ_c012_1_14 (mix_q_src_c012_1_14 mix_q_c012_1 win_1_14 0) relay vt1=-1m vt2=1m ropen=ropen_mix rclosed=rclosed_mix
EMIXI_c012_1_15 (mix_i_src_c012_1_15 0 bpf_c012_1 0) vcvs gain=9.807852804032e-01
SMIXI_c012_1_15 (mix_i_src_c012_1_15 mix_i_c012_1 win_1_15 0) relay vt1=-1m vt2=1m ropen=ropen_mix rclosed=rclosed_mix
EMIXQ_c012_1_15 (mix_q_src_c012_1_15 0 bpf_c012_1 0) vcvs gain=-1.950903220161e-01
SMIXQ_c012_1_15 (mix_q_src_c012_1_15 mix_q_c012_1 win_1_15 0) relay vt1=-1m vt2=1m ropen=ropen_mix rclosed=rclosed_mix
RMIXI_c012_1 (mix_i_c012_1 0) resistor r=1G
RMIXQ_c012_1 (mix_q_c012_1 0) resistor r=1G
RINTI_c012_1 (mix_i_c012_1 Icar_c012_1) resistor r=1k
CINTI_c012_1 (Icar_c012_1 0) capacitor c=80p
RINTQ_c012_1 (mix_q_c012_1 Qcar_c012_1) resistor r=1k
CINTQ_c012_1 (Qcar_c012_1 0) capacitor c=80p
save bpf_c012_1 Icar_c012_1 Qcar_c012_1

// bl012, carrier_2: 750000000 Hz coherent I/Q phase-window verification-demod path
CBPF_c012_2 (bl012 n_cbpf_c012_2) capacitor c=4.503163717437e-14
LBPF_c012_2 (n_cbpf_c012_2 bpf_c012_2) inductor l=1.000000000000e-06
RBPF_c012_2 (bpf_c012_2 0) resistor r=2.356194490192e+02
EMIXI_c012_2_00 (mix_i_src_c012_2_00 0 bpf_c012_2 0) vcvs gain=9.807852804032e-01
SMIXI_c012_2_00 (mix_i_src_c012_2_00 mix_i_c012_2 win_2_00 0) relay vt1=-1m vt2=1m ropen=ropen_mix rclosed=rclosed_mix
EMIXQ_c012_2_00 (mix_q_src_c012_2_00 0 bpf_c012_2 0) vcvs gain=1.950903220161e-01
SMIXQ_c012_2_00 (mix_q_src_c012_2_00 mix_q_c012_2 win_2_00 0) relay vt1=-1m vt2=1m ropen=ropen_mix rclosed=rclosed_mix
EMIXI_c012_2_01 (mix_i_src_c012_2_01 0 bpf_c012_2 0) vcvs gain=8.314696123025e-01
SMIXI_c012_2_01 (mix_i_src_c012_2_01 mix_i_c012_2 win_2_01 0) relay vt1=-1m vt2=1m ropen=ropen_mix rclosed=rclosed_mix
EMIXQ_c012_2_01 (mix_q_src_c012_2_01 0 bpf_c012_2 0) vcvs gain=5.555702330196e-01
SMIXQ_c012_2_01 (mix_q_src_c012_2_01 mix_q_c012_2 win_2_01 0) relay vt1=-1m vt2=1m ropen=ropen_mix rclosed=rclosed_mix
EMIXI_c012_2_02 (mix_i_src_c012_2_02 0 bpf_c012_2 0) vcvs gain=5.555702330196e-01
SMIXI_c012_2_02 (mix_i_src_c012_2_02 mix_i_c012_2 win_2_02 0) relay vt1=-1m vt2=1m ropen=ropen_mix rclosed=rclosed_mix
EMIXQ_c012_2_02 (mix_q_src_c012_2_02 0 bpf_c012_2 0) vcvs gain=8.314696123025e-01
SMIXQ_c012_2_02 (mix_q_src_c012_2_02 mix_q_c012_2 win_2_02 0) relay vt1=-1m vt2=1m ropen=ropen_mix rclosed=rclosed_mix
EMIXI_c012_2_03 (mix_i_src_c012_2_03 0 bpf_c012_2 0) vcvs gain=1.950903220161e-01
SMIXI_c012_2_03 (mix_i_src_c012_2_03 mix_i_c012_2 win_2_03 0) relay vt1=-1m vt2=1m ropen=ropen_mix rclosed=rclosed_mix
EMIXQ_c012_2_03 (mix_q_src_c012_2_03 0 bpf_c012_2 0) vcvs gain=9.807852804032e-01
SMIXQ_c012_2_03 (mix_q_src_c012_2_03 mix_q_c012_2 win_2_03 0) relay vt1=-1m vt2=1m ropen=ropen_mix rclosed=rclosed_mix
EMIXI_c012_2_04 (mix_i_src_c012_2_04 0 bpf_c012_2 0) vcvs gain=-1.950903220161e-01
SMIXI_c012_2_04 (mix_i_src_c012_2_04 mix_i_c012_2 win_2_04 0) relay vt1=-1m vt2=1m ropen=ropen_mix rclosed=rclosed_mix
EMIXQ_c012_2_04 (mix_q_src_c012_2_04 0 bpf_c012_2 0) vcvs gain=9.807852804032e-01
SMIXQ_c012_2_04 (mix_q_src_c012_2_04 mix_q_c012_2 win_2_04 0) relay vt1=-1m vt2=1m ropen=ropen_mix rclosed=rclosed_mix
EMIXI_c012_2_05 (mix_i_src_c012_2_05 0 bpf_c012_2 0) vcvs gain=-5.555702330196e-01
SMIXI_c012_2_05 (mix_i_src_c012_2_05 mix_i_c012_2 win_2_05 0) relay vt1=-1m vt2=1m ropen=ropen_mix rclosed=rclosed_mix
EMIXQ_c012_2_05 (mix_q_src_c012_2_05 0 bpf_c012_2 0) vcvs gain=8.314696123025e-01
SMIXQ_c012_2_05 (mix_q_src_c012_2_05 mix_q_c012_2 win_2_05 0) relay vt1=-1m vt2=1m ropen=ropen_mix rclosed=rclosed_mix
EMIXI_c012_2_06 (mix_i_src_c012_2_06 0 bpf_c012_2 0) vcvs gain=-8.314696123025e-01
SMIXI_c012_2_06 (mix_i_src_c012_2_06 mix_i_c012_2 win_2_06 0) relay vt1=-1m vt2=1m ropen=ropen_mix rclosed=rclosed_mix
EMIXQ_c012_2_06 (mix_q_src_c012_2_06 0 bpf_c012_2 0) vcvs gain=5.555702330196e-01
SMIXQ_c012_2_06 (mix_q_src_c012_2_06 mix_q_c012_2 win_2_06 0) relay vt1=-1m vt2=1m ropen=ropen_mix rclosed=rclosed_mix
EMIXI_c012_2_07 (mix_i_src_c012_2_07 0 bpf_c012_2 0) vcvs gain=-9.807852804032e-01
SMIXI_c012_2_07 (mix_i_src_c012_2_07 mix_i_c012_2 win_2_07 0) relay vt1=-1m vt2=1m ropen=ropen_mix rclosed=rclosed_mix
EMIXQ_c012_2_07 (mix_q_src_c012_2_07 0 bpf_c012_2 0) vcvs gain=1.950903220161e-01
SMIXQ_c012_2_07 (mix_q_src_c012_2_07 mix_q_c012_2 win_2_07 0) relay vt1=-1m vt2=1m ropen=ropen_mix rclosed=rclosed_mix
EMIXI_c012_2_08 (mix_i_src_c012_2_08 0 bpf_c012_2 0) vcvs gain=-9.807852804032e-01
SMIXI_c012_2_08 (mix_i_src_c012_2_08 mix_i_c012_2 win_2_08 0) relay vt1=-1m vt2=1m ropen=ropen_mix rclosed=rclosed_mix
EMIXQ_c012_2_08 (mix_q_src_c012_2_08 0 bpf_c012_2 0) vcvs gain=-1.950903220161e-01
SMIXQ_c012_2_08 (mix_q_src_c012_2_08 mix_q_c012_2 win_2_08 0) relay vt1=-1m vt2=1m ropen=ropen_mix rclosed=rclosed_mix
EMIXI_c012_2_09 (mix_i_src_c012_2_09 0 bpf_c012_2 0) vcvs gain=-8.314696123025e-01
SMIXI_c012_2_09 (mix_i_src_c012_2_09 mix_i_c012_2 win_2_09 0) relay vt1=-1m vt2=1m ropen=ropen_mix rclosed=rclosed_mix
EMIXQ_c012_2_09 (mix_q_src_c012_2_09 0 bpf_c012_2 0) vcvs gain=-5.555702330196e-01
SMIXQ_c012_2_09 (mix_q_src_c012_2_09 mix_q_c012_2 win_2_09 0) relay vt1=-1m vt2=1m ropen=ropen_mix rclosed=rclosed_mix
EMIXI_c012_2_10 (mix_i_src_c012_2_10 0 bpf_c012_2 0) vcvs gain=-5.555702330196e-01
SMIXI_c012_2_10 (mix_i_src_c012_2_10 mix_i_c012_2 win_2_10 0) relay vt1=-1m vt2=1m ropen=ropen_mix rclosed=rclosed_mix
EMIXQ_c012_2_10 (mix_q_src_c012_2_10 0 bpf_c012_2 0) vcvs gain=-8.314696123025e-01
SMIXQ_c012_2_10 (mix_q_src_c012_2_10 mix_q_c012_2 win_2_10 0) relay vt1=-1m vt2=1m ropen=ropen_mix rclosed=rclosed_mix
EMIXI_c012_2_11 (mix_i_src_c012_2_11 0 bpf_c012_2 0) vcvs gain=-1.950903220161e-01
SMIXI_c012_2_11 (mix_i_src_c012_2_11 mix_i_c012_2 win_2_11 0) relay vt1=-1m vt2=1m ropen=ropen_mix rclosed=rclosed_mix
EMIXQ_c012_2_11 (mix_q_src_c012_2_11 0 bpf_c012_2 0) vcvs gain=-9.807852804032e-01
SMIXQ_c012_2_11 (mix_q_src_c012_2_11 mix_q_c012_2 win_2_11 0) relay vt1=-1m vt2=1m ropen=ropen_mix rclosed=rclosed_mix
EMIXI_c012_2_12 (mix_i_src_c012_2_12 0 bpf_c012_2 0) vcvs gain=1.950903220161e-01
SMIXI_c012_2_12 (mix_i_src_c012_2_12 mix_i_c012_2 win_2_12 0) relay vt1=-1m vt2=1m ropen=ropen_mix rclosed=rclosed_mix
EMIXQ_c012_2_12 (mix_q_src_c012_2_12 0 bpf_c012_2 0) vcvs gain=-9.807852804032e-01
SMIXQ_c012_2_12 (mix_q_src_c012_2_12 mix_q_c012_2 win_2_12 0) relay vt1=-1m vt2=1m ropen=ropen_mix rclosed=rclosed_mix
EMIXI_c012_2_13 (mix_i_src_c012_2_13 0 bpf_c012_2 0) vcvs gain=5.555702330196e-01
SMIXI_c012_2_13 (mix_i_src_c012_2_13 mix_i_c012_2 win_2_13 0) relay vt1=-1m vt2=1m ropen=ropen_mix rclosed=rclosed_mix
EMIXQ_c012_2_13 (mix_q_src_c012_2_13 0 bpf_c012_2 0) vcvs gain=-8.314696123025e-01
SMIXQ_c012_2_13 (mix_q_src_c012_2_13 mix_q_c012_2 win_2_13 0) relay vt1=-1m vt2=1m ropen=ropen_mix rclosed=rclosed_mix
EMIXI_c012_2_14 (mix_i_src_c012_2_14 0 bpf_c012_2 0) vcvs gain=8.314696123025e-01
SMIXI_c012_2_14 (mix_i_src_c012_2_14 mix_i_c012_2 win_2_14 0) relay vt1=-1m vt2=1m ropen=ropen_mix rclosed=rclosed_mix
EMIXQ_c012_2_14 (mix_q_src_c012_2_14 0 bpf_c012_2 0) vcvs gain=-5.555702330196e-01
SMIXQ_c012_2_14 (mix_q_src_c012_2_14 mix_q_c012_2 win_2_14 0) relay vt1=-1m vt2=1m ropen=ropen_mix rclosed=rclosed_mix
EMIXI_c012_2_15 (mix_i_src_c012_2_15 0 bpf_c012_2 0) vcvs gain=9.807852804032e-01
SMIXI_c012_2_15 (mix_i_src_c012_2_15 mix_i_c012_2 win_2_15 0) relay vt1=-1m vt2=1m ropen=ropen_mix rclosed=rclosed_mix
EMIXQ_c012_2_15 (mix_q_src_c012_2_15 0 bpf_c012_2 0) vcvs gain=-1.950903220161e-01
SMIXQ_c012_2_15 (mix_q_src_c012_2_15 mix_q_c012_2 win_2_15 0) relay vt1=-1m vt2=1m ropen=ropen_mix rclosed=rclosed_mix
RMIXI_c012_2 (mix_i_c012_2 0) resistor r=1G
RMIXQ_c012_2 (mix_q_c012_2 0) resistor r=1G
RINTI_c012_2 (mix_i_c012_2 Icar_c012_2) resistor r=1k
CINTI_c012_2 (Icar_c012_2 0) capacitor c=80p
RINTQ_c012_2 (mix_q_c012_2 Qcar_c012_2) resistor r=1k
CINTQ_c012_2 (Qcar_c012_2 0) capacitor c=80p
save bpf_c012_2 Icar_c012_2 Qcar_c012_2

// bl012, carrier_3: 1000000000 Hz coherent I/Q phase-window verification-demod path
CBPF_c012_3 (bl012 n_cbpf_c012_3) capacitor c=2.533029591058e-14
LBPF_c012_3 (n_cbpf_c012_3 bpf_c012_3) inductor l=1.000000000000e-06
RBPF_c012_3 (bpf_c012_3 0) resistor r=3.141592653590e+02
EMIXI_c012_3_00 (mix_i_src_c012_3_00 0 bpf_c012_3 0) vcvs gain=9.807852804032e-01
SMIXI_c012_3_00 (mix_i_src_c012_3_00 mix_i_c012_3 win_3_00 0) relay vt1=-1m vt2=1m ropen=ropen_mix rclosed=rclosed_mix
EMIXQ_c012_3_00 (mix_q_src_c012_3_00 0 bpf_c012_3 0) vcvs gain=1.950903220161e-01
SMIXQ_c012_3_00 (mix_q_src_c012_3_00 mix_q_c012_3 win_3_00 0) relay vt1=-1m vt2=1m ropen=ropen_mix rclosed=rclosed_mix
EMIXI_c012_3_01 (mix_i_src_c012_3_01 0 bpf_c012_3 0) vcvs gain=8.314696123025e-01
SMIXI_c012_3_01 (mix_i_src_c012_3_01 mix_i_c012_3 win_3_01 0) relay vt1=-1m vt2=1m ropen=ropen_mix rclosed=rclosed_mix
EMIXQ_c012_3_01 (mix_q_src_c012_3_01 0 bpf_c012_3 0) vcvs gain=5.555702330196e-01
SMIXQ_c012_3_01 (mix_q_src_c012_3_01 mix_q_c012_3 win_3_01 0) relay vt1=-1m vt2=1m ropen=ropen_mix rclosed=rclosed_mix
EMIXI_c012_3_02 (mix_i_src_c012_3_02 0 bpf_c012_3 0) vcvs gain=5.555702330196e-01
SMIXI_c012_3_02 (mix_i_src_c012_3_02 mix_i_c012_3 win_3_02 0) relay vt1=-1m vt2=1m ropen=ropen_mix rclosed=rclosed_mix
EMIXQ_c012_3_02 (mix_q_src_c012_3_02 0 bpf_c012_3 0) vcvs gain=8.314696123025e-01
SMIXQ_c012_3_02 (mix_q_src_c012_3_02 mix_q_c012_3 win_3_02 0) relay vt1=-1m vt2=1m ropen=ropen_mix rclosed=rclosed_mix
EMIXI_c012_3_03 (mix_i_src_c012_3_03 0 bpf_c012_3 0) vcvs gain=1.950903220161e-01
SMIXI_c012_3_03 (mix_i_src_c012_3_03 mix_i_c012_3 win_3_03 0) relay vt1=-1m vt2=1m ropen=ropen_mix rclosed=rclosed_mix
EMIXQ_c012_3_03 (mix_q_src_c012_3_03 0 bpf_c012_3 0) vcvs gain=9.807852804032e-01
SMIXQ_c012_3_03 (mix_q_src_c012_3_03 mix_q_c012_3 win_3_03 0) relay vt1=-1m vt2=1m ropen=ropen_mix rclosed=rclosed_mix
EMIXI_c012_3_04 (mix_i_src_c012_3_04 0 bpf_c012_3 0) vcvs gain=-1.950903220161e-01
SMIXI_c012_3_04 (mix_i_src_c012_3_04 mix_i_c012_3 win_3_04 0) relay vt1=-1m vt2=1m ropen=ropen_mix rclosed=rclosed_mix
EMIXQ_c012_3_04 (mix_q_src_c012_3_04 0 bpf_c012_3 0) vcvs gain=9.807852804032e-01
SMIXQ_c012_3_04 (mix_q_src_c012_3_04 mix_q_c012_3 win_3_04 0) relay vt1=-1m vt2=1m ropen=ropen_mix rclosed=rclosed_mix
EMIXI_c012_3_05 (mix_i_src_c012_3_05 0 bpf_c012_3 0) vcvs gain=-5.555702330196e-01
SMIXI_c012_3_05 (mix_i_src_c012_3_05 mix_i_c012_3 win_3_05 0) relay vt1=-1m vt2=1m ropen=ropen_mix rclosed=rclosed_mix
EMIXQ_c012_3_05 (mix_q_src_c012_3_05 0 bpf_c012_3 0) vcvs gain=8.314696123025e-01
SMIXQ_c012_3_05 (mix_q_src_c012_3_05 mix_q_c012_3 win_3_05 0) relay vt1=-1m vt2=1m ropen=ropen_mix rclosed=rclosed_mix
EMIXI_c012_3_06 (mix_i_src_c012_3_06 0 bpf_c012_3 0) vcvs gain=-8.314696123025e-01
SMIXI_c012_3_06 (mix_i_src_c012_3_06 mix_i_c012_3 win_3_06 0) relay vt1=-1m vt2=1m ropen=ropen_mix rclosed=rclosed_mix
EMIXQ_c012_3_06 (mix_q_src_c012_3_06 0 bpf_c012_3 0) vcvs gain=5.555702330196e-01
SMIXQ_c012_3_06 (mix_q_src_c012_3_06 mix_q_c012_3 win_3_06 0) relay vt1=-1m vt2=1m ropen=ropen_mix rclosed=rclosed_mix
EMIXI_c012_3_07 (mix_i_src_c012_3_07 0 bpf_c012_3 0) vcvs gain=-9.807852804032e-01
SMIXI_c012_3_07 (mix_i_src_c012_3_07 mix_i_c012_3 win_3_07 0) relay vt1=-1m vt2=1m ropen=ropen_mix rclosed=rclosed_mix
EMIXQ_c012_3_07 (mix_q_src_c012_3_07 0 bpf_c012_3 0) vcvs gain=1.950903220161e-01
SMIXQ_c012_3_07 (mix_q_src_c012_3_07 mix_q_c012_3 win_3_07 0) relay vt1=-1m vt2=1m ropen=ropen_mix rclosed=rclosed_mix
EMIXI_c012_3_08 (mix_i_src_c012_3_08 0 bpf_c012_3 0) vcvs gain=-9.807852804032e-01
SMIXI_c012_3_08 (mix_i_src_c012_3_08 mix_i_c012_3 win_3_08 0) relay vt1=-1m vt2=1m ropen=ropen_mix rclosed=rclosed_mix
EMIXQ_c012_3_08 (mix_q_src_c012_3_08 0 bpf_c012_3 0) vcvs gain=-1.950903220161e-01
SMIXQ_c012_3_08 (mix_q_src_c012_3_08 mix_q_c012_3 win_3_08 0) relay vt1=-1m vt2=1m ropen=ropen_mix rclosed=rclosed_mix
EMIXI_c012_3_09 (mix_i_src_c012_3_09 0 bpf_c012_3 0) vcvs gain=-8.314696123025e-01
SMIXI_c012_3_09 (mix_i_src_c012_3_09 mix_i_c012_3 win_3_09 0) relay vt1=-1m vt2=1m ropen=ropen_mix rclosed=rclosed_mix
EMIXQ_c012_3_09 (mix_q_src_c012_3_09 0 bpf_c012_3 0) vcvs gain=-5.555702330196e-01
SMIXQ_c012_3_09 (mix_q_src_c012_3_09 mix_q_c012_3 win_3_09 0) relay vt1=-1m vt2=1m ropen=ropen_mix rclosed=rclosed_mix
EMIXI_c012_3_10 (mix_i_src_c012_3_10 0 bpf_c012_3 0) vcvs gain=-5.555702330196e-01
SMIXI_c012_3_10 (mix_i_src_c012_3_10 mix_i_c012_3 win_3_10 0) relay vt1=-1m vt2=1m ropen=ropen_mix rclosed=rclosed_mix
EMIXQ_c012_3_10 (mix_q_src_c012_3_10 0 bpf_c012_3 0) vcvs gain=-8.314696123025e-01
SMIXQ_c012_3_10 (mix_q_src_c012_3_10 mix_q_c012_3 win_3_10 0) relay vt1=-1m vt2=1m ropen=ropen_mix rclosed=rclosed_mix
EMIXI_c012_3_11 (mix_i_src_c012_3_11 0 bpf_c012_3 0) vcvs gain=-1.950903220161e-01
SMIXI_c012_3_11 (mix_i_src_c012_3_11 mix_i_c012_3 win_3_11 0) relay vt1=-1m vt2=1m ropen=ropen_mix rclosed=rclosed_mix
EMIXQ_c012_3_11 (mix_q_src_c012_3_11 0 bpf_c012_3 0) vcvs gain=-9.807852804032e-01
SMIXQ_c012_3_11 (mix_q_src_c012_3_11 mix_q_c012_3 win_3_11 0) relay vt1=-1m vt2=1m ropen=ropen_mix rclosed=rclosed_mix
EMIXI_c012_3_12 (mix_i_src_c012_3_12 0 bpf_c012_3 0) vcvs gain=1.950903220161e-01
SMIXI_c012_3_12 (mix_i_src_c012_3_12 mix_i_c012_3 win_3_12 0) relay vt1=-1m vt2=1m ropen=ropen_mix rclosed=rclosed_mix
EMIXQ_c012_3_12 (mix_q_src_c012_3_12 0 bpf_c012_3 0) vcvs gain=-9.807852804032e-01
SMIXQ_c012_3_12 (mix_q_src_c012_3_12 mix_q_c012_3 win_3_12 0) relay vt1=-1m vt2=1m ropen=ropen_mix rclosed=rclosed_mix
EMIXI_c012_3_13 (mix_i_src_c012_3_13 0 bpf_c012_3 0) vcvs gain=5.555702330196e-01
SMIXI_c012_3_13 (mix_i_src_c012_3_13 mix_i_c012_3 win_3_13 0) relay vt1=-1m vt2=1m ropen=ropen_mix rclosed=rclosed_mix
EMIXQ_c012_3_13 (mix_q_src_c012_3_13 0 bpf_c012_3 0) vcvs gain=-8.314696123025e-01
SMIXQ_c012_3_13 (mix_q_src_c012_3_13 mix_q_c012_3 win_3_13 0) relay vt1=-1m vt2=1m ropen=ropen_mix rclosed=rclosed_mix
EMIXI_c012_3_14 (mix_i_src_c012_3_14 0 bpf_c012_3 0) vcvs gain=8.314696123025e-01
SMIXI_c012_3_14 (mix_i_src_c012_3_14 mix_i_c012_3 win_3_14 0) relay vt1=-1m vt2=1m ropen=ropen_mix rclosed=rclosed_mix
EMIXQ_c012_3_14 (mix_q_src_c012_3_14 0 bpf_c012_3 0) vcvs gain=-5.555702330196e-01
SMIXQ_c012_3_14 (mix_q_src_c012_3_14 mix_q_c012_3 win_3_14 0) relay vt1=-1m vt2=1m ropen=ropen_mix rclosed=rclosed_mix
EMIXI_c012_3_15 (mix_i_src_c012_3_15 0 bpf_c012_3 0) vcvs gain=9.807852804032e-01
SMIXI_c012_3_15 (mix_i_src_c012_3_15 mix_i_c012_3 win_3_15 0) relay vt1=-1m vt2=1m ropen=ropen_mix rclosed=rclosed_mix
EMIXQ_c012_3_15 (mix_q_src_c012_3_15 0 bpf_c012_3 0) vcvs gain=-1.950903220161e-01
SMIXQ_c012_3_15 (mix_q_src_c012_3_15 mix_q_c012_3 win_3_15 0) relay vt1=-1m vt2=1m ropen=ropen_mix rclosed=rclosed_mix
RMIXI_c012_3 (mix_i_c012_3 0) resistor r=1G
RMIXQ_c012_3 (mix_q_c012_3 0) resistor r=1G
RINTI_c012_3 (mix_i_c012_3 Icar_c012_3) resistor r=1k
CINTI_c012_3 (Icar_c012_3 0) capacitor c=80p
RINTQ_c012_3 (mix_q_c012_3 Qcar_c012_3) resistor r=1k
CINTQ_c012_3 (Qcar_c012_3 0) capacitor c=80p
save bpf_c012_3 Icar_c012_3 Qcar_c012_3

// bl013, carrier_0: 250000000 Hz coherent I/Q phase-window verification-demod path
CBPF_c013_0 (bl013 n_cbpf_c013_0) capacitor c=4.052847345694e-13
LBPF_c013_0 (n_cbpf_c013_0 bpf_c013_0) inductor l=1.000000000000e-06
RBPF_c013_0 (bpf_c013_0 0) resistor r=7.853981633974e+01
EMIXI_c013_0_00 (mix_i_src_c013_0_00 0 bpf_c013_0 0) vcvs gain=9.807852804032e-01
SMIXI_c013_0_00 (mix_i_src_c013_0_00 mix_i_c013_0 win_0_00 0) relay vt1=-1m vt2=1m ropen=ropen_mix rclosed=rclosed_mix
EMIXQ_c013_0_00 (mix_q_src_c013_0_00 0 bpf_c013_0 0) vcvs gain=1.950903220161e-01
SMIXQ_c013_0_00 (mix_q_src_c013_0_00 mix_q_c013_0 win_0_00 0) relay vt1=-1m vt2=1m ropen=ropen_mix rclosed=rclosed_mix
EMIXI_c013_0_01 (mix_i_src_c013_0_01 0 bpf_c013_0 0) vcvs gain=8.314696123025e-01
SMIXI_c013_0_01 (mix_i_src_c013_0_01 mix_i_c013_0 win_0_01 0) relay vt1=-1m vt2=1m ropen=ropen_mix rclosed=rclosed_mix
EMIXQ_c013_0_01 (mix_q_src_c013_0_01 0 bpf_c013_0 0) vcvs gain=5.555702330196e-01
SMIXQ_c013_0_01 (mix_q_src_c013_0_01 mix_q_c013_0 win_0_01 0) relay vt1=-1m vt2=1m ropen=ropen_mix rclosed=rclosed_mix
EMIXI_c013_0_02 (mix_i_src_c013_0_02 0 bpf_c013_0 0) vcvs gain=5.555702330196e-01
SMIXI_c013_0_02 (mix_i_src_c013_0_02 mix_i_c013_0 win_0_02 0) relay vt1=-1m vt2=1m ropen=ropen_mix rclosed=rclosed_mix
EMIXQ_c013_0_02 (mix_q_src_c013_0_02 0 bpf_c013_0 0) vcvs gain=8.314696123025e-01
SMIXQ_c013_0_02 (mix_q_src_c013_0_02 mix_q_c013_0 win_0_02 0) relay vt1=-1m vt2=1m ropen=ropen_mix rclosed=rclosed_mix
EMIXI_c013_0_03 (mix_i_src_c013_0_03 0 bpf_c013_0 0) vcvs gain=1.950903220161e-01
SMIXI_c013_0_03 (mix_i_src_c013_0_03 mix_i_c013_0 win_0_03 0) relay vt1=-1m vt2=1m ropen=ropen_mix rclosed=rclosed_mix
EMIXQ_c013_0_03 (mix_q_src_c013_0_03 0 bpf_c013_0 0) vcvs gain=9.807852804032e-01
SMIXQ_c013_0_03 (mix_q_src_c013_0_03 mix_q_c013_0 win_0_03 0) relay vt1=-1m vt2=1m ropen=ropen_mix rclosed=rclosed_mix
EMIXI_c013_0_04 (mix_i_src_c013_0_04 0 bpf_c013_0 0) vcvs gain=-1.950903220161e-01
SMIXI_c013_0_04 (mix_i_src_c013_0_04 mix_i_c013_0 win_0_04 0) relay vt1=-1m vt2=1m ropen=ropen_mix rclosed=rclosed_mix
EMIXQ_c013_0_04 (mix_q_src_c013_0_04 0 bpf_c013_0 0) vcvs gain=9.807852804032e-01
SMIXQ_c013_0_04 (mix_q_src_c013_0_04 mix_q_c013_0 win_0_04 0) relay vt1=-1m vt2=1m ropen=ropen_mix rclosed=rclosed_mix
EMIXI_c013_0_05 (mix_i_src_c013_0_05 0 bpf_c013_0 0) vcvs gain=-5.555702330196e-01
SMIXI_c013_0_05 (mix_i_src_c013_0_05 mix_i_c013_0 win_0_05 0) relay vt1=-1m vt2=1m ropen=ropen_mix rclosed=rclosed_mix
EMIXQ_c013_0_05 (mix_q_src_c013_0_05 0 bpf_c013_0 0) vcvs gain=8.314696123025e-01
SMIXQ_c013_0_05 (mix_q_src_c013_0_05 mix_q_c013_0 win_0_05 0) relay vt1=-1m vt2=1m ropen=ropen_mix rclosed=rclosed_mix
EMIXI_c013_0_06 (mix_i_src_c013_0_06 0 bpf_c013_0 0) vcvs gain=-8.314696123025e-01
SMIXI_c013_0_06 (mix_i_src_c013_0_06 mix_i_c013_0 win_0_06 0) relay vt1=-1m vt2=1m ropen=ropen_mix rclosed=rclosed_mix
EMIXQ_c013_0_06 (mix_q_src_c013_0_06 0 bpf_c013_0 0) vcvs gain=5.555702330196e-01
SMIXQ_c013_0_06 (mix_q_src_c013_0_06 mix_q_c013_0 win_0_06 0) relay vt1=-1m vt2=1m ropen=ropen_mix rclosed=rclosed_mix
EMIXI_c013_0_07 (mix_i_src_c013_0_07 0 bpf_c013_0 0) vcvs gain=-9.807852804032e-01
SMIXI_c013_0_07 (mix_i_src_c013_0_07 mix_i_c013_0 win_0_07 0) relay vt1=-1m vt2=1m ropen=ropen_mix rclosed=rclosed_mix
EMIXQ_c013_0_07 (mix_q_src_c013_0_07 0 bpf_c013_0 0) vcvs gain=1.950903220161e-01
SMIXQ_c013_0_07 (mix_q_src_c013_0_07 mix_q_c013_0 win_0_07 0) relay vt1=-1m vt2=1m ropen=ropen_mix rclosed=rclosed_mix
EMIXI_c013_0_08 (mix_i_src_c013_0_08 0 bpf_c013_0 0) vcvs gain=-9.807852804032e-01
SMIXI_c013_0_08 (mix_i_src_c013_0_08 mix_i_c013_0 win_0_08 0) relay vt1=-1m vt2=1m ropen=ropen_mix rclosed=rclosed_mix
EMIXQ_c013_0_08 (mix_q_src_c013_0_08 0 bpf_c013_0 0) vcvs gain=-1.950903220161e-01
SMIXQ_c013_0_08 (mix_q_src_c013_0_08 mix_q_c013_0 win_0_08 0) relay vt1=-1m vt2=1m ropen=ropen_mix rclosed=rclosed_mix
EMIXI_c013_0_09 (mix_i_src_c013_0_09 0 bpf_c013_0 0) vcvs gain=-8.314696123025e-01
SMIXI_c013_0_09 (mix_i_src_c013_0_09 mix_i_c013_0 win_0_09 0) relay vt1=-1m vt2=1m ropen=ropen_mix rclosed=rclosed_mix
EMIXQ_c013_0_09 (mix_q_src_c013_0_09 0 bpf_c013_0 0) vcvs gain=-5.555702330196e-01
SMIXQ_c013_0_09 (mix_q_src_c013_0_09 mix_q_c013_0 win_0_09 0) relay vt1=-1m vt2=1m ropen=ropen_mix rclosed=rclosed_mix
EMIXI_c013_0_10 (mix_i_src_c013_0_10 0 bpf_c013_0 0) vcvs gain=-5.555702330196e-01
SMIXI_c013_0_10 (mix_i_src_c013_0_10 mix_i_c013_0 win_0_10 0) relay vt1=-1m vt2=1m ropen=ropen_mix rclosed=rclosed_mix
EMIXQ_c013_0_10 (mix_q_src_c013_0_10 0 bpf_c013_0 0) vcvs gain=-8.314696123025e-01
SMIXQ_c013_0_10 (mix_q_src_c013_0_10 mix_q_c013_0 win_0_10 0) relay vt1=-1m vt2=1m ropen=ropen_mix rclosed=rclosed_mix
EMIXI_c013_0_11 (mix_i_src_c013_0_11 0 bpf_c013_0 0) vcvs gain=-1.950903220161e-01
SMIXI_c013_0_11 (mix_i_src_c013_0_11 mix_i_c013_0 win_0_11 0) relay vt1=-1m vt2=1m ropen=ropen_mix rclosed=rclosed_mix
EMIXQ_c013_0_11 (mix_q_src_c013_0_11 0 bpf_c013_0 0) vcvs gain=-9.807852804032e-01
SMIXQ_c013_0_11 (mix_q_src_c013_0_11 mix_q_c013_0 win_0_11 0) relay vt1=-1m vt2=1m ropen=ropen_mix rclosed=rclosed_mix
EMIXI_c013_0_12 (mix_i_src_c013_0_12 0 bpf_c013_0 0) vcvs gain=1.950903220161e-01
SMIXI_c013_0_12 (mix_i_src_c013_0_12 mix_i_c013_0 win_0_12 0) relay vt1=-1m vt2=1m ropen=ropen_mix rclosed=rclosed_mix
EMIXQ_c013_0_12 (mix_q_src_c013_0_12 0 bpf_c013_0 0) vcvs gain=-9.807852804032e-01
SMIXQ_c013_0_12 (mix_q_src_c013_0_12 mix_q_c013_0 win_0_12 0) relay vt1=-1m vt2=1m ropen=ropen_mix rclosed=rclosed_mix
EMIXI_c013_0_13 (mix_i_src_c013_0_13 0 bpf_c013_0 0) vcvs gain=5.555702330196e-01
SMIXI_c013_0_13 (mix_i_src_c013_0_13 mix_i_c013_0 win_0_13 0) relay vt1=-1m vt2=1m ropen=ropen_mix rclosed=rclosed_mix
EMIXQ_c013_0_13 (mix_q_src_c013_0_13 0 bpf_c013_0 0) vcvs gain=-8.314696123025e-01
SMIXQ_c013_0_13 (mix_q_src_c013_0_13 mix_q_c013_0 win_0_13 0) relay vt1=-1m vt2=1m ropen=ropen_mix rclosed=rclosed_mix
EMIXI_c013_0_14 (mix_i_src_c013_0_14 0 bpf_c013_0 0) vcvs gain=8.314696123025e-01
SMIXI_c013_0_14 (mix_i_src_c013_0_14 mix_i_c013_0 win_0_14 0) relay vt1=-1m vt2=1m ropen=ropen_mix rclosed=rclosed_mix
EMIXQ_c013_0_14 (mix_q_src_c013_0_14 0 bpf_c013_0 0) vcvs gain=-5.555702330196e-01
SMIXQ_c013_0_14 (mix_q_src_c013_0_14 mix_q_c013_0 win_0_14 0) relay vt1=-1m vt2=1m ropen=ropen_mix rclosed=rclosed_mix
EMIXI_c013_0_15 (mix_i_src_c013_0_15 0 bpf_c013_0 0) vcvs gain=9.807852804032e-01
SMIXI_c013_0_15 (mix_i_src_c013_0_15 mix_i_c013_0 win_0_15 0) relay vt1=-1m vt2=1m ropen=ropen_mix rclosed=rclosed_mix
EMIXQ_c013_0_15 (mix_q_src_c013_0_15 0 bpf_c013_0 0) vcvs gain=-1.950903220161e-01
SMIXQ_c013_0_15 (mix_q_src_c013_0_15 mix_q_c013_0 win_0_15 0) relay vt1=-1m vt2=1m ropen=ropen_mix rclosed=rclosed_mix
RMIXI_c013_0 (mix_i_c013_0 0) resistor r=1G
RMIXQ_c013_0 (mix_q_c013_0 0) resistor r=1G
RINTI_c013_0 (mix_i_c013_0 Icar_c013_0) resistor r=1k
CINTI_c013_0 (Icar_c013_0 0) capacitor c=80p
RINTQ_c013_0 (mix_q_c013_0 Qcar_c013_0) resistor r=1k
CINTQ_c013_0 (Qcar_c013_0 0) capacitor c=80p
save bpf_c013_0 Icar_c013_0 Qcar_c013_0

// bl013, carrier_1: 500000000 Hz coherent I/Q phase-window verification-demod path
CBPF_c013_1 (bl013 n_cbpf_c013_1) capacitor c=1.013211836423e-13
LBPF_c013_1 (n_cbpf_c013_1 bpf_c013_1) inductor l=1.000000000000e-06
RBPF_c013_1 (bpf_c013_1 0) resistor r=1.570796326795e+02
EMIXI_c013_1_00 (mix_i_src_c013_1_00 0 bpf_c013_1 0) vcvs gain=9.807852804032e-01
SMIXI_c013_1_00 (mix_i_src_c013_1_00 mix_i_c013_1 win_1_00 0) relay vt1=-1m vt2=1m ropen=ropen_mix rclosed=rclosed_mix
EMIXQ_c013_1_00 (mix_q_src_c013_1_00 0 bpf_c013_1 0) vcvs gain=1.950903220161e-01
SMIXQ_c013_1_00 (mix_q_src_c013_1_00 mix_q_c013_1 win_1_00 0) relay vt1=-1m vt2=1m ropen=ropen_mix rclosed=rclosed_mix
EMIXI_c013_1_01 (mix_i_src_c013_1_01 0 bpf_c013_1 0) vcvs gain=8.314696123025e-01
SMIXI_c013_1_01 (mix_i_src_c013_1_01 mix_i_c013_1 win_1_01 0) relay vt1=-1m vt2=1m ropen=ropen_mix rclosed=rclosed_mix
EMIXQ_c013_1_01 (mix_q_src_c013_1_01 0 bpf_c013_1 0) vcvs gain=5.555702330196e-01
SMIXQ_c013_1_01 (mix_q_src_c013_1_01 mix_q_c013_1 win_1_01 0) relay vt1=-1m vt2=1m ropen=ropen_mix rclosed=rclosed_mix
EMIXI_c013_1_02 (mix_i_src_c013_1_02 0 bpf_c013_1 0) vcvs gain=5.555702330196e-01
SMIXI_c013_1_02 (mix_i_src_c013_1_02 mix_i_c013_1 win_1_02 0) relay vt1=-1m vt2=1m ropen=ropen_mix rclosed=rclosed_mix
EMIXQ_c013_1_02 (mix_q_src_c013_1_02 0 bpf_c013_1 0) vcvs gain=8.314696123025e-01
SMIXQ_c013_1_02 (mix_q_src_c013_1_02 mix_q_c013_1 win_1_02 0) relay vt1=-1m vt2=1m ropen=ropen_mix rclosed=rclosed_mix
EMIXI_c013_1_03 (mix_i_src_c013_1_03 0 bpf_c013_1 0) vcvs gain=1.950903220161e-01
SMIXI_c013_1_03 (mix_i_src_c013_1_03 mix_i_c013_1 win_1_03 0) relay vt1=-1m vt2=1m ropen=ropen_mix rclosed=rclosed_mix
EMIXQ_c013_1_03 (mix_q_src_c013_1_03 0 bpf_c013_1 0) vcvs gain=9.807852804032e-01
SMIXQ_c013_1_03 (mix_q_src_c013_1_03 mix_q_c013_1 win_1_03 0) relay vt1=-1m vt2=1m ropen=ropen_mix rclosed=rclosed_mix
EMIXI_c013_1_04 (mix_i_src_c013_1_04 0 bpf_c013_1 0) vcvs gain=-1.950903220161e-01
SMIXI_c013_1_04 (mix_i_src_c013_1_04 mix_i_c013_1 win_1_04 0) relay vt1=-1m vt2=1m ropen=ropen_mix rclosed=rclosed_mix
EMIXQ_c013_1_04 (mix_q_src_c013_1_04 0 bpf_c013_1 0) vcvs gain=9.807852804032e-01
SMIXQ_c013_1_04 (mix_q_src_c013_1_04 mix_q_c013_1 win_1_04 0) relay vt1=-1m vt2=1m ropen=ropen_mix rclosed=rclosed_mix
EMIXI_c013_1_05 (mix_i_src_c013_1_05 0 bpf_c013_1 0) vcvs gain=-5.555702330196e-01
SMIXI_c013_1_05 (mix_i_src_c013_1_05 mix_i_c013_1 win_1_05 0) relay vt1=-1m vt2=1m ropen=ropen_mix rclosed=rclosed_mix
EMIXQ_c013_1_05 (mix_q_src_c013_1_05 0 bpf_c013_1 0) vcvs gain=8.314696123025e-01
SMIXQ_c013_1_05 (mix_q_src_c013_1_05 mix_q_c013_1 win_1_05 0) relay vt1=-1m vt2=1m ropen=ropen_mix rclosed=rclosed_mix
EMIXI_c013_1_06 (mix_i_src_c013_1_06 0 bpf_c013_1 0) vcvs gain=-8.314696123025e-01
SMIXI_c013_1_06 (mix_i_src_c013_1_06 mix_i_c013_1 win_1_06 0) relay vt1=-1m vt2=1m ropen=ropen_mix rclosed=rclosed_mix
EMIXQ_c013_1_06 (mix_q_src_c013_1_06 0 bpf_c013_1 0) vcvs gain=5.555702330196e-01
SMIXQ_c013_1_06 (mix_q_src_c013_1_06 mix_q_c013_1 win_1_06 0) relay vt1=-1m vt2=1m ropen=ropen_mix rclosed=rclosed_mix
EMIXI_c013_1_07 (mix_i_src_c013_1_07 0 bpf_c013_1 0) vcvs gain=-9.807852804032e-01
SMIXI_c013_1_07 (mix_i_src_c013_1_07 mix_i_c013_1 win_1_07 0) relay vt1=-1m vt2=1m ropen=ropen_mix rclosed=rclosed_mix
EMIXQ_c013_1_07 (mix_q_src_c013_1_07 0 bpf_c013_1 0) vcvs gain=1.950903220161e-01
SMIXQ_c013_1_07 (mix_q_src_c013_1_07 mix_q_c013_1 win_1_07 0) relay vt1=-1m vt2=1m ropen=ropen_mix rclosed=rclosed_mix
EMIXI_c013_1_08 (mix_i_src_c013_1_08 0 bpf_c013_1 0) vcvs gain=-9.807852804032e-01
SMIXI_c013_1_08 (mix_i_src_c013_1_08 mix_i_c013_1 win_1_08 0) relay vt1=-1m vt2=1m ropen=ropen_mix rclosed=rclosed_mix
EMIXQ_c013_1_08 (mix_q_src_c013_1_08 0 bpf_c013_1 0) vcvs gain=-1.950903220161e-01
SMIXQ_c013_1_08 (mix_q_src_c013_1_08 mix_q_c013_1 win_1_08 0) relay vt1=-1m vt2=1m ropen=ropen_mix rclosed=rclosed_mix
EMIXI_c013_1_09 (mix_i_src_c013_1_09 0 bpf_c013_1 0) vcvs gain=-8.314696123025e-01
SMIXI_c013_1_09 (mix_i_src_c013_1_09 mix_i_c013_1 win_1_09 0) relay vt1=-1m vt2=1m ropen=ropen_mix rclosed=rclosed_mix
EMIXQ_c013_1_09 (mix_q_src_c013_1_09 0 bpf_c013_1 0) vcvs gain=-5.555702330196e-01
SMIXQ_c013_1_09 (mix_q_src_c013_1_09 mix_q_c013_1 win_1_09 0) relay vt1=-1m vt2=1m ropen=ropen_mix rclosed=rclosed_mix
EMIXI_c013_1_10 (mix_i_src_c013_1_10 0 bpf_c013_1 0) vcvs gain=-5.555702330196e-01
SMIXI_c013_1_10 (mix_i_src_c013_1_10 mix_i_c013_1 win_1_10 0) relay vt1=-1m vt2=1m ropen=ropen_mix rclosed=rclosed_mix
EMIXQ_c013_1_10 (mix_q_src_c013_1_10 0 bpf_c013_1 0) vcvs gain=-8.314696123025e-01
SMIXQ_c013_1_10 (mix_q_src_c013_1_10 mix_q_c013_1 win_1_10 0) relay vt1=-1m vt2=1m ropen=ropen_mix rclosed=rclosed_mix
EMIXI_c013_1_11 (mix_i_src_c013_1_11 0 bpf_c013_1 0) vcvs gain=-1.950903220161e-01
SMIXI_c013_1_11 (mix_i_src_c013_1_11 mix_i_c013_1 win_1_11 0) relay vt1=-1m vt2=1m ropen=ropen_mix rclosed=rclosed_mix
EMIXQ_c013_1_11 (mix_q_src_c013_1_11 0 bpf_c013_1 0) vcvs gain=-9.807852804032e-01
SMIXQ_c013_1_11 (mix_q_src_c013_1_11 mix_q_c013_1 win_1_11 0) relay vt1=-1m vt2=1m ropen=ropen_mix rclosed=rclosed_mix
EMIXI_c013_1_12 (mix_i_src_c013_1_12 0 bpf_c013_1 0) vcvs gain=1.950903220161e-01
SMIXI_c013_1_12 (mix_i_src_c013_1_12 mix_i_c013_1 win_1_12 0) relay vt1=-1m vt2=1m ropen=ropen_mix rclosed=rclosed_mix
EMIXQ_c013_1_12 (mix_q_src_c013_1_12 0 bpf_c013_1 0) vcvs gain=-9.807852804032e-01
SMIXQ_c013_1_12 (mix_q_src_c013_1_12 mix_q_c013_1 win_1_12 0) relay vt1=-1m vt2=1m ropen=ropen_mix rclosed=rclosed_mix
EMIXI_c013_1_13 (mix_i_src_c013_1_13 0 bpf_c013_1 0) vcvs gain=5.555702330196e-01
SMIXI_c013_1_13 (mix_i_src_c013_1_13 mix_i_c013_1 win_1_13 0) relay vt1=-1m vt2=1m ropen=ropen_mix rclosed=rclosed_mix
EMIXQ_c013_1_13 (mix_q_src_c013_1_13 0 bpf_c013_1 0) vcvs gain=-8.314696123025e-01
SMIXQ_c013_1_13 (mix_q_src_c013_1_13 mix_q_c013_1 win_1_13 0) relay vt1=-1m vt2=1m ropen=ropen_mix rclosed=rclosed_mix
EMIXI_c013_1_14 (mix_i_src_c013_1_14 0 bpf_c013_1 0) vcvs gain=8.314696123025e-01
SMIXI_c013_1_14 (mix_i_src_c013_1_14 mix_i_c013_1 win_1_14 0) relay vt1=-1m vt2=1m ropen=ropen_mix rclosed=rclosed_mix
EMIXQ_c013_1_14 (mix_q_src_c013_1_14 0 bpf_c013_1 0) vcvs gain=-5.555702330196e-01
SMIXQ_c013_1_14 (mix_q_src_c013_1_14 mix_q_c013_1 win_1_14 0) relay vt1=-1m vt2=1m ropen=ropen_mix rclosed=rclosed_mix
EMIXI_c013_1_15 (mix_i_src_c013_1_15 0 bpf_c013_1 0) vcvs gain=9.807852804032e-01
SMIXI_c013_1_15 (mix_i_src_c013_1_15 mix_i_c013_1 win_1_15 0) relay vt1=-1m vt2=1m ropen=ropen_mix rclosed=rclosed_mix
EMIXQ_c013_1_15 (mix_q_src_c013_1_15 0 bpf_c013_1 0) vcvs gain=-1.950903220161e-01
SMIXQ_c013_1_15 (mix_q_src_c013_1_15 mix_q_c013_1 win_1_15 0) relay vt1=-1m vt2=1m ropen=ropen_mix rclosed=rclosed_mix
RMIXI_c013_1 (mix_i_c013_1 0) resistor r=1G
RMIXQ_c013_1 (mix_q_c013_1 0) resistor r=1G
RINTI_c013_1 (mix_i_c013_1 Icar_c013_1) resistor r=1k
CINTI_c013_1 (Icar_c013_1 0) capacitor c=80p
RINTQ_c013_1 (mix_q_c013_1 Qcar_c013_1) resistor r=1k
CINTQ_c013_1 (Qcar_c013_1 0) capacitor c=80p
save bpf_c013_1 Icar_c013_1 Qcar_c013_1

// bl013, carrier_2: 750000000 Hz coherent I/Q phase-window verification-demod path
CBPF_c013_2 (bl013 n_cbpf_c013_2) capacitor c=4.503163717437e-14
LBPF_c013_2 (n_cbpf_c013_2 bpf_c013_2) inductor l=1.000000000000e-06
RBPF_c013_2 (bpf_c013_2 0) resistor r=2.356194490192e+02
EMIXI_c013_2_00 (mix_i_src_c013_2_00 0 bpf_c013_2 0) vcvs gain=9.807852804032e-01
SMIXI_c013_2_00 (mix_i_src_c013_2_00 mix_i_c013_2 win_2_00 0) relay vt1=-1m vt2=1m ropen=ropen_mix rclosed=rclosed_mix
EMIXQ_c013_2_00 (mix_q_src_c013_2_00 0 bpf_c013_2 0) vcvs gain=1.950903220161e-01
SMIXQ_c013_2_00 (mix_q_src_c013_2_00 mix_q_c013_2 win_2_00 0) relay vt1=-1m vt2=1m ropen=ropen_mix rclosed=rclosed_mix
EMIXI_c013_2_01 (mix_i_src_c013_2_01 0 bpf_c013_2 0) vcvs gain=8.314696123025e-01
SMIXI_c013_2_01 (mix_i_src_c013_2_01 mix_i_c013_2 win_2_01 0) relay vt1=-1m vt2=1m ropen=ropen_mix rclosed=rclosed_mix
EMIXQ_c013_2_01 (mix_q_src_c013_2_01 0 bpf_c013_2 0) vcvs gain=5.555702330196e-01
SMIXQ_c013_2_01 (mix_q_src_c013_2_01 mix_q_c013_2 win_2_01 0) relay vt1=-1m vt2=1m ropen=ropen_mix rclosed=rclosed_mix
EMIXI_c013_2_02 (mix_i_src_c013_2_02 0 bpf_c013_2 0) vcvs gain=5.555702330196e-01
SMIXI_c013_2_02 (mix_i_src_c013_2_02 mix_i_c013_2 win_2_02 0) relay vt1=-1m vt2=1m ropen=ropen_mix rclosed=rclosed_mix
EMIXQ_c013_2_02 (mix_q_src_c013_2_02 0 bpf_c013_2 0) vcvs gain=8.314696123025e-01
SMIXQ_c013_2_02 (mix_q_src_c013_2_02 mix_q_c013_2 win_2_02 0) relay vt1=-1m vt2=1m ropen=ropen_mix rclosed=rclosed_mix
EMIXI_c013_2_03 (mix_i_src_c013_2_03 0 bpf_c013_2 0) vcvs gain=1.950903220161e-01
SMIXI_c013_2_03 (mix_i_src_c013_2_03 mix_i_c013_2 win_2_03 0) relay vt1=-1m vt2=1m ropen=ropen_mix rclosed=rclosed_mix
EMIXQ_c013_2_03 (mix_q_src_c013_2_03 0 bpf_c013_2 0) vcvs gain=9.807852804032e-01
SMIXQ_c013_2_03 (mix_q_src_c013_2_03 mix_q_c013_2 win_2_03 0) relay vt1=-1m vt2=1m ropen=ropen_mix rclosed=rclosed_mix
EMIXI_c013_2_04 (mix_i_src_c013_2_04 0 bpf_c013_2 0) vcvs gain=-1.950903220161e-01
SMIXI_c013_2_04 (mix_i_src_c013_2_04 mix_i_c013_2 win_2_04 0) relay vt1=-1m vt2=1m ropen=ropen_mix rclosed=rclosed_mix
EMIXQ_c013_2_04 (mix_q_src_c013_2_04 0 bpf_c013_2 0) vcvs gain=9.807852804032e-01
SMIXQ_c013_2_04 (mix_q_src_c013_2_04 mix_q_c013_2 win_2_04 0) relay vt1=-1m vt2=1m ropen=ropen_mix rclosed=rclosed_mix
EMIXI_c013_2_05 (mix_i_src_c013_2_05 0 bpf_c013_2 0) vcvs gain=-5.555702330196e-01
SMIXI_c013_2_05 (mix_i_src_c013_2_05 mix_i_c013_2 win_2_05 0) relay vt1=-1m vt2=1m ropen=ropen_mix rclosed=rclosed_mix
EMIXQ_c013_2_05 (mix_q_src_c013_2_05 0 bpf_c013_2 0) vcvs gain=8.314696123025e-01
SMIXQ_c013_2_05 (mix_q_src_c013_2_05 mix_q_c013_2 win_2_05 0) relay vt1=-1m vt2=1m ropen=ropen_mix rclosed=rclosed_mix
EMIXI_c013_2_06 (mix_i_src_c013_2_06 0 bpf_c013_2 0) vcvs gain=-8.314696123025e-01
SMIXI_c013_2_06 (mix_i_src_c013_2_06 mix_i_c013_2 win_2_06 0) relay vt1=-1m vt2=1m ropen=ropen_mix rclosed=rclosed_mix
EMIXQ_c013_2_06 (mix_q_src_c013_2_06 0 bpf_c013_2 0) vcvs gain=5.555702330196e-01
SMIXQ_c013_2_06 (mix_q_src_c013_2_06 mix_q_c013_2 win_2_06 0) relay vt1=-1m vt2=1m ropen=ropen_mix rclosed=rclosed_mix
EMIXI_c013_2_07 (mix_i_src_c013_2_07 0 bpf_c013_2 0) vcvs gain=-9.807852804032e-01
SMIXI_c013_2_07 (mix_i_src_c013_2_07 mix_i_c013_2 win_2_07 0) relay vt1=-1m vt2=1m ropen=ropen_mix rclosed=rclosed_mix
EMIXQ_c013_2_07 (mix_q_src_c013_2_07 0 bpf_c013_2 0) vcvs gain=1.950903220161e-01
SMIXQ_c013_2_07 (mix_q_src_c013_2_07 mix_q_c013_2 win_2_07 0) relay vt1=-1m vt2=1m ropen=ropen_mix rclosed=rclosed_mix
EMIXI_c013_2_08 (mix_i_src_c013_2_08 0 bpf_c013_2 0) vcvs gain=-9.807852804032e-01
SMIXI_c013_2_08 (mix_i_src_c013_2_08 mix_i_c013_2 win_2_08 0) relay vt1=-1m vt2=1m ropen=ropen_mix rclosed=rclosed_mix
EMIXQ_c013_2_08 (mix_q_src_c013_2_08 0 bpf_c013_2 0) vcvs gain=-1.950903220161e-01
SMIXQ_c013_2_08 (mix_q_src_c013_2_08 mix_q_c013_2 win_2_08 0) relay vt1=-1m vt2=1m ropen=ropen_mix rclosed=rclosed_mix
EMIXI_c013_2_09 (mix_i_src_c013_2_09 0 bpf_c013_2 0) vcvs gain=-8.314696123025e-01
SMIXI_c013_2_09 (mix_i_src_c013_2_09 mix_i_c013_2 win_2_09 0) relay vt1=-1m vt2=1m ropen=ropen_mix rclosed=rclosed_mix
EMIXQ_c013_2_09 (mix_q_src_c013_2_09 0 bpf_c013_2 0) vcvs gain=-5.555702330196e-01
SMIXQ_c013_2_09 (mix_q_src_c013_2_09 mix_q_c013_2 win_2_09 0) relay vt1=-1m vt2=1m ropen=ropen_mix rclosed=rclosed_mix
EMIXI_c013_2_10 (mix_i_src_c013_2_10 0 bpf_c013_2 0) vcvs gain=-5.555702330196e-01
SMIXI_c013_2_10 (mix_i_src_c013_2_10 mix_i_c013_2 win_2_10 0) relay vt1=-1m vt2=1m ropen=ropen_mix rclosed=rclosed_mix
EMIXQ_c013_2_10 (mix_q_src_c013_2_10 0 bpf_c013_2 0) vcvs gain=-8.314696123025e-01
SMIXQ_c013_2_10 (mix_q_src_c013_2_10 mix_q_c013_2 win_2_10 0) relay vt1=-1m vt2=1m ropen=ropen_mix rclosed=rclosed_mix
EMIXI_c013_2_11 (mix_i_src_c013_2_11 0 bpf_c013_2 0) vcvs gain=-1.950903220161e-01
SMIXI_c013_2_11 (mix_i_src_c013_2_11 mix_i_c013_2 win_2_11 0) relay vt1=-1m vt2=1m ropen=ropen_mix rclosed=rclosed_mix
EMIXQ_c013_2_11 (mix_q_src_c013_2_11 0 bpf_c013_2 0) vcvs gain=-9.807852804032e-01
SMIXQ_c013_2_11 (mix_q_src_c013_2_11 mix_q_c013_2 win_2_11 0) relay vt1=-1m vt2=1m ropen=ropen_mix rclosed=rclosed_mix
EMIXI_c013_2_12 (mix_i_src_c013_2_12 0 bpf_c013_2 0) vcvs gain=1.950903220161e-01
SMIXI_c013_2_12 (mix_i_src_c013_2_12 mix_i_c013_2 win_2_12 0) relay vt1=-1m vt2=1m ropen=ropen_mix rclosed=rclosed_mix
EMIXQ_c013_2_12 (mix_q_src_c013_2_12 0 bpf_c013_2 0) vcvs gain=-9.807852804032e-01
SMIXQ_c013_2_12 (mix_q_src_c013_2_12 mix_q_c013_2 win_2_12 0) relay vt1=-1m vt2=1m ropen=ropen_mix rclosed=rclosed_mix
EMIXI_c013_2_13 (mix_i_src_c013_2_13 0 bpf_c013_2 0) vcvs gain=5.555702330196e-01
SMIXI_c013_2_13 (mix_i_src_c013_2_13 mix_i_c013_2 win_2_13 0) relay vt1=-1m vt2=1m ropen=ropen_mix rclosed=rclosed_mix
EMIXQ_c013_2_13 (mix_q_src_c013_2_13 0 bpf_c013_2 0) vcvs gain=-8.314696123025e-01
SMIXQ_c013_2_13 (mix_q_src_c013_2_13 mix_q_c013_2 win_2_13 0) relay vt1=-1m vt2=1m ropen=ropen_mix rclosed=rclosed_mix
EMIXI_c013_2_14 (mix_i_src_c013_2_14 0 bpf_c013_2 0) vcvs gain=8.314696123025e-01
SMIXI_c013_2_14 (mix_i_src_c013_2_14 mix_i_c013_2 win_2_14 0) relay vt1=-1m vt2=1m ropen=ropen_mix rclosed=rclosed_mix
EMIXQ_c013_2_14 (mix_q_src_c013_2_14 0 bpf_c013_2 0) vcvs gain=-5.555702330196e-01
SMIXQ_c013_2_14 (mix_q_src_c013_2_14 mix_q_c013_2 win_2_14 0) relay vt1=-1m vt2=1m ropen=ropen_mix rclosed=rclosed_mix
EMIXI_c013_2_15 (mix_i_src_c013_2_15 0 bpf_c013_2 0) vcvs gain=9.807852804032e-01
SMIXI_c013_2_15 (mix_i_src_c013_2_15 mix_i_c013_2 win_2_15 0) relay vt1=-1m vt2=1m ropen=ropen_mix rclosed=rclosed_mix
EMIXQ_c013_2_15 (mix_q_src_c013_2_15 0 bpf_c013_2 0) vcvs gain=-1.950903220161e-01
SMIXQ_c013_2_15 (mix_q_src_c013_2_15 mix_q_c013_2 win_2_15 0) relay vt1=-1m vt2=1m ropen=ropen_mix rclosed=rclosed_mix
RMIXI_c013_2 (mix_i_c013_2 0) resistor r=1G
RMIXQ_c013_2 (mix_q_c013_2 0) resistor r=1G
RINTI_c013_2 (mix_i_c013_2 Icar_c013_2) resistor r=1k
CINTI_c013_2 (Icar_c013_2 0) capacitor c=80p
RINTQ_c013_2 (mix_q_c013_2 Qcar_c013_2) resistor r=1k
CINTQ_c013_2 (Qcar_c013_2 0) capacitor c=80p
save bpf_c013_2 Icar_c013_2 Qcar_c013_2

// bl013, carrier_3: 1000000000 Hz coherent I/Q phase-window verification-demod path
CBPF_c013_3 (bl013 n_cbpf_c013_3) capacitor c=2.533029591058e-14
LBPF_c013_3 (n_cbpf_c013_3 bpf_c013_3) inductor l=1.000000000000e-06
RBPF_c013_3 (bpf_c013_3 0) resistor r=3.141592653590e+02
EMIXI_c013_3_00 (mix_i_src_c013_3_00 0 bpf_c013_3 0) vcvs gain=9.807852804032e-01
SMIXI_c013_3_00 (mix_i_src_c013_3_00 mix_i_c013_3 win_3_00 0) relay vt1=-1m vt2=1m ropen=ropen_mix rclosed=rclosed_mix
EMIXQ_c013_3_00 (mix_q_src_c013_3_00 0 bpf_c013_3 0) vcvs gain=1.950903220161e-01
SMIXQ_c013_3_00 (mix_q_src_c013_3_00 mix_q_c013_3 win_3_00 0) relay vt1=-1m vt2=1m ropen=ropen_mix rclosed=rclosed_mix
EMIXI_c013_3_01 (mix_i_src_c013_3_01 0 bpf_c013_3 0) vcvs gain=8.314696123025e-01
SMIXI_c013_3_01 (mix_i_src_c013_3_01 mix_i_c013_3 win_3_01 0) relay vt1=-1m vt2=1m ropen=ropen_mix rclosed=rclosed_mix
EMIXQ_c013_3_01 (mix_q_src_c013_3_01 0 bpf_c013_3 0) vcvs gain=5.555702330196e-01
SMIXQ_c013_3_01 (mix_q_src_c013_3_01 mix_q_c013_3 win_3_01 0) relay vt1=-1m vt2=1m ropen=ropen_mix rclosed=rclosed_mix
EMIXI_c013_3_02 (mix_i_src_c013_3_02 0 bpf_c013_3 0) vcvs gain=5.555702330196e-01
SMIXI_c013_3_02 (mix_i_src_c013_3_02 mix_i_c013_3 win_3_02 0) relay vt1=-1m vt2=1m ropen=ropen_mix rclosed=rclosed_mix
EMIXQ_c013_3_02 (mix_q_src_c013_3_02 0 bpf_c013_3 0) vcvs gain=8.314696123025e-01
SMIXQ_c013_3_02 (mix_q_src_c013_3_02 mix_q_c013_3 win_3_02 0) relay vt1=-1m vt2=1m ropen=ropen_mix rclosed=rclosed_mix
EMIXI_c013_3_03 (mix_i_src_c013_3_03 0 bpf_c013_3 0) vcvs gain=1.950903220161e-01
SMIXI_c013_3_03 (mix_i_src_c013_3_03 mix_i_c013_3 win_3_03 0) relay vt1=-1m vt2=1m ropen=ropen_mix rclosed=rclosed_mix
EMIXQ_c013_3_03 (mix_q_src_c013_3_03 0 bpf_c013_3 0) vcvs gain=9.807852804032e-01
SMIXQ_c013_3_03 (mix_q_src_c013_3_03 mix_q_c013_3 win_3_03 0) relay vt1=-1m vt2=1m ropen=ropen_mix rclosed=rclosed_mix
EMIXI_c013_3_04 (mix_i_src_c013_3_04 0 bpf_c013_3 0) vcvs gain=-1.950903220161e-01
SMIXI_c013_3_04 (mix_i_src_c013_3_04 mix_i_c013_3 win_3_04 0) relay vt1=-1m vt2=1m ropen=ropen_mix rclosed=rclosed_mix
EMIXQ_c013_3_04 (mix_q_src_c013_3_04 0 bpf_c013_3 0) vcvs gain=9.807852804032e-01
SMIXQ_c013_3_04 (mix_q_src_c013_3_04 mix_q_c013_3 win_3_04 0) relay vt1=-1m vt2=1m ropen=ropen_mix rclosed=rclosed_mix
EMIXI_c013_3_05 (mix_i_src_c013_3_05 0 bpf_c013_3 0) vcvs gain=-5.555702330196e-01
SMIXI_c013_3_05 (mix_i_src_c013_3_05 mix_i_c013_3 win_3_05 0) relay vt1=-1m vt2=1m ropen=ropen_mix rclosed=rclosed_mix
EMIXQ_c013_3_05 (mix_q_src_c013_3_05 0 bpf_c013_3 0) vcvs gain=8.314696123025e-01
SMIXQ_c013_3_05 (mix_q_src_c013_3_05 mix_q_c013_3 win_3_05 0) relay vt1=-1m vt2=1m ropen=ropen_mix rclosed=rclosed_mix
EMIXI_c013_3_06 (mix_i_src_c013_3_06 0 bpf_c013_3 0) vcvs gain=-8.314696123025e-01
SMIXI_c013_3_06 (mix_i_src_c013_3_06 mix_i_c013_3 win_3_06 0) relay vt1=-1m vt2=1m ropen=ropen_mix rclosed=rclosed_mix
EMIXQ_c013_3_06 (mix_q_src_c013_3_06 0 bpf_c013_3 0) vcvs gain=5.555702330196e-01
SMIXQ_c013_3_06 (mix_q_src_c013_3_06 mix_q_c013_3 win_3_06 0) relay vt1=-1m vt2=1m ropen=ropen_mix rclosed=rclosed_mix
EMIXI_c013_3_07 (mix_i_src_c013_3_07 0 bpf_c013_3 0) vcvs gain=-9.807852804032e-01
SMIXI_c013_3_07 (mix_i_src_c013_3_07 mix_i_c013_3 win_3_07 0) relay vt1=-1m vt2=1m ropen=ropen_mix rclosed=rclosed_mix
EMIXQ_c013_3_07 (mix_q_src_c013_3_07 0 bpf_c013_3 0) vcvs gain=1.950903220161e-01
SMIXQ_c013_3_07 (mix_q_src_c013_3_07 mix_q_c013_3 win_3_07 0) relay vt1=-1m vt2=1m ropen=ropen_mix rclosed=rclosed_mix
EMIXI_c013_3_08 (mix_i_src_c013_3_08 0 bpf_c013_3 0) vcvs gain=-9.807852804032e-01
SMIXI_c013_3_08 (mix_i_src_c013_3_08 mix_i_c013_3 win_3_08 0) relay vt1=-1m vt2=1m ropen=ropen_mix rclosed=rclosed_mix
EMIXQ_c013_3_08 (mix_q_src_c013_3_08 0 bpf_c013_3 0) vcvs gain=-1.950903220161e-01
SMIXQ_c013_3_08 (mix_q_src_c013_3_08 mix_q_c013_3 win_3_08 0) relay vt1=-1m vt2=1m ropen=ropen_mix rclosed=rclosed_mix
EMIXI_c013_3_09 (mix_i_src_c013_3_09 0 bpf_c013_3 0) vcvs gain=-8.314696123025e-01
SMIXI_c013_3_09 (mix_i_src_c013_3_09 mix_i_c013_3 win_3_09 0) relay vt1=-1m vt2=1m ropen=ropen_mix rclosed=rclosed_mix
EMIXQ_c013_3_09 (mix_q_src_c013_3_09 0 bpf_c013_3 0) vcvs gain=-5.555702330196e-01
SMIXQ_c013_3_09 (mix_q_src_c013_3_09 mix_q_c013_3 win_3_09 0) relay vt1=-1m vt2=1m ropen=ropen_mix rclosed=rclosed_mix
EMIXI_c013_3_10 (mix_i_src_c013_3_10 0 bpf_c013_3 0) vcvs gain=-5.555702330196e-01
SMIXI_c013_3_10 (mix_i_src_c013_3_10 mix_i_c013_3 win_3_10 0) relay vt1=-1m vt2=1m ropen=ropen_mix rclosed=rclosed_mix
EMIXQ_c013_3_10 (mix_q_src_c013_3_10 0 bpf_c013_3 0) vcvs gain=-8.314696123025e-01
SMIXQ_c013_3_10 (mix_q_src_c013_3_10 mix_q_c013_3 win_3_10 0) relay vt1=-1m vt2=1m ropen=ropen_mix rclosed=rclosed_mix
EMIXI_c013_3_11 (mix_i_src_c013_3_11 0 bpf_c013_3 0) vcvs gain=-1.950903220161e-01
SMIXI_c013_3_11 (mix_i_src_c013_3_11 mix_i_c013_3 win_3_11 0) relay vt1=-1m vt2=1m ropen=ropen_mix rclosed=rclosed_mix
EMIXQ_c013_3_11 (mix_q_src_c013_3_11 0 bpf_c013_3 0) vcvs gain=-9.807852804032e-01
SMIXQ_c013_3_11 (mix_q_src_c013_3_11 mix_q_c013_3 win_3_11 0) relay vt1=-1m vt2=1m ropen=ropen_mix rclosed=rclosed_mix
EMIXI_c013_3_12 (mix_i_src_c013_3_12 0 bpf_c013_3 0) vcvs gain=1.950903220161e-01
SMIXI_c013_3_12 (mix_i_src_c013_3_12 mix_i_c013_3 win_3_12 0) relay vt1=-1m vt2=1m ropen=ropen_mix rclosed=rclosed_mix
EMIXQ_c013_3_12 (mix_q_src_c013_3_12 0 bpf_c013_3 0) vcvs gain=-9.807852804032e-01
SMIXQ_c013_3_12 (mix_q_src_c013_3_12 mix_q_c013_3 win_3_12 0) relay vt1=-1m vt2=1m ropen=ropen_mix rclosed=rclosed_mix
EMIXI_c013_3_13 (mix_i_src_c013_3_13 0 bpf_c013_3 0) vcvs gain=5.555702330196e-01
SMIXI_c013_3_13 (mix_i_src_c013_3_13 mix_i_c013_3 win_3_13 0) relay vt1=-1m vt2=1m ropen=ropen_mix rclosed=rclosed_mix
EMIXQ_c013_3_13 (mix_q_src_c013_3_13 0 bpf_c013_3 0) vcvs gain=-8.314696123025e-01
SMIXQ_c013_3_13 (mix_q_src_c013_3_13 mix_q_c013_3 win_3_13 0) relay vt1=-1m vt2=1m ropen=ropen_mix rclosed=rclosed_mix
EMIXI_c013_3_14 (mix_i_src_c013_3_14 0 bpf_c013_3 0) vcvs gain=8.314696123025e-01
SMIXI_c013_3_14 (mix_i_src_c013_3_14 mix_i_c013_3 win_3_14 0) relay vt1=-1m vt2=1m ropen=ropen_mix rclosed=rclosed_mix
EMIXQ_c013_3_14 (mix_q_src_c013_3_14 0 bpf_c013_3 0) vcvs gain=-5.555702330196e-01
SMIXQ_c013_3_14 (mix_q_src_c013_3_14 mix_q_c013_3 win_3_14 0) relay vt1=-1m vt2=1m ropen=ropen_mix rclosed=rclosed_mix
EMIXI_c013_3_15 (mix_i_src_c013_3_15 0 bpf_c013_3 0) vcvs gain=9.807852804032e-01
SMIXI_c013_3_15 (mix_i_src_c013_3_15 mix_i_c013_3 win_3_15 0) relay vt1=-1m vt2=1m ropen=ropen_mix rclosed=rclosed_mix
EMIXQ_c013_3_15 (mix_q_src_c013_3_15 0 bpf_c013_3 0) vcvs gain=-1.950903220161e-01
SMIXQ_c013_3_15 (mix_q_src_c013_3_15 mix_q_c013_3 win_3_15 0) relay vt1=-1m vt2=1m ropen=ropen_mix rclosed=rclosed_mix
RMIXI_c013_3 (mix_i_c013_3 0) resistor r=1G
RMIXQ_c013_3 (mix_q_c013_3 0) resistor r=1G
RINTI_c013_3 (mix_i_c013_3 Icar_c013_3) resistor r=1k
CINTI_c013_3 (Icar_c013_3 0) capacitor c=80p
RINTQ_c013_3 (mix_q_c013_3 Qcar_c013_3) resistor r=1k
CINTQ_c013_3 (Qcar_c013_3 0) capacitor c=80p
save bpf_c013_3 Icar_c013_3 Qcar_c013_3

// bl014, carrier_0: 250000000 Hz coherent I/Q phase-window verification-demod path
CBPF_c014_0 (bl014 n_cbpf_c014_0) capacitor c=4.052847345694e-13
LBPF_c014_0 (n_cbpf_c014_0 bpf_c014_0) inductor l=1.000000000000e-06
RBPF_c014_0 (bpf_c014_0 0) resistor r=7.853981633974e+01
EMIXI_c014_0_00 (mix_i_src_c014_0_00 0 bpf_c014_0 0) vcvs gain=9.807852804032e-01
SMIXI_c014_0_00 (mix_i_src_c014_0_00 mix_i_c014_0 win_0_00 0) relay vt1=-1m vt2=1m ropen=ropen_mix rclosed=rclosed_mix
EMIXQ_c014_0_00 (mix_q_src_c014_0_00 0 bpf_c014_0 0) vcvs gain=1.950903220161e-01
SMIXQ_c014_0_00 (mix_q_src_c014_0_00 mix_q_c014_0 win_0_00 0) relay vt1=-1m vt2=1m ropen=ropen_mix rclosed=rclosed_mix
EMIXI_c014_0_01 (mix_i_src_c014_0_01 0 bpf_c014_0 0) vcvs gain=8.314696123025e-01
SMIXI_c014_0_01 (mix_i_src_c014_0_01 mix_i_c014_0 win_0_01 0) relay vt1=-1m vt2=1m ropen=ropen_mix rclosed=rclosed_mix
EMIXQ_c014_0_01 (mix_q_src_c014_0_01 0 bpf_c014_0 0) vcvs gain=5.555702330196e-01
SMIXQ_c014_0_01 (mix_q_src_c014_0_01 mix_q_c014_0 win_0_01 0) relay vt1=-1m vt2=1m ropen=ropen_mix rclosed=rclosed_mix
EMIXI_c014_0_02 (mix_i_src_c014_0_02 0 bpf_c014_0 0) vcvs gain=5.555702330196e-01
SMIXI_c014_0_02 (mix_i_src_c014_0_02 mix_i_c014_0 win_0_02 0) relay vt1=-1m vt2=1m ropen=ropen_mix rclosed=rclosed_mix
EMIXQ_c014_0_02 (mix_q_src_c014_0_02 0 bpf_c014_0 0) vcvs gain=8.314696123025e-01
SMIXQ_c014_0_02 (mix_q_src_c014_0_02 mix_q_c014_0 win_0_02 0) relay vt1=-1m vt2=1m ropen=ropen_mix rclosed=rclosed_mix
EMIXI_c014_0_03 (mix_i_src_c014_0_03 0 bpf_c014_0 0) vcvs gain=1.950903220161e-01
SMIXI_c014_0_03 (mix_i_src_c014_0_03 mix_i_c014_0 win_0_03 0) relay vt1=-1m vt2=1m ropen=ropen_mix rclosed=rclosed_mix
EMIXQ_c014_0_03 (mix_q_src_c014_0_03 0 bpf_c014_0 0) vcvs gain=9.807852804032e-01
SMIXQ_c014_0_03 (mix_q_src_c014_0_03 mix_q_c014_0 win_0_03 0) relay vt1=-1m vt2=1m ropen=ropen_mix rclosed=rclosed_mix
EMIXI_c014_0_04 (mix_i_src_c014_0_04 0 bpf_c014_0 0) vcvs gain=-1.950903220161e-01
SMIXI_c014_0_04 (mix_i_src_c014_0_04 mix_i_c014_0 win_0_04 0) relay vt1=-1m vt2=1m ropen=ropen_mix rclosed=rclosed_mix
EMIXQ_c014_0_04 (mix_q_src_c014_0_04 0 bpf_c014_0 0) vcvs gain=9.807852804032e-01
SMIXQ_c014_0_04 (mix_q_src_c014_0_04 mix_q_c014_0 win_0_04 0) relay vt1=-1m vt2=1m ropen=ropen_mix rclosed=rclosed_mix
EMIXI_c014_0_05 (mix_i_src_c014_0_05 0 bpf_c014_0 0) vcvs gain=-5.555702330196e-01
SMIXI_c014_0_05 (mix_i_src_c014_0_05 mix_i_c014_0 win_0_05 0) relay vt1=-1m vt2=1m ropen=ropen_mix rclosed=rclosed_mix
EMIXQ_c014_0_05 (mix_q_src_c014_0_05 0 bpf_c014_0 0) vcvs gain=8.314696123025e-01
SMIXQ_c014_0_05 (mix_q_src_c014_0_05 mix_q_c014_0 win_0_05 0) relay vt1=-1m vt2=1m ropen=ropen_mix rclosed=rclosed_mix
EMIXI_c014_0_06 (mix_i_src_c014_0_06 0 bpf_c014_0 0) vcvs gain=-8.314696123025e-01
SMIXI_c014_0_06 (mix_i_src_c014_0_06 mix_i_c014_0 win_0_06 0) relay vt1=-1m vt2=1m ropen=ropen_mix rclosed=rclosed_mix
EMIXQ_c014_0_06 (mix_q_src_c014_0_06 0 bpf_c014_0 0) vcvs gain=5.555702330196e-01
SMIXQ_c014_0_06 (mix_q_src_c014_0_06 mix_q_c014_0 win_0_06 0) relay vt1=-1m vt2=1m ropen=ropen_mix rclosed=rclosed_mix
EMIXI_c014_0_07 (mix_i_src_c014_0_07 0 bpf_c014_0 0) vcvs gain=-9.807852804032e-01
SMIXI_c014_0_07 (mix_i_src_c014_0_07 mix_i_c014_0 win_0_07 0) relay vt1=-1m vt2=1m ropen=ropen_mix rclosed=rclosed_mix
EMIXQ_c014_0_07 (mix_q_src_c014_0_07 0 bpf_c014_0 0) vcvs gain=1.950903220161e-01
SMIXQ_c014_0_07 (mix_q_src_c014_0_07 mix_q_c014_0 win_0_07 0) relay vt1=-1m vt2=1m ropen=ropen_mix rclosed=rclosed_mix
EMIXI_c014_0_08 (mix_i_src_c014_0_08 0 bpf_c014_0 0) vcvs gain=-9.807852804032e-01
SMIXI_c014_0_08 (mix_i_src_c014_0_08 mix_i_c014_0 win_0_08 0) relay vt1=-1m vt2=1m ropen=ropen_mix rclosed=rclosed_mix
EMIXQ_c014_0_08 (mix_q_src_c014_0_08 0 bpf_c014_0 0) vcvs gain=-1.950903220161e-01
SMIXQ_c014_0_08 (mix_q_src_c014_0_08 mix_q_c014_0 win_0_08 0) relay vt1=-1m vt2=1m ropen=ropen_mix rclosed=rclosed_mix
EMIXI_c014_0_09 (mix_i_src_c014_0_09 0 bpf_c014_0 0) vcvs gain=-8.314696123025e-01
SMIXI_c014_0_09 (mix_i_src_c014_0_09 mix_i_c014_0 win_0_09 0) relay vt1=-1m vt2=1m ropen=ropen_mix rclosed=rclosed_mix
EMIXQ_c014_0_09 (mix_q_src_c014_0_09 0 bpf_c014_0 0) vcvs gain=-5.555702330196e-01
SMIXQ_c014_0_09 (mix_q_src_c014_0_09 mix_q_c014_0 win_0_09 0) relay vt1=-1m vt2=1m ropen=ropen_mix rclosed=rclosed_mix
EMIXI_c014_0_10 (mix_i_src_c014_0_10 0 bpf_c014_0 0) vcvs gain=-5.555702330196e-01
SMIXI_c014_0_10 (mix_i_src_c014_0_10 mix_i_c014_0 win_0_10 0) relay vt1=-1m vt2=1m ropen=ropen_mix rclosed=rclosed_mix
EMIXQ_c014_0_10 (mix_q_src_c014_0_10 0 bpf_c014_0 0) vcvs gain=-8.314696123025e-01
SMIXQ_c014_0_10 (mix_q_src_c014_0_10 mix_q_c014_0 win_0_10 0) relay vt1=-1m vt2=1m ropen=ropen_mix rclosed=rclosed_mix
EMIXI_c014_0_11 (mix_i_src_c014_0_11 0 bpf_c014_0 0) vcvs gain=-1.950903220161e-01
SMIXI_c014_0_11 (mix_i_src_c014_0_11 mix_i_c014_0 win_0_11 0) relay vt1=-1m vt2=1m ropen=ropen_mix rclosed=rclosed_mix
EMIXQ_c014_0_11 (mix_q_src_c014_0_11 0 bpf_c014_0 0) vcvs gain=-9.807852804032e-01
SMIXQ_c014_0_11 (mix_q_src_c014_0_11 mix_q_c014_0 win_0_11 0) relay vt1=-1m vt2=1m ropen=ropen_mix rclosed=rclosed_mix
EMIXI_c014_0_12 (mix_i_src_c014_0_12 0 bpf_c014_0 0) vcvs gain=1.950903220161e-01
SMIXI_c014_0_12 (mix_i_src_c014_0_12 mix_i_c014_0 win_0_12 0) relay vt1=-1m vt2=1m ropen=ropen_mix rclosed=rclosed_mix
EMIXQ_c014_0_12 (mix_q_src_c014_0_12 0 bpf_c014_0 0) vcvs gain=-9.807852804032e-01
SMIXQ_c014_0_12 (mix_q_src_c014_0_12 mix_q_c014_0 win_0_12 0) relay vt1=-1m vt2=1m ropen=ropen_mix rclosed=rclosed_mix
EMIXI_c014_0_13 (mix_i_src_c014_0_13 0 bpf_c014_0 0) vcvs gain=5.555702330196e-01
SMIXI_c014_0_13 (mix_i_src_c014_0_13 mix_i_c014_0 win_0_13 0) relay vt1=-1m vt2=1m ropen=ropen_mix rclosed=rclosed_mix
EMIXQ_c014_0_13 (mix_q_src_c014_0_13 0 bpf_c014_0 0) vcvs gain=-8.314696123025e-01
SMIXQ_c014_0_13 (mix_q_src_c014_0_13 mix_q_c014_0 win_0_13 0) relay vt1=-1m vt2=1m ropen=ropen_mix rclosed=rclosed_mix
EMIXI_c014_0_14 (mix_i_src_c014_0_14 0 bpf_c014_0 0) vcvs gain=8.314696123025e-01
SMIXI_c014_0_14 (mix_i_src_c014_0_14 mix_i_c014_0 win_0_14 0) relay vt1=-1m vt2=1m ropen=ropen_mix rclosed=rclosed_mix
EMIXQ_c014_0_14 (mix_q_src_c014_0_14 0 bpf_c014_0 0) vcvs gain=-5.555702330196e-01
SMIXQ_c014_0_14 (mix_q_src_c014_0_14 mix_q_c014_0 win_0_14 0) relay vt1=-1m vt2=1m ropen=ropen_mix rclosed=rclosed_mix
EMIXI_c014_0_15 (mix_i_src_c014_0_15 0 bpf_c014_0 0) vcvs gain=9.807852804032e-01
SMIXI_c014_0_15 (mix_i_src_c014_0_15 mix_i_c014_0 win_0_15 0) relay vt1=-1m vt2=1m ropen=ropen_mix rclosed=rclosed_mix
EMIXQ_c014_0_15 (mix_q_src_c014_0_15 0 bpf_c014_0 0) vcvs gain=-1.950903220161e-01
SMIXQ_c014_0_15 (mix_q_src_c014_0_15 mix_q_c014_0 win_0_15 0) relay vt1=-1m vt2=1m ropen=ropen_mix rclosed=rclosed_mix
RMIXI_c014_0 (mix_i_c014_0 0) resistor r=1G
RMIXQ_c014_0 (mix_q_c014_0 0) resistor r=1G
RINTI_c014_0 (mix_i_c014_0 Icar_c014_0) resistor r=1k
CINTI_c014_0 (Icar_c014_0 0) capacitor c=80p
RINTQ_c014_0 (mix_q_c014_0 Qcar_c014_0) resistor r=1k
CINTQ_c014_0 (Qcar_c014_0 0) capacitor c=80p
save bpf_c014_0 Icar_c014_0 Qcar_c014_0

// bl014, carrier_1: 500000000 Hz coherent I/Q phase-window verification-demod path
CBPF_c014_1 (bl014 n_cbpf_c014_1) capacitor c=1.013211836423e-13
LBPF_c014_1 (n_cbpf_c014_1 bpf_c014_1) inductor l=1.000000000000e-06
RBPF_c014_1 (bpf_c014_1 0) resistor r=1.570796326795e+02
EMIXI_c014_1_00 (mix_i_src_c014_1_00 0 bpf_c014_1 0) vcvs gain=9.807852804032e-01
SMIXI_c014_1_00 (mix_i_src_c014_1_00 mix_i_c014_1 win_1_00 0) relay vt1=-1m vt2=1m ropen=ropen_mix rclosed=rclosed_mix
EMIXQ_c014_1_00 (mix_q_src_c014_1_00 0 bpf_c014_1 0) vcvs gain=1.950903220161e-01
SMIXQ_c014_1_00 (mix_q_src_c014_1_00 mix_q_c014_1 win_1_00 0) relay vt1=-1m vt2=1m ropen=ropen_mix rclosed=rclosed_mix
EMIXI_c014_1_01 (mix_i_src_c014_1_01 0 bpf_c014_1 0) vcvs gain=8.314696123025e-01
SMIXI_c014_1_01 (mix_i_src_c014_1_01 mix_i_c014_1 win_1_01 0) relay vt1=-1m vt2=1m ropen=ropen_mix rclosed=rclosed_mix
EMIXQ_c014_1_01 (mix_q_src_c014_1_01 0 bpf_c014_1 0) vcvs gain=5.555702330196e-01
SMIXQ_c014_1_01 (mix_q_src_c014_1_01 mix_q_c014_1 win_1_01 0) relay vt1=-1m vt2=1m ropen=ropen_mix rclosed=rclosed_mix
EMIXI_c014_1_02 (mix_i_src_c014_1_02 0 bpf_c014_1 0) vcvs gain=5.555702330196e-01
SMIXI_c014_1_02 (mix_i_src_c014_1_02 mix_i_c014_1 win_1_02 0) relay vt1=-1m vt2=1m ropen=ropen_mix rclosed=rclosed_mix
EMIXQ_c014_1_02 (mix_q_src_c014_1_02 0 bpf_c014_1 0) vcvs gain=8.314696123025e-01
SMIXQ_c014_1_02 (mix_q_src_c014_1_02 mix_q_c014_1 win_1_02 0) relay vt1=-1m vt2=1m ropen=ropen_mix rclosed=rclosed_mix
EMIXI_c014_1_03 (mix_i_src_c014_1_03 0 bpf_c014_1 0) vcvs gain=1.950903220161e-01
SMIXI_c014_1_03 (mix_i_src_c014_1_03 mix_i_c014_1 win_1_03 0) relay vt1=-1m vt2=1m ropen=ropen_mix rclosed=rclosed_mix
EMIXQ_c014_1_03 (mix_q_src_c014_1_03 0 bpf_c014_1 0) vcvs gain=9.807852804032e-01
SMIXQ_c014_1_03 (mix_q_src_c014_1_03 mix_q_c014_1 win_1_03 0) relay vt1=-1m vt2=1m ropen=ropen_mix rclosed=rclosed_mix
EMIXI_c014_1_04 (mix_i_src_c014_1_04 0 bpf_c014_1 0) vcvs gain=-1.950903220161e-01
SMIXI_c014_1_04 (mix_i_src_c014_1_04 mix_i_c014_1 win_1_04 0) relay vt1=-1m vt2=1m ropen=ropen_mix rclosed=rclosed_mix
EMIXQ_c014_1_04 (mix_q_src_c014_1_04 0 bpf_c014_1 0) vcvs gain=9.807852804032e-01
SMIXQ_c014_1_04 (mix_q_src_c014_1_04 mix_q_c014_1 win_1_04 0) relay vt1=-1m vt2=1m ropen=ropen_mix rclosed=rclosed_mix
EMIXI_c014_1_05 (mix_i_src_c014_1_05 0 bpf_c014_1 0) vcvs gain=-5.555702330196e-01
SMIXI_c014_1_05 (mix_i_src_c014_1_05 mix_i_c014_1 win_1_05 0) relay vt1=-1m vt2=1m ropen=ropen_mix rclosed=rclosed_mix
EMIXQ_c014_1_05 (mix_q_src_c014_1_05 0 bpf_c014_1 0) vcvs gain=8.314696123025e-01
SMIXQ_c014_1_05 (mix_q_src_c014_1_05 mix_q_c014_1 win_1_05 0) relay vt1=-1m vt2=1m ropen=ropen_mix rclosed=rclosed_mix
EMIXI_c014_1_06 (mix_i_src_c014_1_06 0 bpf_c014_1 0) vcvs gain=-8.314696123025e-01
SMIXI_c014_1_06 (mix_i_src_c014_1_06 mix_i_c014_1 win_1_06 0) relay vt1=-1m vt2=1m ropen=ropen_mix rclosed=rclosed_mix
EMIXQ_c014_1_06 (mix_q_src_c014_1_06 0 bpf_c014_1 0) vcvs gain=5.555702330196e-01
SMIXQ_c014_1_06 (mix_q_src_c014_1_06 mix_q_c014_1 win_1_06 0) relay vt1=-1m vt2=1m ropen=ropen_mix rclosed=rclosed_mix
EMIXI_c014_1_07 (mix_i_src_c014_1_07 0 bpf_c014_1 0) vcvs gain=-9.807852804032e-01
SMIXI_c014_1_07 (mix_i_src_c014_1_07 mix_i_c014_1 win_1_07 0) relay vt1=-1m vt2=1m ropen=ropen_mix rclosed=rclosed_mix
EMIXQ_c014_1_07 (mix_q_src_c014_1_07 0 bpf_c014_1 0) vcvs gain=1.950903220161e-01
SMIXQ_c014_1_07 (mix_q_src_c014_1_07 mix_q_c014_1 win_1_07 0) relay vt1=-1m vt2=1m ropen=ropen_mix rclosed=rclosed_mix
EMIXI_c014_1_08 (mix_i_src_c014_1_08 0 bpf_c014_1 0) vcvs gain=-9.807852804032e-01
SMIXI_c014_1_08 (mix_i_src_c014_1_08 mix_i_c014_1 win_1_08 0) relay vt1=-1m vt2=1m ropen=ropen_mix rclosed=rclosed_mix
EMIXQ_c014_1_08 (mix_q_src_c014_1_08 0 bpf_c014_1 0) vcvs gain=-1.950903220161e-01
SMIXQ_c014_1_08 (mix_q_src_c014_1_08 mix_q_c014_1 win_1_08 0) relay vt1=-1m vt2=1m ropen=ropen_mix rclosed=rclosed_mix
EMIXI_c014_1_09 (mix_i_src_c014_1_09 0 bpf_c014_1 0) vcvs gain=-8.314696123025e-01
SMIXI_c014_1_09 (mix_i_src_c014_1_09 mix_i_c014_1 win_1_09 0) relay vt1=-1m vt2=1m ropen=ropen_mix rclosed=rclosed_mix
EMIXQ_c014_1_09 (mix_q_src_c014_1_09 0 bpf_c014_1 0) vcvs gain=-5.555702330196e-01
SMIXQ_c014_1_09 (mix_q_src_c014_1_09 mix_q_c014_1 win_1_09 0) relay vt1=-1m vt2=1m ropen=ropen_mix rclosed=rclosed_mix
EMIXI_c014_1_10 (mix_i_src_c014_1_10 0 bpf_c014_1 0) vcvs gain=-5.555702330196e-01
SMIXI_c014_1_10 (mix_i_src_c014_1_10 mix_i_c014_1 win_1_10 0) relay vt1=-1m vt2=1m ropen=ropen_mix rclosed=rclosed_mix
EMIXQ_c014_1_10 (mix_q_src_c014_1_10 0 bpf_c014_1 0) vcvs gain=-8.314696123025e-01
SMIXQ_c014_1_10 (mix_q_src_c014_1_10 mix_q_c014_1 win_1_10 0) relay vt1=-1m vt2=1m ropen=ropen_mix rclosed=rclosed_mix
EMIXI_c014_1_11 (mix_i_src_c014_1_11 0 bpf_c014_1 0) vcvs gain=-1.950903220161e-01
SMIXI_c014_1_11 (mix_i_src_c014_1_11 mix_i_c014_1 win_1_11 0) relay vt1=-1m vt2=1m ropen=ropen_mix rclosed=rclosed_mix
EMIXQ_c014_1_11 (mix_q_src_c014_1_11 0 bpf_c014_1 0) vcvs gain=-9.807852804032e-01
SMIXQ_c014_1_11 (mix_q_src_c014_1_11 mix_q_c014_1 win_1_11 0) relay vt1=-1m vt2=1m ropen=ropen_mix rclosed=rclosed_mix
EMIXI_c014_1_12 (mix_i_src_c014_1_12 0 bpf_c014_1 0) vcvs gain=1.950903220161e-01
SMIXI_c014_1_12 (mix_i_src_c014_1_12 mix_i_c014_1 win_1_12 0) relay vt1=-1m vt2=1m ropen=ropen_mix rclosed=rclosed_mix
EMIXQ_c014_1_12 (mix_q_src_c014_1_12 0 bpf_c014_1 0) vcvs gain=-9.807852804032e-01
SMIXQ_c014_1_12 (mix_q_src_c014_1_12 mix_q_c014_1 win_1_12 0) relay vt1=-1m vt2=1m ropen=ropen_mix rclosed=rclosed_mix
EMIXI_c014_1_13 (mix_i_src_c014_1_13 0 bpf_c014_1 0) vcvs gain=5.555702330196e-01
SMIXI_c014_1_13 (mix_i_src_c014_1_13 mix_i_c014_1 win_1_13 0) relay vt1=-1m vt2=1m ropen=ropen_mix rclosed=rclosed_mix
EMIXQ_c014_1_13 (mix_q_src_c014_1_13 0 bpf_c014_1 0) vcvs gain=-8.314696123025e-01
SMIXQ_c014_1_13 (mix_q_src_c014_1_13 mix_q_c014_1 win_1_13 0) relay vt1=-1m vt2=1m ropen=ropen_mix rclosed=rclosed_mix
EMIXI_c014_1_14 (mix_i_src_c014_1_14 0 bpf_c014_1 0) vcvs gain=8.314696123025e-01
SMIXI_c014_1_14 (mix_i_src_c014_1_14 mix_i_c014_1 win_1_14 0) relay vt1=-1m vt2=1m ropen=ropen_mix rclosed=rclosed_mix
EMIXQ_c014_1_14 (mix_q_src_c014_1_14 0 bpf_c014_1 0) vcvs gain=-5.555702330196e-01
SMIXQ_c014_1_14 (mix_q_src_c014_1_14 mix_q_c014_1 win_1_14 0) relay vt1=-1m vt2=1m ropen=ropen_mix rclosed=rclosed_mix
EMIXI_c014_1_15 (mix_i_src_c014_1_15 0 bpf_c014_1 0) vcvs gain=9.807852804032e-01
SMIXI_c014_1_15 (mix_i_src_c014_1_15 mix_i_c014_1 win_1_15 0) relay vt1=-1m vt2=1m ropen=ropen_mix rclosed=rclosed_mix
EMIXQ_c014_1_15 (mix_q_src_c014_1_15 0 bpf_c014_1 0) vcvs gain=-1.950903220161e-01
SMIXQ_c014_1_15 (mix_q_src_c014_1_15 mix_q_c014_1 win_1_15 0) relay vt1=-1m vt2=1m ropen=ropen_mix rclosed=rclosed_mix
RMIXI_c014_1 (mix_i_c014_1 0) resistor r=1G
RMIXQ_c014_1 (mix_q_c014_1 0) resistor r=1G
RINTI_c014_1 (mix_i_c014_1 Icar_c014_1) resistor r=1k
CINTI_c014_1 (Icar_c014_1 0) capacitor c=80p
RINTQ_c014_1 (mix_q_c014_1 Qcar_c014_1) resistor r=1k
CINTQ_c014_1 (Qcar_c014_1 0) capacitor c=80p
save bpf_c014_1 Icar_c014_1 Qcar_c014_1

// bl014, carrier_2: 750000000 Hz coherent I/Q phase-window verification-demod path
CBPF_c014_2 (bl014 n_cbpf_c014_2) capacitor c=4.503163717437e-14
LBPF_c014_2 (n_cbpf_c014_2 bpf_c014_2) inductor l=1.000000000000e-06
RBPF_c014_2 (bpf_c014_2 0) resistor r=2.356194490192e+02
EMIXI_c014_2_00 (mix_i_src_c014_2_00 0 bpf_c014_2 0) vcvs gain=9.807852804032e-01
SMIXI_c014_2_00 (mix_i_src_c014_2_00 mix_i_c014_2 win_2_00 0) relay vt1=-1m vt2=1m ropen=ropen_mix rclosed=rclosed_mix
EMIXQ_c014_2_00 (mix_q_src_c014_2_00 0 bpf_c014_2 0) vcvs gain=1.950903220161e-01
SMIXQ_c014_2_00 (mix_q_src_c014_2_00 mix_q_c014_2 win_2_00 0) relay vt1=-1m vt2=1m ropen=ropen_mix rclosed=rclosed_mix
EMIXI_c014_2_01 (mix_i_src_c014_2_01 0 bpf_c014_2 0) vcvs gain=8.314696123025e-01
SMIXI_c014_2_01 (mix_i_src_c014_2_01 mix_i_c014_2 win_2_01 0) relay vt1=-1m vt2=1m ropen=ropen_mix rclosed=rclosed_mix
EMIXQ_c014_2_01 (mix_q_src_c014_2_01 0 bpf_c014_2 0) vcvs gain=5.555702330196e-01
SMIXQ_c014_2_01 (mix_q_src_c014_2_01 mix_q_c014_2 win_2_01 0) relay vt1=-1m vt2=1m ropen=ropen_mix rclosed=rclosed_mix
EMIXI_c014_2_02 (mix_i_src_c014_2_02 0 bpf_c014_2 0) vcvs gain=5.555702330196e-01
SMIXI_c014_2_02 (mix_i_src_c014_2_02 mix_i_c014_2 win_2_02 0) relay vt1=-1m vt2=1m ropen=ropen_mix rclosed=rclosed_mix
EMIXQ_c014_2_02 (mix_q_src_c014_2_02 0 bpf_c014_2 0) vcvs gain=8.314696123025e-01
SMIXQ_c014_2_02 (mix_q_src_c014_2_02 mix_q_c014_2 win_2_02 0) relay vt1=-1m vt2=1m ropen=ropen_mix rclosed=rclosed_mix
EMIXI_c014_2_03 (mix_i_src_c014_2_03 0 bpf_c014_2 0) vcvs gain=1.950903220161e-01
SMIXI_c014_2_03 (mix_i_src_c014_2_03 mix_i_c014_2 win_2_03 0) relay vt1=-1m vt2=1m ropen=ropen_mix rclosed=rclosed_mix
EMIXQ_c014_2_03 (mix_q_src_c014_2_03 0 bpf_c014_2 0) vcvs gain=9.807852804032e-01
SMIXQ_c014_2_03 (mix_q_src_c014_2_03 mix_q_c014_2 win_2_03 0) relay vt1=-1m vt2=1m ropen=ropen_mix rclosed=rclosed_mix
EMIXI_c014_2_04 (mix_i_src_c014_2_04 0 bpf_c014_2 0) vcvs gain=-1.950903220161e-01
SMIXI_c014_2_04 (mix_i_src_c014_2_04 mix_i_c014_2 win_2_04 0) relay vt1=-1m vt2=1m ropen=ropen_mix rclosed=rclosed_mix
EMIXQ_c014_2_04 (mix_q_src_c014_2_04 0 bpf_c014_2 0) vcvs gain=9.807852804032e-01
SMIXQ_c014_2_04 (mix_q_src_c014_2_04 mix_q_c014_2 win_2_04 0) relay vt1=-1m vt2=1m ropen=ropen_mix rclosed=rclosed_mix
EMIXI_c014_2_05 (mix_i_src_c014_2_05 0 bpf_c014_2 0) vcvs gain=-5.555702330196e-01
SMIXI_c014_2_05 (mix_i_src_c014_2_05 mix_i_c014_2 win_2_05 0) relay vt1=-1m vt2=1m ropen=ropen_mix rclosed=rclosed_mix
EMIXQ_c014_2_05 (mix_q_src_c014_2_05 0 bpf_c014_2 0) vcvs gain=8.314696123025e-01
SMIXQ_c014_2_05 (mix_q_src_c014_2_05 mix_q_c014_2 win_2_05 0) relay vt1=-1m vt2=1m ropen=ropen_mix rclosed=rclosed_mix
EMIXI_c014_2_06 (mix_i_src_c014_2_06 0 bpf_c014_2 0) vcvs gain=-8.314696123025e-01
SMIXI_c014_2_06 (mix_i_src_c014_2_06 mix_i_c014_2 win_2_06 0) relay vt1=-1m vt2=1m ropen=ropen_mix rclosed=rclosed_mix
EMIXQ_c014_2_06 (mix_q_src_c014_2_06 0 bpf_c014_2 0) vcvs gain=5.555702330196e-01
SMIXQ_c014_2_06 (mix_q_src_c014_2_06 mix_q_c014_2 win_2_06 0) relay vt1=-1m vt2=1m ropen=ropen_mix rclosed=rclosed_mix
EMIXI_c014_2_07 (mix_i_src_c014_2_07 0 bpf_c014_2 0) vcvs gain=-9.807852804032e-01
SMIXI_c014_2_07 (mix_i_src_c014_2_07 mix_i_c014_2 win_2_07 0) relay vt1=-1m vt2=1m ropen=ropen_mix rclosed=rclosed_mix
EMIXQ_c014_2_07 (mix_q_src_c014_2_07 0 bpf_c014_2 0) vcvs gain=1.950903220161e-01
SMIXQ_c014_2_07 (mix_q_src_c014_2_07 mix_q_c014_2 win_2_07 0) relay vt1=-1m vt2=1m ropen=ropen_mix rclosed=rclosed_mix
EMIXI_c014_2_08 (mix_i_src_c014_2_08 0 bpf_c014_2 0) vcvs gain=-9.807852804032e-01
SMIXI_c014_2_08 (mix_i_src_c014_2_08 mix_i_c014_2 win_2_08 0) relay vt1=-1m vt2=1m ropen=ropen_mix rclosed=rclosed_mix
EMIXQ_c014_2_08 (mix_q_src_c014_2_08 0 bpf_c014_2 0) vcvs gain=-1.950903220161e-01
SMIXQ_c014_2_08 (mix_q_src_c014_2_08 mix_q_c014_2 win_2_08 0) relay vt1=-1m vt2=1m ropen=ropen_mix rclosed=rclosed_mix
EMIXI_c014_2_09 (mix_i_src_c014_2_09 0 bpf_c014_2 0) vcvs gain=-8.314696123025e-01
SMIXI_c014_2_09 (mix_i_src_c014_2_09 mix_i_c014_2 win_2_09 0) relay vt1=-1m vt2=1m ropen=ropen_mix rclosed=rclosed_mix
EMIXQ_c014_2_09 (mix_q_src_c014_2_09 0 bpf_c014_2 0) vcvs gain=-5.555702330196e-01
SMIXQ_c014_2_09 (mix_q_src_c014_2_09 mix_q_c014_2 win_2_09 0) relay vt1=-1m vt2=1m ropen=ropen_mix rclosed=rclosed_mix
EMIXI_c014_2_10 (mix_i_src_c014_2_10 0 bpf_c014_2 0) vcvs gain=-5.555702330196e-01
SMIXI_c014_2_10 (mix_i_src_c014_2_10 mix_i_c014_2 win_2_10 0) relay vt1=-1m vt2=1m ropen=ropen_mix rclosed=rclosed_mix
EMIXQ_c014_2_10 (mix_q_src_c014_2_10 0 bpf_c014_2 0) vcvs gain=-8.314696123025e-01
SMIXQ_c014_2_10 (mix_q_src_c014_2_10 mix_q_c014_2 win_2_10 0) relay vt1=-1m vt2=1m ropen=ropen_mix rclosed=rclosed_mix
EMIXI_c014_2_11 (mix_i_src_c014_2_11 0 bpf_c014_2 0) vcvs gain=-1.950903220161e-01
SMIXI_c014_2_11 (mix_i_src_c014_2_11 mix_i_c014_2 win_2_11 0) relay vt1=-1m vt2=1m ropen=ropen_mix rclosed=rclosed_mix
EMIXQ_c014_2_11 (mix_q_src_c014_2_11 0 bpf_c014_2 0) vcvs gain=-9.807852804032e-01
SMIXQ_c014_2_11 (mix_q_src_c014_2_11 mix_q_c014_2 win_2_11 0) relay vt1=-1m vt2=1m ropen=ropen_mix rclosed=rclosed_mix
EMIXI_c014_2_12 (mix_i_src_c014_2_12 0 bpf_c014_2 0) vcvs gain=1.950903220161e-01
SMIXI_c014_2_12 (mix_i_src_c014_2_12 mix_i_c014_2 win_2_12 0) relay vt1=-1m vt2=1m ropen=ropen_mix rclosed=rclosed_mix
EMIXQ_c014_2_12 (mix_q_src_c014_2_12 0 bpf_c014_2 0) vcvs gain=-9.807852804032e-01
SMIXQ_c014_2_12 (mix_q_src_c014_2_12 mix_q_c014_2 win_2_12 0) relay vt1=-1m vt2=1m ropen=ropen_mix rclosed=rclosed_mix
EMIXI_c014_2_13 (mix_i_src_c014_2_13 0 bpf_c014_2 0) vcvs gain=5.555702330196e-01
SMIXI_c014_2_13 (mix_i_src_c014_2_13 mix_i_c014_2 win_2_13 0) relay vt1=-1m vt2=1m ropen=ropen_mix rclosed=rclosed_mix
EMIXQ_c014_2_13 (mix_q_src_c014_2_13 0 bpf_c014_2 0) vcvs gain=-8.314696123025e-01
SMIXQ_c014_2_13 (mix_q_src_c014_2_13 mix_q_c014_2 win_2_13 0) relay vt1=-1m vt2=1m ropen=ropen_mix rclosed=rclosed_mix
EMIXI_c014_2_14 (mix_i_src_c014_2_14 0 bpf_c014_2 0) vcvs gain=8.314696123025e-01
SMIXI_c014_2_14 (mix_i_src_c014_2_14 mix_i_c014_2 win_2_14 0) relay vt1=-1m vt2=1m ropen=ropen_mix rclosed=rclosed_mix
EMIXQ_c014_2_14 (mix_q_src_c014_2_14 0 bpf_c014_2 0) vcvs gain=-5.555702330196e-01
SMIXQ_c014_2_14 (mix_q_src_c014_2_14 mix_q_c014_2 win_2_14 0) relay vt1=-1m vt2=1m ropen=ropen_mix rclosed=rclosed_mix
EMIXI_c014_2_15 (mix_i_src_c014_2_15 0 bpf_c014_2 0) vcvs gain=9.807852804032e-01
SMIXI_c014_2_15 (mix_i_src_c014_2_15 mix_i_c014_2 win_2_15 0) relay vt1=-1m vt2=1m ropen=ropen_mix rclosed=rclosed_mix
EMIXQ_c014_2_15 (mix_q_src_c014_2_15 0 bpf_c014_2 0) vcvs gain=-1.950903220161e-01
SMIXQ_c014_2_15 (mix_q_src_c014_2_15 mix_q_c014_2 win_2_15 0) relay vt1=-1m vt2=1m ropen=ropen_mix rclosed=rclosed_mix
RMIXI_c014_2 (mix_i_c014_2 0) resistor r=1G
RMIXQ_c014_2 (mix_q_c014_2 0) resistor r=1G
RINTI_c014_2 (mix_i_c014_2 Icar_c014_2) resistor r=1k
CINTI_c014_2 (Icar_c014_2 0) capacitor c=80p
RINTQ_c014_2 (mix_q_c014_2 Qcar_c014_2) resistor r=1k
CINTQ_c014_2 (Qcar_c014_2 0) capacitor c=80p
save bpf_c014_2 Icar_c014_2 Qcar_c014_2

// bl014, carrier_3: 1000000000 Hz coherent I/Q phase-window verification-demod path
CBPF_c014_3 (bl014 n_cbpf_c014_3) capacitor c=2.533029591058e-14
LBPF_c014_3 (n_cbpf_c014_3 bpf_c014_3) inductor l=1.000000000000e-06
RBPF_c014_3 (bpf_c014_3 0) resistor r=3.141592653590e+02
EMIXI_c014_3_00 (mix_i_src_c014_3_00 0 bpf_c014_3 0) vcvs gain=9.807852804032e-01
SMIXI_c014_3_00 (mix_i_src_c014_3_00 mix_i_c014_3 win_3_00 0) relay vt1=-1m vt2=1m ropen=ropen_mix rclosed=rclosed_mix
EMIXQ_c014_3_00 (mix_q_src_c014_3_00 0 bpf_c014_3 0) vcvs gain=1.950903220161e-01
SMIXQ_c014_3_00 (mix_q_src_c014_3_00 mix_q_c014_3 win_3_00 0) relay vt1=-1m vt2=1m ropen=ropen_mix rclosed=rclosed_mix
EMIXI_c014_3_01 (mix_i_src_c014_3_01 0 bpf_c014_3 0) vcvs gain=8.314696123025e-01
SMIXI_c014_3_01 (mix_i_src_c014_3_01 mix_i_c014_3 win_3_01 0) relay vt1=-1m vt2=1m ropen=ropen_mix rclosed=rclosed_mix
EMIXQ_c014_3_01 (mix_q_src_c014_3_01 0 bpf_c014_3 0) vcvs gain=5.555702330196e-01
SMIXQ_c014_3_01 (mix_q_src_c014_3_01 mix_q_c014_3 win_3_01 0) relay vt1=-1m vt2=1m ropen=ropen_mix rclosed=rclosed_mix
EMIXI_c014_3_02 (mix_i_src_c014_3_02 0 bpf_c014_3 0) vcvs gain=5.555702330196e-01
SMIXI_c014_3_02 (mix_i_src_c014_3_02 mix_i_c014_3 win_3_02 0) relay vt1=-1m vt2=1m ropen=ropen_mix rclosed=rclosed_mix
EMIXQ_c014_3_02 (mix_q_src_c014_3_02 0 bpf_c014_3 0) vcvs gain=8.314696123025e-01
SMIXQ_c014_3_02 (mix_q_src_c014_3_02 mix_q_c014_3 win_3_02 0) relay vt1=-1m vt2=1m ropen=ropen_mix rclosed=rclosed_mix
EMIXI_c014_3_03 (mix_i_src_c014_3_03 0 bpf_c014_3 0) vcvs gain=1.950903220161e-01
SMIXI_c014_3_03 (mix_i_src_c014_3_03 mix_i_c014_3 win_3_03 0) relay vt1=-1m vt2=1m ropen=ropen_mix rclosed=rclosed_mix
EMIXQ_c014_3_03 (mix_q_src_c014_3_03 0 bpf_c014_3 0) vcvs gain=9.807852804032e-01
SMIXQ_c014_3_03 (mix_q_src_c014_3_03 mix_q_c014_3 win_3_03 0) relay vt1=-1m vt2=1m ropen=ropen_mix rclosed=rclosed_mix
EMIXI_c014_3_04 (mix_i_src_c014_3_04 0 bpf_c014_3 0) vcvs gain=-1.950903220161e-01
SMIXI_c014_3_04 (mix_i_src_c014_3_04 mix_i_c014_3 win_3_04 0) relay vt1=-1m vt2=1m ropen=ropen_mix rclosed=rclosed_mix
EMIXQ_c014_3_04 (mix_q_src_c014_3_04 0 bpf_c014_3 0) vcvs gain=9.807852804032e-01
SMIXQ_c014_3_04 (mix_q_src_c014_3_04 mix_q_c014_3 win_3_04 0) relay vt1=-1m vt2=1m ropen=ropen_mix rclosed=rclosed_mix
EMIXI_c014_3_05 (mix_i_src_c014_3_05 0 bpf_c014_3 0) vcvs gain=-5.555702330196e-01
SMIXI_c014_3_05 (mix_i_src_c014_3_05 mix_i_c014_3 win_3_05 0) relay vt1=-1m vt2=1m ropen=ropen_mix rclosed=rclosed_mix
EMIXQ_c014_3_05 (mix_q_src_c014_3_05 0 bpf_c014_3 0) vcvs gain=8.314696123025e-01
SMIXQ_c014_3_05 (mix_q_src_c014_3_05 mix_q_c014_3 win_3_05 0) relay vt1=-1m vt2=1m ropen=ropen_mix rclosed=rclosed_mix
EMIXI_c014_3_06 (mix_i_src_c014_3_06 0 bpf_c014_3 0) vcvs gain=-8.314696123025e-01
SMIXI_c014_3_06 (mix_i_src_c014_3_06 mix_i_c014_3 win_3_06 0) relay vt1=-1m vt2=1m ropen=ropen_mix rclosed=rclosed_mix
EMIXQ_c014_3_06 (mix_q_src_c014_3_06 0 bpf_c014_3 0) vcvs gain=5.555702330196e-01
SMIXQ_c014_3_06 (mix_q_src_c014_3_06 mix_q_c014_3 win_3_06 0) relay vt1=-1m vt2=1m ropen=ropen_mix rclosed=rclosed_mix
EMIXI_c014_3_07 (mix_i_src_c014_3_07 0 bpf_c014_3 0) vcvs gain=-9.807852804032e-01
SMIXI_c014_3_07 (mix_i_src_c014_3_07 mix_i_c014_3 win_3_07 0) relay vt1=-1m vt2=1m ropen=ropen_mix rclosed=rclosed_mix
EMIXQ_c014_3_07 (mix_q_src_c014_3_07 0 bpf_c014_3 0) vcvs gain=1.950903220161e-01
SMIXQ_c014_3_07 (mix_q_src_c014_3_07 mix_q_c014_3 win_3_07 0) relay vt1=-1m vt2=1m ropen=ropen_mix rclosed=rclosed_mix
EMIXI_c014_3_08 (mix_i_src_c014_3_08 0 bpf_c014_3 0) vcvs gain=-9.807852804032e-01
SMIXI_c014_3_08 (mix_i_src_c014_3_08 mix_i_c014_3 win_3_08 0) relay vt1=-1m vt2=1m ropen=ropen_mix rclosed=rclosed_mix
EMIXQ_c014_3_08 (mix_q_src_c014_3_08 0 bpf_c014_3 0) vcvs gain=-1.950903220161e-01
SMIXQ_c014_3_08 (mix_q_src_c014_3_08 mix_q_c014_3 win_3_08 0) relay vt1=-1m vt2=1m ropen=ropen_mix rclosed=rclosed_mix
EMIXI_c014_3_09 (mix_i_src_c014_3_09 0 bpf_c014_3 0) vcvs gain=-8.314696123025e-01
SMIXI_c014_3_09 (mix_i_src_c014_3_09 mix_i_c014_3 win_3_09 0) relay vt1=-1m vt2=1m ropen=ropen_mix rclosed=rclosed_mix
EMIXQ_c014_3_09 (mix_q_src_c014_3_09 0 bpf_c014_3 0) vcvs gain=-5.555702330196e-01
SMIXQ_c014_3_09 (mix_q_src_c014_3_09 mix_q_c014_3 win_3_09 0) relay vt1=-1m vt2=1m ropen=ropen_mix rclosed=rclosed_mix
EMIXI_c014_3_10 (mix_i_src_c014_3_10 0 bpf_c014_3 0) vcvs gain=-5.555702330196e-01
SMIXI_c014_3_10 (mix_i_src_c014_3_10 mix_i_c014_3 win_3_10 0) relay vt1=-1m vt2=1m ropen=ropen_mix rclosed=rclosed_mix
EMIXQ_c014_3_10 (mix_q_src_c014_3_10 0 bpf_c014_3 0) vcvs gain=-8.314696123025e-01
SMIXQ_c014_3_10 (mix_q_src_c014_3_10 mix_q_c014_3 win_3_10 0) relay vt1=-1m vt2=1m ropen=ropen_mix rclosed=rclosed_mix
EMIXI_c014_3_11 (mix_i_src_c014_3_11 0 bpf_c014_3 0) vcvs gain=-1.950903220161e-01
SMIXI_c014_3_11 (mix_i_src_c014_3_11 mix_i_c014_3 win_3_11 0) relay vt1=-1m vt2=1m ropen=ropen_mix rclosed=rclosed_mix
EMIXQ_c014_3_11 (mix_q_src_c014_3_11 0 bpf_c014_3 0) vcvs gain=-9.807852804032e-01
SMIXQ_c014_3_11 (mix_q_src_c014_3_11 mix_q_c014_3 win_3_11 0) relay vt1=-1m vt2=1m ropen=ropen_mix rclosed=rclosed_mix
EMIXI_c014_3_12 (mix_i_src_c014_3_12 0 bpf_c014_3 0) vcvs gain=1.950903220161e-01
SMIXI_c014_3_12 (mix_i_src_c014_3_12 mix_i_c014_3 win_3_12 0) relay vt1=-1m vt2=1m ropen=ropen_mix rclosed=rclosed_mix
EMIXQ_c014_3_12 (mix_q_src_c014_3_12 0 bpf_c014_3 0) vcvs gain=-9.807852804032e-01
SMIXQ_c014_3_12 (mix_q_src_c014_3_12 mix_q_c014_3 win_3_12 0) relay vt1=-1m vt2=1m ropen=ropen_mix rclosed=rclosed_mix
EMIXI_c014_3_13 (mix_i_src_c014_3_13 0 bpf_c014_3 0) vcvs gain=5.555702330196e-01
SMIXI_c014_3_13 (mix_i_src_c014_3_13 mix_i_c014_3 win_3_13 0) relay vt1=-1m vt2=1m ropen=ropen_mix rclosed=rclosed_mix
EMIXQ_c014_3_13 (mix_q_src_c014_3_13 0 bpf_c014_3 0) vcvs gain=-8.314696123025e-01
SMIXQ_c014_3_13 (mix_q_src_c014_3_13 mix_q_c014_3 win_3_13 0) relay vt1=-1m vt2=1m ropen=ropen_mix rclosed=rclosed_mix
EMIXI_c014_3_14 (mix_i_src_c014_3_14 0 bpf_c014_3 0) vcvs gain=8.314696123025e-01
SMIXI_c014_3_14 (mix_i_src_c014_3_14 mix_i_c014_3 win_3_14 0) relay vt1=-1m vt2=1m ropen=ropen_mix rclosed=rclosed_mix
EMIXQ_c014_3_14 (mix_q_src_c014_3_14 0 bpf_c014_3 0) vcvs gain=-5.555702330196e-01
SMIXQ_c014_3_14 (mix_q_src_c014_3_14 mix_q_c014_3 win_3_14 0) relay vt1=-1m vt2=1m ropen=ropen_mix rclosed=rclosed_mix
EMIXI_c014_3_15 (mix_i_src_c014_3_15 0 bpf_c014_3 0) vcvs gain=9.807852804032e-01
SMIXI_c014_3_15 (mix_i_src_c014_3_15 mix_i_c014_3 win_3_15 0) relay vt1=-1m vt2=1m ropen=ropen_mix rclosed=rclosed_mix
EMIXQ_c014_3_15 (mix_q_src_c014_3_15 0 bpf_c014_3 0) vcvs gain=-1.950903220161e-01
SMIXQ_c014_3_15 (mix_q_src_c014_3_15 mix_q_c014_3 win_3_15 0) relay vt1=-1m vt2=1m ropen=ropen_mix rclosed=rclosed_mix
RMIXI_c014_3 (mix_i_c014_3 0) resistor r=1G
RMIXQ_c014_3 (mix_q_c014_3 0) resistor r=1G
RINTI_c014_3 (mix_i_c014_3 Icar_c014_3) resistor r=1k
CINTI_c014_3 (Icar_c014_3 0) capacitor c=80p
RINTQ_c014_3 (mix_q_c014_3 Qcar_c014_3) resistor r=1k
CINTQ_c014_3 (Qcar_c014_3 0) capacitor c=80p
save bpf_c014_3 Icar_c014_3 Qcar_c014_3

// bl015, carrier_0: 250000000 Hz coherent I/Q phase-window verification-demod path
CBPF_c015_0 (bl015 n_cbpf_c015_0) capacitor c=4.052847345694e-13
LBPF_c015_0 (n_cbpf_c015_0 bpf_c015_0) inductor l=1.000000000000e-06
RBPF_c015_0 (bpf_c015_0 0) resistor r=7.853981633974e+01
EMIXI_c015_0_00 (mix_i_src_c015_0_00 0 bpf_c015_0 0) vcvs gain=9.807852804032e-01
SMIXI_c015_0_00 (mix_i_src_c015_0_00 mix_i_c015_0 win_0_00 0) relay vt1=-1m vt2=1m ropen=ropen_mix rclosed=rclosed_mix
EMIXQ_c015_0_00 (mix_q_src_c015_0_00 0 bpf_c015_0 0) vcvs gain=1.950903220161e-01
SMIXQ_c015_0_00 (mix_q_src_c015_0_00 mix_q_c015_0 win_0_00 0) relay vt1=-1m vt2=1m ropen=ropen_mix rclosed=rclosed_mix
EMIXI_c015_0_01 (mix_i_src_c015_0_01 0 bpf_c015_0 0) vcvs gain=8.314696123025e-01
SMIXI_c015_0_01 (mix_i_src_c015_0_01 mix_i_c015_0 win_0_01 0) relay vt1=-1m vt2=1m ropen=ropen_mix rclosed=rclosed_mix
EMIXQ_c015_0_01 (mix_q_src_c015_0_01 0 bpf_c015_0 0) vcvs gain=5.555702330196e-01
SMIXQ_c015_0_01 (mix_q_src_c015_0_01 mix_q_c015_0 win_0_01 0) relay vt1=-1m vt2=1m ropen=ropen_mix rclosed=rclosed_mix
EMIXI_c015_0_02 (mix_i_src_c015_0_02 0 bpf_c015_0 0) vcvs gain=5.555702330196e-01
SMIXI_c015_0_02 (mix_i_src_c015_0_02 mix_i_c015_0 win_0_02 0) relay vt1=-1m vt2=1m ropen=ropen_mix rclosed=rclosed_mix
EMIXQ_c015_0_02 (mix_q_src_c015_0_02 0 bpf_c015_0 0) vcvs gain=8.314696123025e-01
SMIXQ_c015_0_02 (mix_q_src_c015_0_02 mix_q_c015_0 win_0_02 0) relay vt1=-1m vt2=1m ropen=ropen_mix rclosed=rclosed_mix
EMIXI_c015_0_03 (mix_i_src_c015_0_03 0 bpf_c015_0 0) vcvs gain=1.950903220161e-01
SMIXI_c015_0_03 (mix_i_src_c015_0_03 mix_i_c015_0 win_0_03 0) relay vt1=-1m vt2=1m ropen=ropen_mix rclosed=rclosed_mix
EMIXQ_c015_0_03 (mix_q_src_c015_0_03 0 bpf_c015_0 0) vcvs gain=9.807852804032e-01
SMIXQ_c015_0_03 (mix_q_src_c015_0_03 mix_q_c015_0 win_0_03 0) relay vt1=-1m vt2=1m ropen=ropen_mix rclosed=rclosed_mix
EMIXI_c015_0_04 (mix_i_src_c015_0_04 0 bpf_c015_0 0) vcvs gain=-1.950903220161e-01
SMIXI_c015_0_04 (mix_i_src_c015_0_04 mix_i_c015_0 win_0_04 0) relay vt1=-1m vt2=1m ropen=ropen_mix rclosed=rclosed_mix
EMIXQ_c015_0_04 (mix_q_src_c015_0_04 0 bpf_c015_0 0) vcvs gain=9.807852804032e-01
SMIXQ_c015_0_04 (mix_q_src_c015_0_04 mix_q_c015_0 win_0_04 0) relay vt1=-1m vt2=1m ropen=ropen_mix rclosed=rclosed_mix
EMIXI_c015_0_05 (mix_i_src_c015_0_05 0 bpf_c015_0 0) vcvs gain=-5.555702330196e-01
SMIXI_c015_0_05 (mix_i_src_c015_0_05 mix_i_c015_0 win_0_05 0) relay vt1=-1m vt2=1m ropen=ropen_mix rclosed=rclosed_mix
EMIXQ_c015_0_05 (mix_q_src_c015_0_05 0 bpf_c015_0 0) vcvs gain=8.314696123025e-01
SMIXQ_c015_0_05 (mix_q_src_c015_0_05 mix_q_c015_0 win_0_05 0) relay vt1=-1m vt2=1m ropen=ropen_mix rclosed=rclosed_mix
EMIXI_c015_0_06 (mix_i_src_c015_0_06 0 bpf_c015_0 0) vcvs gain=-8.314696123025e-01
SMIXI_c015_0_06 (mix_i_src_c015_0_06 mix_i_c015_0 win_0_06 0) relay vt1=-1m vt2=1m ropen=ropen_mix rclosed=rclosed_mix
EMIXQ_c015_0_06 (mix_q_src_c015_0_06 0 bpf_c015_0 0) vcvs gain=5.555702330196e-01
SMIXQ_c015_0_06 (mix_q_src_c015_0_06 mix_q_c015_0 win_0_06 0) relay vt1=-1m vt2=1m ropen=ropen_mix rclosed=rclosed_mix
EMIXI_c015_0_07 (mix_i_src_c015_0_07 0 bpf_c015_0 0) vcvs gain=-9.807852804032e-01
SMIXI_c015_0_07 (mix_i_src_c015_0_07 mix_i_c015_0 win_0_07 0) relay vt1=-1m vt2=1m ropen=ropen_mix rclosed=rclosed_mix
EMIXQ_c015_0_07 (mix_q_src_c015_0_07 0 bpf_c015_0 0) vcvs gain=1.950903220161e-01
SMIXQ_c015_0_07 (mix_q_src_c015_0_07 mix_q_c015_0 win_0_07 0) relay vt1=-1m vt2=1m ropen=ropen_mix rclosed=rclosed_mix
EMIXI_c015_0_08 (mix_i_src_c015_0_08 0 bpf_c015_0 0) vcvs gain=-9.807852804032e-01
SMIXI_c015_0_08 (mix_i_src_c015_0_08 mix_i_c015_0 win_0_08 0) relay vt1=-1m vt2=1m ropen=ropen_mix rclosed=rclosed_mix
EMIXQ_c015_0_08 (mix_q_src_c015_0_08 0 bpf_c015_0 0) vcvs gain=-1.950903220161e-01
SMIXQ_c015_0_08 (mix_q_src_c015_0_08 mix_q_c015_0 win_0_08 0) relay vt1=-1m vt2=1m ropen=ropen_mix rclosed=rclosed_mix
EMIXI_c015_0_09 (mix_i_src_c015_0_09 0 bpf_c015_0 0) vcvs gain=-8.314696123025e-01
SMIXI_c015_0_09 (mix_i_src_c015_0_09 mix_i_c015_0 win_0_09 0) relay vt1=-1m vt2=1m ropen=ropen_mix rclosed=rclosed_mix
EMIXQ_c015_0_09 (mix_q_src_c015_0_09 0 bpf_c015_0 0) vcvs gain=-5.555702330196e-01
SMIXQ_c015_0_09 (mix_q_src_c015_0_09 mix_q_c015_0 win_0_09 0) relay vt1=-1m vt2=1m ropen=ropen_mix rclosed=rclosed_mix
EMIXI_c015_0_10 (mix_i_src_c015_0_10 0 bpf_c015_0 0) vcvs gain=-5.555702330196e-01
SMIXI_c015_0_10 (mix_i_src_c015_0_10 mix_i_c015_0 win_0_10 0) relay vt1=-1m vt2=1m ropen=ropen_mix rclosed=rclosed_mix
EMIXQ_c015_0_10 (mix_q_src_c015_0_10 0 bpf_c015_0 0) vcvs gain=-8.314696123025e-01
SMIXQ_c015_0_10 (mix_q_src_c015_0_10 mix_q_c015_0 win_0_10 0) relay vt1=-1m vt2=1m ropen=ropen_mix rclosed=rclosed_mix
EMIXI_c015_0_11 (mix_i_src_c015_0_11 0 bpf_c015_0 0) vcvs gain=-1.950903220161e-01
SMIXI_c015_0_11 (mix_i_src_c015_0_11 mix_i_c015_0 win_0_11 0) relay vt1=-1m vt2=1m ropen=ropen_mix rclosed=rclosed_mix
EMIXQ_c015_0_11 (mix_q_src_c015_0_11 0 bpf_c015_0 0) vcvs gain=-9.807852804032e-01
SMIXQ_c015_0_11 (mix_q_src_c015_0_11 mix_q_c015_0 win_0_11 0) relay vt1=-1m vt2=1m ropen=ropen_mix rclosed=rclosed_mix
EMIXI_c015_0_12 (mix_i_src_c015_0_12 0 bpf_c015_0 0) vcvs gain=1.950903220161e-01
SMIXI_c015_0_12 (mix_i_src_c015_0_12 mix_i_c015_0 win_0_12 0) relay vt1=-1m vt2=1m ropen=ropen_mix rclosed=rclosed_mix
EMIXQ_c015_0_12 (mix_q_src_c015_0_12 0 bpf_c015_0 0) vcvs gain=-9.807852804032e-01
SMIXQ_c015_0_12 (mix_q_src_c015_0_12 mix_q_c015_0 win_0_12 0) relay vt1=-1m vt2=1m ropen=ropen_mix rclosed=rclosed_mix
EMIXI_c015_0_13 (mix_i_src_c015_0_13 0 bpf_c015_0 0) vcvs gain=5.555702330196e-01
SMIXI_c015_0_13 (mix_i_src_c015_0_13 mix_i_c015_0 win_0_13 0) relay vt1=-1m vt2=1m ropen=ropen_mix rclosed=rclosed_mix
EMIXQ_c015_0_13 (mix_q_src_c015_0_13 0 bpf_c015_0 0) vcvs gain=-8.314696123025e-01
SMIXQ_c015_0_13 (mix_q_src_c015_0_13 mix_q_c015_0 win_0_13 0) relay vt1=-1m vt2=1m ropen=ropen_mix rclosed=rclosed_mix
EMIXI_c015_0_14 (mix_i_src_c015_0_14 0 bpf_c015_0 0) vcvs gain=8.314696123025e-01
SMIXI_c015_0_14 (mix_i_src_c015_0_14 mix_i_c015_0 win_0_14 0) relay vt1=-1m vt2=1m ropen=ropen_mix rclosed=rclosed_mix
EMIXQ_c015_0_14 (mix_q_src_c015_0_14 0 bpf_c015_0 0) vcvs gain=-5.555702330196e-01
SMIXQ_c015_0_14 (mix_q_src_c015_0_14 mix_q_c015_0 win_0_14 0) relay vt1=-1m vt2=1m ropen=ropen_mix rclosed=rclosed_mix
EMIXI_c015_0_15 (mix_i_src_c015_0_15 0 bpf_c015_0 0) vcvs gain=9.807852804032e-01
SMIXI_c015_0_15 (mix_i_src_c015_0_15 mix_i_c015_0 win_0_15 0) relay vt1=-1m vt2=1m ropen=ropen_mix rclosed=rclosed_mix
EMIXQ_c015_0_15 (mix_q_src_c015_0_15 0 bpf_c015_0 0) vcvs gain=-1.950903220161e-01
SMIXQ_c015_0_15 (mix_q_src_c015_0_15 mix_q_c015_0 win_0_15 0) relay vt1=-1m vt2=1m ropen=ropen_mix rclosed=rclosed_mix
RMIXI_c015_0 (mix_i_c015_0 0) resistor r=1G
RMIXQ_c015_0 (mix_q_c015_0 0) resistor r=1G
RINTI_c015_0 (mix_i_c015_0 Icar_c015_0) resistor r=1k
CINTI_c015_0 (Icar_c015_0 0) capacitor c=80p
RINTQ_c015_0 (mix_q_c015_0 Qcar_c015_0) resistor r=1k
CINTQ_c015_0 (Qcar_c015_0 0) capacitor c=80p
save bpf_c015_0 Icar_c015_0 Qcar_c015_0

// bl015, carrier_1: 500000000 Hz coherent I/Q phase-window verification-demod path
CBPF_c015_1 (bl015 n_cbpf_c015_1) capacitor c=1.013211836423e-13
LBPF_c015_1 (n_cbpf_c015_1 bpf_c015_1) inductor l=1.000000000000e-06
RBPF_c015_1 (bpf_c015_1 0) resistor r=1.570796326795e+02
EMIXI_c015_1_00 (mix_i_src_c015_1_00 0 bpf_c015_1 0) vcvs gain=9.807852804032e-01
SMIXI_c015_1_00 (mix_i_src_c015_1_00 mix_i_c015_1 win_1_00 0) relay vt1=-1m vt2=1m ropen=ropen_mix rclosed=rclosed_mix
EMIXQ_c015_1_00 (mix_q_src_c015_1_00 0 bpf_c015_1 0) vcvs gain=1.950903220161e-01
SMIXQ_c015_1_00 (mix_q_src_c015_1_00 mix_q_c015_1 win_1_00 0) relay vt1=-1m vt2=1m ropen=ropen_mix rclosed=rclosed_mix
EMIXI_c015_1_01 (mix_i_src_c015_1_01 0 bpf_c015_1 0) vcvs gain=8.314696123025e-01
SMIXI_c015_1_01 (mix_i_src_c015_1_01 mix_i_c015_1 win_1_01 0) relay vt1=-1m vt2=1m ropen=ropen_mix rclosed=rclosed_mix
EMIXQ_c015_1_01 (mix_q_src_c015_1_01 0 bpf_c015_1 0) vcvs gain=5.555702330196e-01
SMIXQ_c015_1_01 (mix_q_src_c015_1_01 mix_q_c015_1 win_1_01 0) relay vt1=-1m vt2=1m ropen=ropen_mix rclosed=rclosed_mix
EMIXI_c015_1_02 (mix_i_src_c015_1_02 0 bpf_c015_1 0) vcvs gain=5.555702330196e-01
SMIXI_c015_1_02 (mix_i_src_c015_1_02 mix_i_c015_1 win_1_02 0) relay vt1=-1m vt2=1m ropen=ropen_mix rclosed=rclosed_mix
EMIXQ_c015_1_02 (mix_q_src_c015_1_02 0 bpf_c015_1 0) vcvs gain=8.314696123025e-01
SMIXQ_c015_1_02 (mix_q_src_c015_1_02 mix_q_c015_1 win_1_02 0) relay vt1=-1m vt2=1m ropen=ropen_mix rclosed=rclosed_mix
EMIXI_c015_1_03 (mix_i_src_c015_1_03 0 bpf_c015_1 0) vcvs gain=1.950903220161e-01
SMIXI_c015_1_03 (mix_i_src_c015_1_03 mix_i_c015_1 win_1_03 0) relay vt1=-1m vt2=1m ropen=ropen_mix rclosed=rclosed_mix
EMIXQ_c015_1_03 (mix_q_src_c015_1_03 0 bpf_c015_1 0) vcvs gain=9.807852804032e-01
SMIXQ_c015_1_03 (mix_q_src_c015_1_03 mix_q_c015_1 win_1_03 0) relay vt1=-1m vt2=1m ropen=ropen_mix rclosed=rclosed_mix
EMIXI_c015_1_04 (mix_i_src_c015_1_04 0 bpf_c015_1 0) vcvs gain=-1.950903220161e-01
SMIXI_c015_1_04 (mix_i_src_c015_1_04 mix_i_c015_1 win_1_04 0) relay vt1=-1m vt2=1m ropen=ropen_mix rclosed=rclosed_mix
EMIXQ_c015_1_04 (mix_q_src_c015_1_04 0 bpf_c015_1 0) vcvs gain=9.807852804032e-01
SMIXQ_c015_1_04 (mix_q_src_c015_1_04 mix_q_c015_1 win_1_04 0) relay vt1=-1m vt2=1m ropen=ropen_mix rclosed=rclosed_mix
EMIXI_c015_1_05 (mix_i_src_c015_1_05 0 bpf_c015_1 0) vcvs gain=-5.555702330196e-01
SMIXI_c015_1_05 (mix_i_src_c015_1_05 mix_i_c015_1 win_1_05 0) relay vt1=-1m vt2=1m ropen=ropen_mix rclosed=rclosed_mix
EMIXQ_c015_1_05 (mix_q_src_c015_1_05 0 bpf_c015_1 0) vcvs gain=8.314696123025e-01
SMIXQ_c015_1_05 (mix_q_src_c015_1_05 mix_q_c015_1 win_1_05 0) relay vt1=-1m vt2=1m ropen=ropen_mix rclosed=rclosed_mix
EMIXI_c015_1_06 (mix_i_src_c015_1_06 0 bpf_c015_1 0) vcvs gain=-8.314696123025e-01
SMIXI_c015_1_06 (mix_i_src_c015_1_06 mix_i_c015_1 win_1_06 0) relay vt1=-1m vt2=1m ropen=ropen_mix rclosed=rclosed_mix
EMIXQ_c015_1_06 (mix_q_src_c015_1_06 0 bpf_c015_1 0) vcvs gain=5.555702330196e-01
SMIXQ_c015_1_06 (mix_q_src_c015_1_06 mix_q_c015_1 win_1_06 0) relay vt1=-1m vt2=1m ropen=ropen_mix rclosed=rclosed_mix
EMIXI_c015_1_07 (mix_i_src_c015_1_07 0 bpf_c015_1 0) vcvs gain=-9.807852804032e-01
SMIXI_c015_1_07 (mix_i_src_c015_1_07 mix_i_c015_1 win_1_07 0) relay vt1=-1m vt2=1m ropen=ropen_mix rclosed=rclosed_mix
EMIXQ_c015_1_07 (mix_q_src_c015_1_07 0 bpf_c015_1 0) vcvs gain=1.950903220161e-01
SMIXQ_c015_1_07 (mix_q_src_c015_1_07 mix_q_c015_1 win_1_07 0) relay vt1=-1m vt2=1m ropen=ropen_mix rclosed=rclosed_mix
EMIXI_c015_1_08 (mix_i_src_c015_1_08 0 bpf_c015_1 0) vcvs gain=-9.807852804032e-01
SMIXI_c015_1_08 (mix_i_src_c015_1_08 mix_i_c015_1 win_1_08 0) relay vt1=-1m vt2=1m ropen=ropen_mix rclosed=rclosed_mix
EMIXQ_c015_1_08 (mix_q_src_c015_1_08 0 bpf_c015_1 0) vcvs gain=-1.950903220161e-01
SMIXQ_c015_1_08 (mix_q_src_c015_1_08 mix_q_c015_1 win_1_08 0) relay vt1=-1m vt2=1m ropen=ropen_mix rclosed=rclosed_mix
EMIXI_c015_1_09 (mix_i_src_c015_1_09 0 bpf_c015_1 0) vcvs gain=-8.314696123025e-01
SMIXI_c015_1_09 (mix_i_src_c015_1_09 mix_i_c015_1 win_1_09 0) relay vt1=-1m vt2=1m ropen=ropen_mix rclosed=rclosed_mix
EMIXQ_c015_1_09 (mix_q_src_c015_1_09 0 bpf_c015_1 0) vcvs gain=-5.555702330196e-01
SMIXQ_c015_1_09 (mix_q_src_c015_1_09 mix_q_c015_1 win_1_09 0) relay vt1=-1m vt2=1m ropen=ropen_mix rclosed=rclosed_mix
EMIXI_c015_1_10 (mix_i_src_c015_1_10 0 bpf_c015_1 0) vcvs gain=-5.555702330196e-01
SMIXI_c015_1_10 (mix_i_src_c015_1_10 mix_i_c015_1 win_1_10 0) relay vt1=-1m vt2=1m ropen=ropen_mix rclosed=rclosed_mix
EMIXQ_c015_1_10 (mix_q_src_c015_1_10 0 bpf_c015_1 0) vcvs gain=-8.314696123025e-01
SMIXQ_c015_1_10 (mix_q_src_c015_1_10 mix_q_c015_1 win_1_10 0) relay vt1=-1m vt2=1m ropen=ropen_mix rclosed=rclosed_mix
EMIXI_c015_1_11 (mix_i_src_c015_1_11 0 bpf_c015_1 0) vcvs gain=-1.950903220161e-01
SMIXI_c015_1_11 (mix_i_src_c015_1_11 mix_i_c015_1 win_1_11 0) relay vt1=-1m vt2=1m ropen=ropen_mix rclosed=rclosed_mix
EMIXQ_c015_1_11 (mix_q_src_c015_1_11 0 bpf_c015_1 0) vcvs gain=-9.807852804032e-01
SMIXQ_c015_1_11 (mix_q_src_c015_1_11 mix_q_c015_1 win_1_11 0) relay vt1=-1m vt2=1m ropen=ropen_mix rclosed=rclosed_mix
EMIXI_c015_1_12 (mix_i_src_c015_1_12 0 bpf_c015_1 0) vcvs gain=1.950903220161e-01
SMIXI_c015_1_12 (mix_i_src_c015_1_12 mix_i_c015_1 win_1_12 0) relay vt1=-1m vt2=1m ropen=ropen_mix rclosed=rclosed_mix
EMIXQ_c015_1_12 (mix_q_src_c015_1_12 0 bpf_c015_1 0) vcvs gain=-9.807852804032e-01
SMIXQ_c015_1_12 (mix_q_src_c015_1_12 mix_q_c015_1 win_1_12 0) relay vt1=-1m vt2=1m ropen=ropen_mix rclosed=rclosed_mix
EMIXI_c015_1_13 (mix_i_src_c015_1_13 0 bpf_c015_1 0) vcvs gain=5.555702330196e-01
SMIXI_c015_1_13 (mix_i_src_c015_1_13 mix_i_c015_1 win_1_13 0) relay vt1=-1m vt2=1m ropen=ropen_mix rclosed=rclosed_mix
EMIXQ_c015_1_13 (mix_q_src_c015_1_13 0 bpf_c015_1 0) vcvs gain=-8.314696123025e-01
SMIXQ_c015_1_13 (mix_q_src_c015_1_13 mix_q_c015_1 win_1_13 0) relay vt1=-1m vt2=1m ropen=ropen_mix rclosed=rclosed_mix
EMIXI_c015_1_14 (mix_i_src_c015_1_14 0 bpf_c015_1 0) vcvs gain=8.314696123025e-01
SMIXI_c015_1_14 (mix_i_src_c015_1_14 mix_i_c015_1 win_1_14 0) relay vt1=-1m vt2=1m ropen=ropen_mix rclosed=rclosed_mix
EMIXQ_c015_1_14 (mix_q_src_c015_1_14 0 bpf_c015_1 0) vcvs gain=-5.555702330196e-01
SMIXQ_c015_1_14 (mix_q_src_c015_1_14 mix_q_c015_1 win_1_14 0) relay vt1=-1m vt2=1m ropen=ropen_mix rclosed=rclosed_mix
EMIXI_c015_1_15 (mix_i_src_c015_1_15 0 bpf_c015_1 0) vcvs gain=9.807852804032e-01
SMIXI_c015_1_15 (mix_i_src_c015_1_15 mix_i_c015_1 win_1_15 0) relay vt1=-1m vt2=1m ropen=ropen_mix rclosed=rclosed_mix
EMIXQ_c015_1_15 (mix_q_src_c015_1_15 0 bpf_c015_1 0) vcvs gain=-1.950903220161e-01
SMIXQ_c015_1_15 (mix_q_src_c015_1_15 mix_q_c015_1 win_1_15 0) relay vt1=-1m vt2=1m ropen=ropen_mix rclosed=rclosed_mix
RMIXI_c015_1 (mix_i_c015_1 0) resistor r=1G
RMIXQ_c015_1 (mix_q_c015_1 0) resistor r=1G
RINTI_c015_1 (mix_i_c015_1 Icar_c015_1) resistor r=1k
CINTI_c015_1 (Icar_c015_1 0) capacitor c=80p
RINTQ_c015_1 (mix_q_c015_1 Qcar_c015_1) resistor r=1k
CINTQ_c015_1 (Qcar_c015_1 0) capacitor c=80p
save bpf_c015_1 Icar_c015_1 Qcar_c015_1

// bl015, carrier_2: 750000000 Hz coherent I/Q phase-window verification-demod path
CBPF_c015_2 (bl015 n_cbpf_c015_2) capacitor c=4.503163717437e-14
LBPF_c015_2 (n_cbpf_c015_2 bpf_c015_2) inductor l=1.000000000000e-06
RBPF_c015_2 (bpf_c015_2 0) resistor r=2.356194490192e+02
EMIXI_c015_2_00 (mix_i_src_c015_2_00 0 bpf_c015_2 0) vcvs gain=9.807852804032e-01
SMIXI_c015_2_00 (mix_i_src_c015_2_00 mix_i_c015_2 win_2_00 0) relay vt1=-1m vt2=1m ropen=ropen_mix rclosed=rclosed_mix
EMIXQ_c015_2_00 (mix_q_src_c015_2_00 0 bpf_c015_2 0) vcvs gain=1.950903220161e-01
SMIXQ_c015_2_00 (mix_q_src_c015_2_00 mix_q_c015_2 win_2_00 0) relay vt1=-1m vt2=1m ropen=ropen_mix rclosed=rclosed_mix
EMIXI_c015_2_01 (mix_i_src_c015_2_01 0 bpf_c015_2 0) vcvs gain=8.314696123025e-01
SMIXI_c015_2_01 (mix_i_src_c015_2_01 mix_i_c015_2 win_2_01 0) relay vt1=-1m vt2=1m ropen=ropen_mix rclosed=rclosed_mix
EMIXQ_c015_2_01 (mix_q_src_c015_2_01 0 bpf_c015_2 0) vcvs gain=5.555702330196e-01
SMIXQ_c015_2_01 (mix_q_src_c015_2_01 mix_q_c015_2 win_2_01 0) relay vt1=-1m vt2=1m ropen=ropen_mix rclosed=rclosed_mix
EMIXI_c015_2_02 (mix_i_src_c015_2_02 0 bpf_c015_2 0) vcvs gain=5.555702330196e-01
SMIXI_c015_2_02 (mix_i_src_c015_2_02 mix_i_c015_2 win_2_02 0) relay vt1=-1m vt2=1m ropen=ropen_mix rclosed=rclosed_mix
EMIXQ_c015_2_02 (mix_q_src_c015_2_02 0 bpf_c015_2 0) vcvs gain=8.314696123025e-01
SMIXQ_c015_2_02 (mix_q_src_c015_2_02 mix_q_c015_2 win_2_02 0) relay vt1=-1m vt2=1m ropen=ropen_mix rclosed=rclosed_mix
EMIXI_c015_2_03 (mix_i_src_c015_2_03 0 bpf_c015_2 0) vcvs gain=1.950903220161e-01
SMIXI_c015_2_03 (mix_i_src_c015_2_03 mix_i_c015_2 win_2_03 0) relay vt1=-1m vt2=1m ropen=ropen_mix rclosed=rclosed_mix
EMIXQ_c015_2_03 (mix_q_src_c015_2_03 0 bpf_c015_2 0) vcvs gain=9.807852804032e-01
SMIXQ_c015_2_03 (mix_q_src_c015_2_03 mix_q_c015_2 win_2_03 0) relay vt1=-1m vt2=1m ropen=ropen_mix rclosed=rclosed_mix
EMIXI_c015_2_04 (mix_i_src_c015_2_04 0 bpf_c015_2 0) vcvs gain=-1.950903220161e-01
SMIXI_c015_2_04 (mix_i_src_c015_2_04 mix_i_c015_2 win_2_04 0) relay vt1=-1m vt2=1m ropen=ropen_mix rclosed=rclosed_mix
EMIXQ_c015_2_04 (mix_q_src_c015_2_04 0 bpf_c015_2 0) vcvs gain=9.807852804032e-01
SMIXQ_c015_2_04 (mix_q_src_c015_2_04 mix_q_c015_2 win_2_04 0) relay vt1=-1m vt2=1m ropen=ropen_mix rclosed=rclosed_mix
EMIXI_c015_2_05 (mix_i_src_c015_2_05 0 bpf_c015_2 0) vcvs gain=-5.555702330196e-01
SMIXI_c015_2_05 (mix_i_src_c015_2_05 mix_i_c015_2 win_2_05 0) relay vt1=-1m vt2=1m ropen=ropen_mix rclosed=rclosed_mix
EMIXQ_c015_2_05 (mix_q_src_c015_2_05 0 bpf_c015_2 0) vcvs gain=8.314696123025e-01
SMIXQ_c015_2_05 (mix_q_src_c015_2_05 mix_q_c015_2 win_2_05 0) relay vt1=-1m vt2=1m ropen=ropen_mix rclosed=rclosed_mix
EMIXI_c015_2_06 (mix_i_src_c015_2_06 0 bpf_c015_2 0) vcvs gain=-8.314696123025e-01
SMIXI_c015_2_06 (mix_i_src_c015_2_06 mix_i_c015_2 win_2_06 0) relay vt1=-1m vt2=1m ropen=ropen_mix rclosed=rclosed_mix
EMIXQ_c015_2_06 (mix_q_src_c015_2_06 0 bpf_c015_2 0) vcvs gain=5.555702330196e-01
SMIXQ_c015_2_06 (mix_q_src_c015_2_06 mix_q_c015_2 win_2_06 0) relay vt1=-1m vt2=1m ropen=ropen_mix rclosed=rclosed_mix
EMIXI_c015_2_07 (mix_i_src_c015_2_07 0 bpf_c015_2 0) vcvs gain=-9.807852804032e-01
SMIXI_c015_2_07 (mix_i_src_c015_2_07 mix_i_c015_2 win_2_07 0) relay vt1=-1m vt2=1m ropen=ropen_mix rclosed=rclosed_mix
EMIXQ_c015_2_07 (mix_q_src_c015_2_07 0 bpf_c015_2 0) vcvs gain=1.950903220161e-01
SMIXQ_c015_2_07 (mix_q_src_c015_2_07 mix_q_c015_2 win_2_07 0) relay vt1=-1m vt2=1m ropen=ropen_mix rclosed=rclosed_mix
EMIXI_c015_2_08 (mix_i_src_c015_2_08 0 bpf_c015_2 0) vcvs gain=-9.807852804032e-01
SMIXI_c015_2_08 (mix_i_src_c015_2_08 mix_i_c015_2 win_2_08 0) relay vt1=-1m vt2=1m ropen=ropen_mix rclosed=rclosed_mix
EMIXQ_c015_2_08 (mix_q_src_c015_2_08 0 bpf_c015_2 0) vcvs gain=-1.950903220161e-01
SMIXQ_c015_2_08 (mix_q_src_c015_2_08 mix_q_c015_2 win_2_08 0) relay vt1=-1m vt2=1m ropen=ropen_mix rclosed=rclosed_mix
EMIXI_c015_2_09 (mix_i_src_c015_2_09 0 bpf_c015_2 0) vcvs gain=-8.314696123025e-01
SMIXI_c015_2_09 (mix_i_src_c015_2_09 mix_i_c015_2 win_2_09 0) relay vt1=-1m vt2=1m ropen=ropen_mix rclosed=rclosed_mix
EMIXQ_c015_2_09 (mix_q_src_c015_2_09 0 bpf_c015_2 0) vcvs gain=-5.555702330196e-01
SMIXQ_c015_2_09 (mix_q_src_c015_2_09 mix_q_c015_2 win_2_09 0) relay vt1=-1m vt2=1m ropen=ropen_mix rclosed=rclosed_mix
EMIXI_c015_2_10 (mix_i_src_c015_2_10 0 bpf_c015_2 0) vcvs gain=-5.555702330196e-01
SMIXI_c015_2_10 (mix_i_src_c015_2_10 mix_i_c015_2 win_2_10 0) relay vt1=-1m vt2=1m ropen=ropen_mix rclosed=rclosed_mix
EMIXQ_c015_2_10 (mix_q_src_c015_2_10 0 bpf_c015_2 0) vcvs gain=-8.314696123025e-01
SMIXQ_c015_2_10 (mix_q_src_c015_2_10 mix_q_c015_2 win_2_10 0) relay vt1=-1m vt2=1m ropen=ropen_mix rclosed=rclosed_mix
EMIXI_c015_2_11 (mix_i_src_c015_2_11 0 bpf_c015_2 0) vcvs gain=-1.950903220161e-01
SMIXI_c015_2_11 (mix_i_src_c015_2_11 mix_i_c015_2 win_2_11 0) relay vt1=-1m vt2=1m ropen=ropen_mix rclosed=rclosed_mix
EMIXQ_c015_2_11 (mix_q_src_c015_2_11 0 bpf_c015_2 0) vcvs gain=-9.807852804032e-01
SMIXQ_c015_2_11 (mix_q_src_c015_2_11 mix_q_c015_2 win_2_11 0) relay vt1=-1m vt2=1m ropen=ropen_mix rclosed=rclosed_mix
EMIXI_c015_2_12 (mix_i_src_c015_2_12 0 bpf_c015_2 0) vcvs gain=1.950903220161e-01
SMIXI_c015_2_12 (mix_i_src_c015_2_12 mix_i_c015_2 win_2_12 0) relay vt1=-1m vt2=1m ropen=ropen_mix rclosed=rclosed_mix
EMIXQ_c015_2_12 (mix_q_src_c015_2_12 0 bpf_c015_2 0) vcvs gain=-9.807852804032e-01
SMIXQ_c015_2_12 (mix_q_src_c015_2_12 mix_q_c015_2 win_2_12 0) relay vt1=-1m vt2=1m ropen=ropen_mix rclosed=rclosed_mix
EMIXI_c015_2_13 (mix_i_src_c015_2_13 0 bpf_c015_2 0) vcvs gain=5.555702330196e-01
SMIXI_c015_2_13 (mix_i_src_c015_2_13 mix_i_c015_2 win_2_13 0) relay vt1=-1m vt2=1m ropen=ropen_mix rclosed=rclosed_mix
EMIXQ_c015_2_13 (mix_q_src_c015_2_13 0 bpf_c015_2 0) vcvs gain=-8.314696123025e-01
SMIXQ_c015_2_13 (mix_q_src_c015_2_13 mix_q_c015_2 win_2_13 0) relay vt1=-1m vt2=1m ropen=ropen_mix rclosed=rclosed_mix
EMIXI_c015_2_14 (mix_i_src_c015_2_14 0 bpf_c015_2 0) vcvs gain=8.314696123025e-01
SMIXI_c015_2_14 (mix_i_src_c015_2_14 mix_i_c015_2 win_2_14 0) relay vt1=-1m vt2=1m ropen=ropen_mix rclosed=rclosed_mix
EMIXQ_c015_2_14 (mix_q_src_c015_2_14 0 bpf_c015_2 0) vcvs gain=-5.555702330196e-01
SMIXQ_c015_2_14 (mix_q_src_c015_2_14 mix_q_c015_2 win_2_14 0) relay vt1=-1m vt2=1m ropen=ropen_mix rclosed=rclosed_mix
EMIXI_c015_2_15 (mix_i_src_c015_2_15 0 bpf_c015_2 0) vcvs gain=9.807852804032e-01
SMIXI_c015_2_15 (mix_i_src_c015_2_15 mix_i_c015_2 win_2_15 0) relay vt1=-1m vt2=1m ropen=ropen_mix rclosed=rclosed_mix
EMIXQ_c015_2_15 (mix_q_src_c015_2_15 0 bpf_c015_2 0) vcvs gain=-1.950903220161e-01
SMIXQ_c015_2_15 (mix_q_src_c015_2_15 mix_q_c015_2 win_2_15 0) relay vt1=-1m vt2=1m ropen=ropen_mix rclosed=rclosed_mix
RMIXI_c015_2 (mix_i_c015_2 0) resistor r=1G
RMIXQ_c015_2 (mix_q_c015_2 0) resistor r=1G
RINTI_c015_2 (mix_i_c015_2 Icar_c015_2) resistor r=1k
CINTI_c015_2 (Icar_c015_2 0) capacitor c=80p
RINTQ_c015_2 (mix_q_c015_2 Qcar_c015_2) resistor r=1k
CINTQ_c015_2 (Qcar_c015_2 0) capacitor c=80p
save bpf_c015_2 Icar_c015_2 Qcar_c015_2

// bl015, carrier_3: 1000000000 Hz coherent I/Q phase-window verification-demod path
CBPF_c015_3 (bl015 n_cbpf_c015_3) capacitor c=2.533029591058e-14
LBPF_c015_3 (n_cbpf_c015_3 bpf_c015_3) inductor l=1.000000000000e-06
RBPF_c015_3 (bpf_c015_3 0) resistor r=3.141592653590e+02
EMIXI_c015_3_00 (mix_i_src_c015_3_00 0 bpf_c015_3 0) vcvs gain=9.807852804032e-01
SMIXI_c015_3_00 (mix_i_src_c015_3_00 mix_i_c015_3 win_3_00 0) relay vt1=-1m vt2=1m ropen=ropen_mix rclosed=rclosed_mix
EMIXQ_c015_3_00 (mix_q_src_c015_3_00 0 bpf_c015_3 0) vcvs gain=1.950903220161e-01
SMIXQ_c015_3_00 (mix_q_src_c015_3_00 mix_q_c015_3 win_3_00 0) relay vt1=-1m vt2=1m ropen=ropen_mix rclosed=rclosed_mix
EMIXI_c015_3_01 (mix_i_src_c015_3_01 0 bpf_c015_3 0) vcvs gain=8.314696123025e-01
SMIXI_c015_3_01 (mix_i_src_c015_3_01 mix_i_c015_3 win_3_01 0) relay vt1=-1m vt2=1m ropen=ropen_mix rclosed=rclosed_mix
EMIXQ_c015_3_01 (mix_q_src_c015_3_01 0 bpf_c015_3 0) vcvs gain=5.555702330196e-01
SMIXQ_c015_3_01 (mix_q_src_c015_3_01 mix_q_c015_3 win_3_01 0) relay vt1=-1m vt2=1m ropen=ropen_mix rclosed=rclosed_mix
EMIXI_c015_3_02 (mix_i_src_c015_3_02 0 bpf_c015_3 0) vcvs gain=5.555702330196e-01
SMIXI_c015_3_02 (mix_i_src_c015_3_02 mix_i_c015_3 win_3_02 0) relay vt1=-1m vt2=1m ropen=ropen_mix rclosed=rclosed_mix
EMIXQ_c015_3_02 (mix_q_src_c015_3_02 0 bpf_c015_3 0) vcvs gain=8.314696123025e-01
SMIXQ_c015_3_02 (mix_q_src_c015_3_02 mix_q_c015_3 win_3_02 0) relay vt1=-1m vt2=1m ropen=ropen_mix rclosed=rclosed_mix
EMIXI_c015_3_03 (mix_i_src_c015_3_03 0 bpf_c015_3 0) vcvs gain=1.950903220161e-01
SMIXI_c015_3_03 (mix_i_src_c015_3_03 mix_i_c015_3 win_3_03 0) relay vt1=-1m vt2=1m ropen=ropen_mix rclosed=rclosed_mix
EMIXQ_c015_3_03 (mix_q_src_c015_3_03 0 bpf_c015_3 0) vcvs gain=9.807852804032e-01
SMIXQ_c015_3_03 (mix_q_src_c015_3_03 mix_q_c015_3 win_3_03 0) relay vt1=-1m vt2=1m ropen=ropen_mix rclosed=rclosed_mix
EMIXI_c015_3_04 (mix_i_src_c015_3_04 0 bpf_c015_3 0) vcvs gain=-1.950903220161e-01
SMIXI_c015_3_04 (mix_i_src_c015_3_04 mix_i_c015_3 win_3_04 0) relay vt1=-1m vt2=1m ropen=ropen_mix rclosed=rclosed_mix
EMIXQ_c015_3_04 (mix_q_src_c015_3_04 0 bpf_c015_3 0) vcvs gain=9.807852804032e-01
SMIXQ_c015_3_04 (mix_q_src_c015_3_04 mix_q_c015_3 win_3_04 0) relay vt1=-1m vt2=1m ropen=ropen_mix rclosed=rclosed_mix
EMIXI_c015_3_05 (mix_i_src_c015_3_05 0 bpf_c015_3 0) vcvs gain=-5.555702330196e-01
SMIXI_c015_3_05 (mix_i_src_c015_3_05 mix_i_c015_3 win_3_05 0) relay vt1=-1m vt2=1m ropen=ropen_mix rclosed=rclosed_mix
EMIXQ_c015_3_05 (mix_q_src_c015_3_05 0 bpf_c015_3 0) vcvs gain=8.314696123025e-01
SMIXQ_c015_3_05 (mix_q_src_c015_3_05 mix_q_c015_3 win_3_05 0) relay vt1=-1m vt2=1m ropen=ropen_mix rclosed=rclosed_mix
EMIXI_c015_3_06 (mix_i_src_c015_3_06 0 bpf_c015_3 0) vcvs gain=-8.314696123025e-01
SMIXI_c015_3_06 (mix_i_src_c015_3_06 mix_i_c015_3 win_3_06 0) relay vt1=-1m vt2=1m ropen=ropen_mix rclosed=rclosed_mix
EMIXQ_c015_3_06 (mix_q_src_c015_3_06 0 bpf_c015_3 0) vcvs gain=5.555702330196e-01
SMIXQ_c015_3_06 (mix_q_src_c015_3_06 mix_q_c015_3 win_3_06 0) relay vt1=-1m vt2=1m ropen=ropen_mix rclosed=rclosed_mix
EMIXI_c015_3_07 (mix_i_src_c015_3_07 0 bpf_c015_3 0) vcvs gain=-9.807852804032e-01
SMIXI_c015_3_07 (mix_i_src_c015_3_07 mix_i_c015_3 win_3_07 0) relay vt1=-1m vt2=1m ropen=ropen_mix rclosed=rclosed_mix
EMIXQ_c015_3_07 (mix_q_src_c015_3_07 0 bpf_c015_3 0) vcvs gain=1.950903220161e-01
SMIXQ_c015_3_07 (mix_q_src_c015_3_07 mix_q_c015_3 win_3_07 0) relay vt1=-1m vt2=1m ropen=ropen_mix rclosed=rclosed_mix
EMIXI_c015_3_08 (mix_i_src_c015_3_08 0 bpf_c015_3 0) vcvs gain=-9.807852804032e-01
SMIXI_c015_3_08 (mix_i_src_c015_3_08 mix_i_c015_3 win_3_08 0) relay vt1=-1m vt2=1m ropen=ropen_mix rclosed=rclosed_mix
EMIXQ_c015_3_08 (mix_q_src_c015_3_08 0 bpf_c015_3 0) vcvs gain=-1.950903220161e-01
SMIXQ_c015_3_08 (mix_q_src_c015_3_08 mix_q_c015_3 win_3_08 0) relay vt1=-1m vt2=1m ropen=ropen_mix rclosed=rclosed_mix
EMIXI_c015_3_09 (mix_i_src_c015_3_09 0 bpf_c015_3 0) vcvs gain=-8.314696123025e-01
SMIXI_c015_3_09 (mix_i_src_c015_3_09 mix_i_c015_3 win_3_09 0) relay vt1=-1m vt2=1m ropen=ropen_mix rclosed=rclosed_mix
EMIXQ_c015_3_09 (mix_q_src_c015_3_09 0 bpf_c015_3 0) vcvs gain=-5.555702330196e-01
SMIXQ_c015_3_09 (mix_q_src_c015_3_09 mix_q_c015_3 win_3_09 0) relay vt1=-1m vt2=1m ropen=ropen_mix rclosed=rclosed_mix
EMIXI_c015_3_10 (mix_i_src_c015_3_10 0 bpf_c015_3 0) vcvs gain=-5.555702330196e-01
SMIXI_c015_3_10 (mix_i_src_c015_3_10 mix_i_c015_3 win_3_10 0) relay vt1=-1m vt2=1m ropen=ropen_mix rclosed=rclosed_mix
EMIXQ_c015_3_10 (mix_q_src_c015_3_10 0 bpf_c015_3 0) vcvs gain=-8.314696123025e-01
SMIXQ_c015_3_10 (mix_q_src_c015_3_10 mix_q_c015_3 win_3_10 0) relay vt1=-1m vt2=1m ropen=ropen_mix rclosed=rclosed_mix
EMIXI_c015_3_11 (mix_i_src_c015_3_11 0 bpf_c015_3 0) vcvs gain=-1.950903220161e-01
SMIXI_c015_3_11 (mix_i_src_c015_3_11 mix_i_c015_3 win_3_11 0) relay vt1=-1m vt2=1m ropen=ropen_mix rclosed=rclosed_mix
EMIXQ_c015_3_11 (mix_q_src_c015_3_11 0 bpf_c015_3 0) vcvs gain=-9.807852804032e-01
SMIXQ_c015_3_11 (mix_q_src_c015_3_11 mix_q_c015_3 win_3_11 0) relay vt1=-1m vt2=1m ropen=ropen_mix rclosed=rclosed_mix
EMIXI_c015_3_12 (mix_i_src_c015_3_12 0 bpf_c015_3 0) vcvs gain=1.950903220161e-01
SMIXI_c015_3_12 (mix_i_src_c015_3_12 mix_i_c015_3 win_3_12 0) relay vt1=-1m vt2=1m ropen=ropen_mix rclosed=rclosed_mix
EMIXQ_c015_3_12 (mix_q_src_c015_3_12 0 bpf_c015_3 0) vcvs gain=-9.807852804032e-01
SMIXQ_c015_3_12 (mix_q_src_c015_3_12 mix_q_c015_3 win_3_12 0) relay vt1=-1m vt2=1m ropen=ropen_mix rclosed=rclosed_mix
EMIXI_c015_3_13 (mix_i_src_c015_3_13 0 bpf_c015_3 0) vcvs gain=5.555702330196e-01
SMIXI_c015_3_13 (mix_i_src_c015_3_13 mix_i_c015_3 win_3_13 0) relay vt1=-1m vt2=1m ropen=ropen_mix rclosed=rclosed_mix
EMIXQ_c015_3_13 (mix_q_src_c015_3_13 0 bpf_c015_3 0) vcvs gain=-8.314696123025e-01
SMIXQ_c015_3_13 (mix_q_src_c015_3_13 mix_q_c015_3 win_3_13 0) relay vt1=-1m vt2=1m ropen=ropen_mix rclosed=rclosed_mix
EMIXI_c015_3_14 (mix_i_src_c015_3_14 0 bpf_c015_3 0) vcvs gain=8.314696123025e-01
SMIXI_c015_3_14 (mix_i_src_c015_3_14 mix_i_c015_3 win_3_14 0) relay vt1=-1m vt2=1m ropen=ropen_mix rclosed=rclosed_mix
EMIXQ_c015_3_14 (mix_q_src_c015_3_14 0 bpf_c015_3 0) vcvs gain=-5.555702330196e-01
SMIXQ_c015_3_14 (mix_q_src_c015_3_14 mix_q_c015_3 win_3_14 0) relay vt1=-1m vt2=1m ropen=ropen_mix rclosed=rclosed_mix
EMIXI_c015_3_15 (mix_i_src_c015_3_15 0 bpf_c015_3 0) vcvs gain=9.807852804032e-01
SMIXI_c015_3_15 (mix_i_src_c015_3_15 mix_i_c015_3 win_3_15 0) relay vt1=-1m vt2=1m ropen=ropen_mix rclosed=rclosed_mix
EMIXQ_c015_3_15 (mix_q_src_c015_3_15 0 bpf_c015_3 0) vcvs gain=-1.950903220161e-01
SMIXQ_c015_3_15 (mix_q_src_c015_3_15 mix_q_c015_3 win_3_15 0) relay vt1=-1m vt2=1m ropen=ropen_mix rclosed=rclosed_mix
RMIXI_c015_3 (mix_i_c015_3 0) resistor r=1G
RMIXQ_c015_3 (mix_q_c015_3 0) resistor r=1G
RINTI_c015_3 (mix_i_c015_3 Icar_c015_3) resistor r=1k
CINTI_c015_3 (Icar_c015_3 0) capacitor c=80p
RINTQ_c015_3 (mix_q_c015_3 Qcar_c015_3) resistor r=1k
CINTQ_c015_3 (Qcar_c015_3 0) capacitor c=80p
save bpf_c015_3 Icar_c015_3 Qcar_c015_3

// bl016, carrier_0: 250000000 Hz coherent I/Q phase-window verification-demod path
CBPF_c016_0 (bl016 n_cbpf_c016_0) capacitor c=4.052847345694e-13
LBPF_c016_0 (n_cbpf_c016_0 bpf_c016_0) inductor l=1.000000000000e-06
RBPF_c016_0 (bpf_c016_0 0) resistor r=7.853981633974e+01
EMIXI_c016_0_00 (mix_i_src_c016_0_00 0 bpf_c016_0 0) vcvs gain=9.807852804032e-01
SMIXI_c016_0_00 (mix_i_src_c016_0_00 mix_i_c016_0 win_0_00 0) relay vt1=-1m vt2=1m ropen=ropen_mix rclosed=rclosed_mix
EMIXQ_c016_0_00 (mix_q_src_c016_0_00 0 bpf_c016_0 0) vcvs gain=1.950903220161e-01
SMIXQ_c016_0_00 (mix_q_src_c016_0_00 mix_q_c016_0 win_0_00 0) relay vt1=-1m vt2=1m ropen=ropen_mix rclosed=rclosed_mix
EMIXI_c016_0_01 (mix_i_src_c016_0_01 0 bpf_c016_0 0) vcvs gain=8.314696123025e-01
SMIXI_c016_0_01 (mix_i_src_c016_0_01 mix_i_c016_0 win_0_01 0) relay vt1=-1m vt2=1m ropen=ropen_mix rclosed=rclosed_mix
EMIXQ_c016_0_01 (mix_q_src_c016_0_01 0 bpf_c016_0 0) vcvs gain=5.555702330196e-01
SMIXQ_c016_0_01 (mix_q_src_c016_0_01 mix_q_c016_0 win_0_01 0) relay vt1=-1m vt2=1m ropen=ropen_mix rclosed=rclosed_mix
EMIXI_c016_0_02 (mix_i_src_c016_0_02 0 bpf_c016_0 0) vcvs gain=5.555702330196e-01
SMIXI_c016_0_02 (mix_i_src_c016_0_02 mix_i_c016_0 win_0_02 0) relay vt1=-1m vt2=1m ropen=ropen_mix rclosed=rclosed_mix
EMIXQ_c016_0_02 (mix_q_src_c016_0_02 0 bpf_c016_0 0) vcvs gain=8.314696123025e-01
SMIXQ_c016_0_02 (mix_q_src_c016_0_02 mix_q_c016_0 win_0_02 0) relay vt1=-1m vt2=1m ropen=ropen_mix rclosed=rclosed_mix
EMIXI_c016_0_03 (mix_i_src_c016_0_03 0 bpf_c016_0 0) vcvs gain=1.950903220161e-01
SMIXI_c016_0_03 (mix_i_src_c016_0_03 mix_i_c016_0 win_0_03 0) relay vt1=-1m vt2=1m ropen=ropen_mix rclosed=rclosed_mix
EMIXQ_c016_0_03 (mix_q_src_c016_0_03 0 bpf_c016_0 0) vcvs gain=9.807852804032e-01
SMIXQ_c016_0_03 (mix_q_src_c016_0_03 mix_q_c016_0 win_0_03 0) relay vt1=-1m vt2=1m ropen=ropen_mix rclosed=rclosed_mix
EMIXI_c016_0_04 (mix_i_src_c016_0_04 0 bpf_c016_0 0) vcvs gain=-1.950903220161e-01
SMIXI_c016_0_04 (mix_i_src_c016_0_04 mix_i_c016_0 win_0_04 0) relay vt1=-1m vt2=1m ropen=ropen_mix rclosed=rclosed_mix
EMIXQ_c016_0_04 (mix_q_src_c016_0_04 0 bpf_c016_0 0) vcvs gain=9.807852804032e-01
SMIXQ_c016_0_04 (mix_q_src_c016_0_04 mix_q_c016_0 win_0_04 0) relay vt1=-1m vt2=1m ropen=ropen_mix rclosed=rclosed_mix
EMIXI_c016_0_05 (mix_i_src_c016_0_05 0 bpf_c016_0 0) vcvs gain=-5.555702330196e-01
SMIXI_c016_0_05 (mix_i_src_c016_0_05 mix_i_c016_0 win_0_05 0) relay vt1=-1m vt2=1m ropen=ropen_mix rclosed=rclosed_mix
EMIXQ_c016_0_05 (mix_q_src_c016_0_05 0 bpf_c016_0 0) vcvs gain=8.314696123025e-01
SMIXQ_c016_0_05 (mix_q_src_c016_0_05 mix_q_c016_0 win_0_05 0) relay vt1=-1m vt2=1m ropen=ropen_mix rclosed=rclosed_mix
EMIXI_c016_0_06 (mix_i_src_c016_0_06 0 bpf_c016_0 0) vcvs gain=-8.314696123025e-01
SMIXI_c016_0_06 (mix_i_src_c016_0_06 mix_i_c016_0 win_0_06 0) relay vt1=-1m vt2=1m ropen=ropen_mix rclosed=rclosed_mix
EMIXQ_c016_0_06 (mix_q_src_c016_0_06 0 bpf_c016_0 0) vcvs gain=5.555702330196e-01
SMIXQ_c016_0_06 (mix_q_src_c016_0_06 mix_q_c016_0 win_0_06 0) relay vt1=-1m vt2=1m ropen=ropen_mix rclosed=rclosed_mix
EMIXI_c016_0_07 (mix_i_src_c016_0_07 0 bpf_c016_0 0) vcvs gain=-9.807852804032e-01
SMIXI_c016_0_07 (mix_i_src_c016_0_07 mix_i_c016_0 win_0_07 0) relay vt1=-1m vt2=1m ropen=ropen_mix rclosed=rclosed_mix
EMIXQ_c016_0_07 (mix_q_src_c016_0_07 0 bpf_c016_0 0) vcvs gain=1.950903220161e-01
SMIXQ_c016_0_07 (mix_q_src_c016_0_07 mix_q_c016_0 win_0_07 0) relay vt1=-1m vt2=1m ropen=ropen_mix rclosed=rclosed_mix
EMIXI_c016_0_08 (mix_i_src_c016_0_08 0 bpf_c016_0 0) vcvs gain=-9.807852804032e-01
SMIXI_c016_0_08 (mix_i_src_c016_0_08 mix_i_c016_0 win_0_08 0) relay vt1=-1m vt2=1m ropen=ropen_mix rclosed=rclosed_mix
EMIXQ_c016_0_08 (mix_q_src_c016_0_08 0 bpf_c016_0 0) vcvs gain=-1.950903220161e-01
SMIXQ_c016_0_08 (mix_q_src_c016_0_08 mix_q_c016_0 win_0_08 0) relay vt1=-1m vt2=1m ropen=ropen_mix rclosed=rclosed_mix
EMIXI_c016_0_09 (mix_i_src_c016_0_09 0 bpf_c016_0 0) vcvs gain=-8.314696123025e-01
SMIXI_c016_0_09 (mix_i_src_c016_0_09 mix_i_c016_0 win_0_09 0) relay vt1=-1m vt2=1m ropen=ropen_mix rclosed=rclosed_mix
EMIXQ_c016_0_09 (mix_q_src_c016_0_09 0 bpf_c016_0 0) vcvs gain=-5.555702330196e-01
SMIXQ_c016_0_09 (mix_q_src_c016_0_09 mix_q_c016_0 win_0_09 0) relay vt1=-1m vt2=1m ropen=ropen_mix rclosed=rclosed_mix
EMIXI_c016_0_10 (mix_i_src_c016_0_10 0 bpf_c016_0 0) vcvs gain=-5.555702330196e-01
SMIXI_c016_0_10 (mix_i_src_c016_0_10 mix_i_c016_0 win_0_10 0) relay vt1=-1m vt2=1m ropen=ropen_mix rclosed=rclosed_mix
EMIXQ_c016_0_10 (mix_q_src_c016_0_10 0 bpf_c016_0 0) vcvs gain=-8.314696123025e-01
SMIXQ_c016_0_10 (mix_q_src_c016_0_10 mix_q_c016_0 win_0_10 0) relay vt1=-1m vt2=1m ropen=ropen_mix rclosed=rclosed_mix
EMIXI_c016_0_11 (mix_i_src_c016_0_11 0 bpf_c016_0 0) vcvs gain=-1.950903220161e-01
SMIXI_c016_0_11 (mix_i_src_c016_0_11 mix_i_c016_0 win_0_11 0) relay vt1=-1m vt2=1m ropen=ropen_mix rclosed=rclosed_mix
EMIXQ_c016_0_11 (mix_q_src_c016_0_11 0 bpf_c016_0 0) vcvs gain=-9.807852804032e-01
SMIXQ_c016_0_11 (mix_q_src_c016_0_11 mix_q_c016_0 win_0_11 0) relay vt1=-1m vt2=1m ropen=ropen_mix rclosed=rclosed_mix
EMIXI_c016_0_12 (mix_i_src_c016_0_12 0 bpf_c016_0 0) vcvs gain=1.950903220161e-01
SMIXI_c016_0_12 (mix_i_src_c016_0_12 mix_i_c016_0 win_0_12 0) relay vt1=-1m vt2=1m ropen=ropen_mix rclosed=rclosed_mix
EMIXQ_c016_0_12 (mix_q_src_c016_0_12 0 bpf_c016_0 0) vcvs gain=-9.807852804032e-01
SMIXQ_c016_0_12 (mix_q_src_c016_0_12 mix_q_c016_0 win_0_12 0) relay vt1=-1m vt2=1m ropen=ropen_mix rclosed=rclosed_mix
EMIXI_c016_0_13 (mix_i_src_c016_0_13 0 bpf_c016_0 0) vcvs gain=5.555702330196e-01
SMIXI_c016_0_13 (mix_i_src_c016_0_13 mix_i_c016_0 win_0_13 0) relay vt1=-1m vt2=1m ropen=ropen_mix rclosed=rclosed_mix
EMIXQ_c016_0_13 (mix_q_src_c016_0_13 0 bpf_c016_0 0) vcvs gain=-8.314696123025e-01
SMIXQ_c016_0_13 (mix_q_src_c016_0_13 mix_q_c016_0 win_0_13 0) relay vt1=-1m vt2=1m ropen=ropen_mix rclosed=rclosed_mix
EMIXI_c016_0_14 (mix_i_src_c016_0_14 0 bpf_c016_0 0) vcvs gain=8.314696123025e-01
SMIXI_c016_0_14 (mix_i_src_c016_0_14 mix_i_c016_0 win_0_14 0) relay vt1=-1m vt2=1m ropen=ropen_mix rclosed=rclosed_mix
EMIXQ_c016_0_14 (mix_q_src_c016_0_14 0 bpf_c016_0 0) vcvs gain=-5.555702330196e-01
SMIXQ_c016_0_14 (mix_q_src_c016_0_14 mix_q_c016_0 win_0_14 0) relay vt1=-1m vt2=1m ropen=ropen_mix rclosed=rclosed_mix
EMIXI_c016_0_15 (mix_i_src_c016_0_15 0 bpf_c016_0 0) vcvs gain=9.807852804032e-01
SMIXI_c016_0_15 (mix_i_src_c016_0_15 mix_i_c016_0 win_0_15 0) relay vt1=-1m vt2=1m ropen=ropen_mix rclosed=rclosed_mix
EMIXQ_c016_0_15 (mix_q_src_c016_0_15 0 bpf_c016_0 0) vcvs gain=-1.950903220161e-01
SMIXQ_c016_0_15 (mix_q_src_c016_0_15 mix_q_c016_0 win_0_15 0) relay vt1=-1m vt2=1m ropen=ropen_mix rclosed=rclosed_mix
RMIXI_c016_0 (mix_i_c016_0 0) resistor r=1G
RMIXQ_c016_0 (mix_q_c016_0 0) resistor r=1G
RINTI_c016_0 (mix_i_c016_0 Icar_c016_0) resistor r=1k
CINTI_c016_0 (Icar_c016_0 0) capacitor c=80p
RINTQ_c016_0 (mix_q_c016_0 Qcar_c016_0) resistor r=1k
CINTQ_c016_0 (Qcar_c016_0 0) capacitor c=80p
save bpf_c016_0 Icar_c016_0 Qcar_c016_0

// bl016, carrier_1: 500000000 Hz coherent I/Q phase-window verification-demod path
CBPF_c016_1 (bl016 n_cbpf_c016_1) capacitor c=1.013211836423e-13
LBPF_c016_1 (n_cbpf_c016_1 bpf_c016_1) inductor l=1.000000000000e-06
RBPF_c016_1 (bpf_c016_1 0) resistor r=1.570796326795e+02
EMIXI_c016_1_00 (mix_i_src_c016_1_00 0 bpf_c016_1 0) vcvs gain=9.807852804032e-01
SMIXI_c016_1_00 (mix_i_src_c016_1_00 mix_i_c016_1 win_1_00 0) relay vt1=-1m vt2=1m ropen=ropen_mix rclosed=rclosed_mix
EMIXQ_c016_1_00 (mix_q_src_c016_1_00 0 bpf_c016_1 0) vcvs gain=1.950903220161e-01
SMIXQ_c016_1_00 (mix_q_src_c016_1_00 mix_q_c016_1 win_1_00 0) relay vt1=-1m vt2=1m ropen=ropen_mix rclosed=rclosed_mix
EMIXI_c016_1_01 (mix_i_src_c016_1_01 0 bpf_c016_1 0) vcvs gain=8.314696123025e-01
SMIXI_c016_1_01 (mix_i_src_c016_1_01 mix_i_c016_1 win_1_01 0) relay vt1=-1m vt2=1m ropen=ropen_mix rclosed=rclosed_mix
EMIXQ_c016_1_01 (mix_q_src_c016_1_01 0 bpf_c016_1 0) vcvs gain=5.555702330196e-01
SMIXQ_c016_1_01 (mix_q_src_c016_1_01 mix_q_c016_1 win_1_01 0) relay vt1=-1m vt2=1m ropen=ropen_mix rclosed=rclosed_mix
EMIXI_c016_1_02 (mix_i_src_c016_1_02 0 bpf_c016_1 0) vcvs gain=5.555702330196e-01
SMIXI_c016_1_02 (mix_i_src_c016_1_02 mix_i_c016_1 win_1_02 0) relay vt1=-1m vt2=1m ropen=ropen_mix rclosed=rclosed_mix
EMIXQ_c016_1_02 (mix_q_src_c016_1_02 0 bpf_c016_1 0) vcvs gain=8.314696123025e-01
SMIXQ_c016_1_02 (mix_q_src_c016_1_02 mix_q_c016_1 win_1_02 0) relay vt1=-1m vt2=1m ropen=ropen_mix rclosed=rclosed_mix
EMIXI_c016_1_03 (mix_i_src_c016_1_03 0 bpf_c016_1 0) vcvs gain=1.950903220161e-01
SMIXI_c016_1_03 (mix_i_src_c016_1_03 mix_i_c016_1 win_1_03 0) relay vt1=-1m vt2=1m ropen=ropen_mix rclosed=rclosed_mix
EMIXQ_c016_1_03 (mix_q_src_c016_1_03 0 bpf_c016_1 0) vcvs gain=9.807852804032e-01
SMIXQ_c016_1_03 (mix_q_src_c016_1_03 mix_q_c016_1 win_1_03 0) relay vt1=-1m vt2=1m ropen=ropen_mix rclosed=rclosed_mix
EMIXI_c016_1_04 (mix_i_src_c016_1_04 0 bpf_c016_1 0) vcvs gain=-1.950903220161e-01
SMIXI_c016_1_04 (mix_i_src_c016_1_04 mix_i_c016_1 win_1_04 0) relay vt1=-1m vt2=1m ropen=ropen_mix rclosed=rclosed_mix
EMIXQ_c016_1_04 (mix_q_src_c016_1_04 0 bpf_c016_1 0) vcvs gain=9.807852804032e-01
SMIXQ_c016_1_04 (mix_q_src_c016_1_04 mix_q_c016_1 win_1_04 0) relay vt1=-1m vt2=1m ropen=ropen_mix rclosed=rclosed_mix
EMIXI_c016_1_05 (mix_i_src_c016_1_05 0 bpf_c016_1 0) vcvs gain=-5.555702330196e-01
SMIXI_c016_1_05 (mix_i_src_c016_1_05 mix_i_c016_1 win_1_05 0) relay vt1=-1m vt2=1m ropen=ropen_mix rclosed=rclosed_mix
EMIXQ_c016_1_05 (mix_q_src_c016_1_05 0 bpf_c016_1 0) vcvs gain=8.314696123025e-01
SMIXQ_c016_1_05 (mix_q_src_c016_1_05 mix_q_c016_1 win_1_05 0) relay vt1=-1m vt2=1m ropen=ropen_mix rclosed=rclosed_mix
EMIXI_c016_1_06 (mix_i_src_c016_1_06 0 bpf_c016_1 0) vcvs gain=-8.314696123025e-01
SMIXI_c016_1_06 (mix_i_src_c016_1_06 mix_i_c016_1 win_1_06 0) relay vt1=-1m vt2=1m ropen=ropen_mix rclosed=rclosed_mix
EMIXQ_c016_1_06 (mix_q_src_c016_1_06 0 bpf_c016_1 0) vcvs gain=5.555702330196e-01
SMIXQ_c016_1_06 (mix_q_src_c016_1_06 mix_q_c016_1 win_1_06 0) relay vt1=-1m vt2=1m ropen=ropen_mix rclosed=rclosed_mix
EMIXI_c016_1_07 (mix_i_src_c016_1_07 0 bpf_c016_1 0) vcvs gain=-9.807852804032e-01
SMIXI_c016_1_07 (mix_i_src_c016_1_07 mix_i_c016_1 win_1_07 0) relay vt1=-1m vt2=1m ropen=ropen_mix rclosed=rclosed_mix
EMIXQ_c016_1_07 (mix_q_src_c016_1_07 0 bpf_c016_1 0) vcvs gain=1.950903220161e-01
SMIXQ_c016_1_07 (mix_q_src_c016_1_07 mix_q_c016_1 win_1_07 0) relay vt1=-1m vt2=1m ropen=ropen_mix rclosed=rclosed_mix
EMIXI_c016_1_08 (mix_i_src_c016_1_08 0 bpf_c016_1 0) vcvs gain=-9.807852804032e-01
SMIXI_c016_1_08 (mix_i_src_c016_1_08 mix_i_c016_1 win_1_08 0) relay vt1=-1m vt2=1m ropen=ropen_mix rclosed=rclosed_mix
EMIXQ_c016_1_08 (mix_q_src_c016_1_08 0 bpf_c016_1 0) vcvs gain=-1.950903220161e-01
SMIXQ_c016_1_08 (mix_q_src_c016_1_08 mix_q_c016_1 win_1_08 0) relay vt1=-1m vt2=1m ropen=ropen_mix rclosed=rclosed_mix
EMIXI_c016_1_09 (mix_i_src_c016_1_09 0 bpf_c016_1 0) vcvs gain=-8.314696123025e-01
SMIXI_c016_1_09 (mix_i_src_c016_1_09 mix_i_c016_1 win_1_09 0) relay vt1=-1m vt2=1m ropen=ropen_mix rclosed=rclosed_mix
EMIXQ_c016_1_09 (mix_q_src_c016_1_09 0 bpf_c016_1 0) vcvs gain=-5.555702330196e-01
SMIXQ_c016_1_09 (mix_q_src_c016_1_09 mix_q_c016_1 win_1_09 0) relay vt1=-1m vt2=1m ropen=ropen_mix rclosed=rclosed_mix
EMIXI_c016_1_10 (mix_i_src_c016_1_10 0 bpf_c016_1 0) vcvs gain=-5.555702330196e-01
SMIXI_c016_1_10 (mix_i_src_c016_1_10 mix_i_c016_1 win_1_10 0) relay vt1=-1m vt2=1m ropen=ropen_mix rclosed=rclosed_mix
EMIXQ_c016_1_10 (mix_q_src_c016_1_10 0 bpf_c016_1 0) vcvs gain=-8.314696123025e-01
SMIXQ_c016_1_10 (mix_q_src_c016_1_10 mix_q_c016_1 win_1_10 0) relay vt1=-1m vt2=1m ropen=ropen_mix rclosed=rclosed_mix
EMIXI_c016_1_11 (mix_i_src_c016_1_11 0 bpf_c016_1 0) vcvs gain=-1.950903220161e-01
SMIXI_c016_1_11 (mix_i_src_c016_1_11 mix_i_c016_1 win_1_11 0) relay vt1=-1m vt2=1m ropen=ropen_mix rclosed=rclosed_mix
EMIXQ_c016_1_11 (mix_q_src_c016_1_11 0 bpf_c016_1 0) vcvs gain=-9.807852804032e-01
SMIXQ_c016_1_11 (mix_q_src_c016_1_11 mix_q_c016_1 win_1_11 0) relay vt1=-1m vt2=1m ropen=ropen_mix rclosed=rclosed_mix
EMIXI_c016_1_12 (mix_i_src_c016_1_12 0 bpf_c016_1 0) vcvs gain=1.950903220161e-01
SMIXI_c016_1_12 (mix_i_src_c016_1_12 mix_i_c016_1 win_1_12 0) relay vt1=-1m vt2=1m ropen=ropen_mix rclosed=rclosed_mix
EMIXQ_c016_1_12 (mix_q_src_c016_1_12 0 bpf_c016_1 0) vcvs gain=-9.807852804032e-01
SMIXQ_c016_1_12 (mix_q_src_c016_1_12 mix_q_c016_1 win_1_12 0) relay vt1=-1m vt2=1m ropen=ropen_mix rclosed=rclosed_mix
EMIXI_c016_1_13 (mix_i_src_c016_1_13 0 bpf_c016_1 0) vcvs gain=5.555702330196e-01
SMIXI_c016_1_13 (mix_i_src_c016_1_13 mix_i_c016_1 win_1_13 0) relay vt1=-1m vt2=1m ropen=ropen_mix rclosed=rclosed_mix
EMIXQ_c016_1_13 (mix_q_src_c016_1_13 0 bpf_c016_1 0) vcvs gain=-8.314696123025e-01
SMIXQ_c016_1_13 (mix_q_src_c016_1_13 mix_q_c016_1 win_1_13 0) relay vt1=-1m vt2=1m ropen=ropen_mix rclosed=rclosed_mix
EMIXI_c016_1_14 (mix_i_src_c016_1_14 0 bpf_c016_1 0) vcvs gain=8.314696123025e-01
SMIXI_c016_1_14 (mix_i_src_c016_1_14 mix_i_c016_1 win_1_14 0) relay vt1=-1m vt2=1m ropen=ropen_mix rclosed=rclosed_mix
EMIXQ_c016_1_14 (mix_q_src_c016_1_14 0 bpf_c016_1 0) vcvs gain=-5.555702330196e-01
SMIXQ_c016_1_14 (mix_q_src_c016_1_14 mix_q_c016_1 win_1_14 0) relay vt1=-1m vt2=1m ropen=ropen_mix rclosed=rclosed_mix
EMIXI_c016_1_15 (mix_i_src_c016_1_15 0 bpf_c016_1 0) vcvs gain=9.807852804032e-01
SMIXI_c016_1_15 (mix_i_src_c016_1_15 mix_i_c016_1 win_1_15 0) relay vt1=-1m vt2=1m ropen=ropen_mix rclosed=rclosed_mix
EMIXQ_c016_1_15 (mix_q_src_c016_1_15 0 bpf_c016_1 0) vcvs gain=-1.950903220161e-01
SMIXQ_c016_1_15 (mix_q_src_c016_1_15 mix_q_c016_1 win_1_15 0) relay vt1=-1m vt2=1m ropen=ropen_mix rclosed=rclosed_mix
RMIXI_c016_1 (mix_i_c016_1 0) resistor r=1G
RMIXQ_c016_1 (mix_q_c016_1 0) resistor r=1G
RINTI_c016_1 (mix_i_c016_1 Icar_c016_1) resistor r=1k
CINTI_c016_1 (Icar_c016_1 0) capacitor c=80p
RINTQ_c016_1 (mix_q_c016_1 Qcar_c016_1) resistor r=1k
CINTQ_c016_1 (Qcar_c016_1 0) capacitor c=80p
save bpf_c016_1 Icar_c016_1 Qcar_c016_1

// bl016, carrier_2: 750000000 Hz coherent I/Q phase-window verification-demod path
CBPF_c016_2 (bl016 n_cbpf_c016_2) capacitor c=4.503163717437e-14
LBPF_c016_2 (n_cbpf_c016_2 bpf_c016_2) inductor l=1.000000000000e-06
RBPF_c016_2 (bpf_c016_2 0) resistor r=2.356194490192e+02
EMIXI_c016_2_00 (mix_i_src_c016_2_00 0 bpf_c016_2 0) vcvs gain=9.807852804032e-01
SMIXI_c016_2_00 (mix_i_src_c016_2_00 mix_i_c016_2 win_2_00 0) relay vt1=-1m vt2=1m ropen=ropen_mix rclosed=rclosed_mix
EMIXQ_c016_2_00 (mix_q_src_c016_2_00 0 bpf_c016_2 0) vcvs gain=1.950903220161e-01
SMIXQ_c016_2_00 (mix_q_src_c016_2_00 mix_q_c016_2 win_2_00 0) relay vt1=-1m vt2=1m ropen=ropen_mix rclosed=rclosed_mix
EMIXI_c016_2_01 (mix_i_src_c016_2_01 0 bpf_c016_2 0) vcvs gain=8.314696123025e-01
SMIXI_c016_2_01 (mix_i_src_c016_2_01 mix_i_c016_2 win_2_01 0) relay vt1=-1m vt2=1m ropen=ropen_mix rclosed=rclosed_mix
EMIXQ_c016_2_01 (mix_q_src_c016_2_01 0 bpf_c016_2 0) vcvs gain=5.555702330196e-01
SMIXQ_c016_2_01 (mix_q_src_c016_2_01 mix_q_c016_2 win_2_01 0) relay vt1=-1m vt2=1m ropen=ropen_mix rclosed=rclosed_mix
EMIXI_c016_2_02 (mix_i_src_c016_2_02 0 bpf_c016_2 0) vcvs gain=5.555702330196e-01
SMIXI_c016_2_02 (mix_i_src_c016_2_02 mix_i_c016_2 win_2_02 0) relay vt1=-1m vt2=1m ropen=ropen_mix rclosed=rclosed_mix
EMIXQ_c016_2_02 (mix_q_src_c016_2_02 0 bpf_c016_2 0) vcvs gain=8.314696123025e-01
SMIXQ_c016_2_02 (mix_q_src_c016_2_02 mix_q_c016_2 win_2_02 0) relay vt1=-1m vt2=1m ropen=ropen_mix rclosed=rclosed_mix
EMIXI_c016_2_03 (mix_i_src_c016_2_03 0 bpf_c016_2 0) vcvs gain=1.950903220161e-01
SMIXI_c016_2_03 (mix_i_src_c016_2_03 mix_i_c016_2 win_2_03 0) relay vt1=-1m vt2=1m ropen=ropen_mix rclosed=rclosed_mix
EMIXQ_c016_2_03 (mix_q_src_c016_2_03 0 bpf_c016_2 0) vcvs gain=9.807852804032e-01
SMIXQ_c016_2_03 (mix_q_src_c016_2_03 mix_q_c016_2 win_2_03 0) relay vt1=-1m vt2=1m ropen=ropen_mix rclosed=rclosed_mix
EMIXI_c016_2_04 (mix_i_src_c016_2_04 0 bpf_c016_2 0) vcvs gain=-1.950903220161e-01
SMIXI_c016_2_04 (mix_i_src_c016_2_04 mix_i_c016_2 win_2_04 0) relay vt1=-1m vt2=1m ropen=ropen_mix rclosed=rclosed_mix
EMIXQ_c016_2_04 (mix_q_src_c016_2_04 0 bpf_c016_2 0) vcvs gain=9.807852804032e-01
SMIXQ_c016_2_04 (mix_q_src_c016_2_04 mix_q_c016_2 win_2_04 0) relay vt1=-1m vt2=1m ropen=ropen_mix rclosed=rclosed_mix
EMIXI_c016_2_05 (mix_i_src_c016_2_05 0 bpf_c016_2 0) vcvs gain=-5.555702330196e-01
SMIXI_c016_2_05 (mix_i_src_c016_2_05 mix_i_c016_2 win_2_05 0) relay vt1=-1m vt2=1m ropen=ropen_mix rclosed=rclosed_mix
EMIXQ_c016_2_05 (mix_q_src_c016_2_05 0 bpf_c016_2 0) vcvs gain=8.314696123025e-01
SMIXQ_c016_2_05 (mix_q_src_c016_2_05 mix_q_c016_2 win_2_05 0) relay vt1=-1m vt2=1m ropen=ropen_mix rclosed=rclosed_mix
EMIXI_c016_2_06 (mix_i_src_c016_2_06 0 bpf_c016_2 0) vcvs gain=-8.314696123025e-01
SMIXI_c016_2_06 (mix_i_src_c016_2_06 mix_i_c016_2 win_2_06 0) relay vt1=-1m vt2=1m ropen=ropen_mix rclosed=rclosed_mix
EMIXQ_c016_2_06 (mix_q_src_c016_2_06 0 bpf_c016_2 0) vcvs gain=5.555702330196e-01
SMIXQ_c016_2_06 (mix_q_src_c016_2_06 mix_q_c016_2 win_2_06 0) relay vt1=-1m vt2=1m ropen=ropen_mix rclosed=rclosed_mix
EMIXI_c016_2_07 (mix_i_src_c016_2_07 0 bpf_c016_2 0) vcvs gain=-9.807852804032e-01
SMIXI_c016_2_07 (mix_i_src_c016_2_07 mix_i_c016_2 win_2_07 0) relay vt1=-1m vt2=1m ropen=ropen_mix rclosed=rclosed_mix
EMIXQ_c016_2_07 (mix_q_src_c016_2_07 0 bpf_c016_2 0) vcvs gain=1.950903220161e-01
SMIXQ_c016_2_07 (mix_q_src_c016_2_07 mix_q_c016_2 win_2_07 0) relay vt1=-1m vt2=1m ropen=ropen_mix rclosed=rclosed_mix
EMIXI_c016_2_08 (mix_i_src_c016_2_08 0 bpf_c016_2 0) vcvs gain=-9.807852804032e-01
SMIXI_c016_2_08 (mix_i_src_c016_2_08 mix_i_c016_2 win_2_08 0) relay vt1=-1m vt2=1m ropen=ropen_mix rclosed=rclosed_mix
EMIXQ_c016_2_08 (mix_q_src_c016_2_08 0 bpf_c016_2 0) vcvs gain=-1.950903220161e-01
SMIXQ_c016_2_08 (mix_q_src_c016_2_08 mix_q_c016_2 win_2_08 0) relay vt1=-1m vt2=1m ropen=ropen_mix rclosed=rclosed_mix
EMIXI_c016_2_09 (mix_i_src_c016_2_09 0 bpf_c016_2 0) vcvs gain=-8.314696123025e-01
SMIXI_c016_2_09 (mix_i_src_c016_2_09 mix_i_c016_2 win_2_09 0) relay vt1=-1m vt2=1m ropen=ropen_mix rclosed=rclosed_mix
EMIXQ_c016_2_09 (mix_q_src_c016_2_09 0 bpf_c016_2 0) vcvs gain=-5.555702330196e-01
SMIXQ_c016_2_09 (mix_q_src_c016_2_09 mix_q_c016_2 win_2_09 0) relay vt1=-1m vt2=1m ropen=ropen_mix rclosed=rclosed_mix
EMIXI_c016_2_10 (mix_i_src_c016_2_10 0 bpf_c016_2 0) vcvs gain=-5.555702330196e-01
SMIXI_c016_2_10 (mix_i_src_c016_2_10 mix_i_c016_2 win_2_10 0) relay vt1=-1m vt2=1m ropen=ropen_mix rclosed=rclosed_mix
EMIXQ_c016_2_10 (mix_q_src_c016_2_10 0 bpf_c016_2 0) vcvs gain=-8.314696123025e-01
SMIXQ_c016_2_10 (mix_q_src_c016_2_10 mix_q_c016_2 win_2_10 0) relay vt1=-1m vt2=1m ropen=ropen_mix rclosed=rclosed_mix
EMIXI_c016_2_11 (mix_i_src_c016_2_11 0 bpf_c016_2 0) vcvs gain=-1.950903220161e-01
SMIXI_c016_2_11 (mix_i_src_c016_2_11 mix_i_c016_2 win_2_11 0) relay vt1=-1m vt2=1m ropen=ropen_mix rclosed=rclosed_mix
EMIXQ_c016_2_11 (mix_q_src_c016_2_11 0 bpf_c016_2 0) vcvs gain=-9.807852804032e-01
SMIXQ_c016_2_11 (mix_q_src_c016_2_11 mix_q_c016_2 win_2_11 0) relay vt1=-1m vt2=1m ropen=ropen_mix rclosed=rclosed_mix
EMIXI_c016_2_12 (mix_i_src_c016_2_12 0 bpf_c016_2 0) vcvs gain=1.950903220161e-01
SMIXI_c016_2_12 (mix_i_src_c016_2_12 mix_i_c016_2 win_2_12 0) relay vt1=-1m vt2=1m ropen=ropen_mix rclosed=rclosed_mix
EMIXQ_c016_2_12 (mix_q_src_c016_2_12 0 bpf_c016_2 0) vcvs gain=-9.807852804032e-01
SMIXQ_c016_2_12 (mix_q_src_c016_2_12 mix_q_c016_2 win_2_12 0) relay vt1=-1m vt2=1m ropen=ropen_mix rclosed=rclosed_mix
EMIXI_c016_2_13 (mix_i_src_c016_2_13 0 bpf_c016_2 0) vcvs gain=5.555702330196e-01
SMIXI_c016_2_13 (mix_i_src_c016_2_13 mix_i_c016_2 win_2_13 0) relay vt1=-1m vt2=1m ropen=ropen_mix rclosed=rclosed_mix
EMIXQ_c016_2_13 (mix_q_src_c016_2_13 0 bpf_c016_2 0) vcvs gain=-8.314696123025e-01
SMIXQ_c016_2_13 (mix_q_src_c016_2_13 mix_q_c016_2 win_2_13 0) relay vt1=-1m vt2=1m ropen=ropen_mix rclosed=rclosed_mix
EMIXI_c016_2_14 (mix_i_src_c016_2_14 0 bpf_c016_2 0) vcvs gain=8.314696123025e-01
SMIXI_c016_2_14 (mix_i_src_c016_2_14 mix_i_c016_2 win_2_14 0) relay vt1=-1m vt2=1m ropen=ropen_mix rclosed=rclosed_mix
EMIXQ_c016_2_14 (mix_q_src_c016_2_14 0 bpf_c016_2 0) vcvs gain=-5.555702330196e-01
SMIXQ_c016_2_14 (mix_q_src_c016_2_14 mix_q_c016_2 win_2_14 0) relay vt1=-1m vt2=1m ropen=ropen_mix rclosed=rclosed_mix
EMIXI_c016_2_15 (mix_i_src_c016_2_15 0 bpf_c016_2 0) vcvs gain=9.807852804032e-01
SMIXI_c016_2_15 (mix_i_src_c016_2_15 mix_i_c016_2 win_2_15 0) relay vt1=-1m vt2=1m ropen=ropen_mix rclosed=rclosed_mix
EMIXQ_c016_2_15 (mix_q_src_c016_2_15 0 bpf_c016_2 0) vcvs gain=-1.950903220161e-01
SMIXQ_c016_2_15 (mix_q_src_c016_2_15 mix_q_c016_2 win_2_15 0) relay vt1=-1m vt2=1m ropen=ropen_mix rclosed=rclosed_mix
RMIXI_c016_2 (mix_i_c016_2 0) resistor r=1G
RMIXQ_c016_2 (mix_q_c016_2 0) resistor r=1G
RINTI_c016_2 (mix_i_c016_2 Icar_c016_2) resistor r=1k
CINTI_c016_2 (Icar_c016_2 0) capacitor c=80p
RINTQ_c016_2 (mix_q_c016_2 Qcar_c016_2) resistor r=1k
CINTQ_c016_2 (Qcar_c016_2 0) capacitor c=80p
save bpf_c016_2 Icar_c016_2 Qcar_c016_2

// bl016, carrier_3: 1000000000 Hz coherent I/Q phase-window verification-demod path
CBPF_c016_3 (bl016 n_cbpf_c016_3) capacitor c=2.533029591058e-14
LBPF_c016_3 (n_cbpf_c016_3 bpf_c016_3) inductor l=1.000000000000e-06
RBPF_c016_3 (bpf_c016_3 0) resistor r=3.141592653590e+02
EMIXI_c016_3_00 (mix_i_src_c016_3_00 0 bpf_c016_3 0) vcvs gain=9.807852804032e-01
SMIXI_c016_3_00 (mix_i_src_c016_3_00 mix_i_c016_3 win_3_00 0) relay vt1=-1m vt2=1m ropen=ropen_mix rclosed=rclosed_mix
EMIXQ_c016_3_00 (mix_q_src_c016_3_00 0 bpf_c016_3 0) vcvs gain=1.950903220161e-01
SMIXQ_c016_3_00 (mix_q_src_c016_3_00 mix_q_c016_3 win_3_00 0) relay vt1=-1m vt2=1m ropen=ropen_mix rclosed=rclosed_mix
EMIXI_c016_3_01 (mix_i_src_c016_3_01 0 bpf_c016_3 0) vcvs gain=8.314696123025e-01
SMIXI_c016_3_01 (mix_i_src_c016_3_01 mix_i_c016_3 win_3_01 0) relay vt1=-1m vt2=1m ropen=ropen_mix rclosed=rclosed_mix
EMIXQ_c016_3_01 (mix_q_src_c016_3_01 0 bpf_c016_3 0) vcvs gain=5.555702330196e-01
SMIXQ_c016_3_01 (mix_q_src_c016_3_01 mix_q_c016_3 win_3_01 0) relay vt1=-1m vt2=1m ropen=ropen_mix rclosed=rclosed_mix
EMIXI_c016_3_02 (mix_i_src_c016_3_02 0 bpf_c016_3 0) vcvs gain=5.555702330196e-01
SMIXI_c016_3_02 (mix_i_src_c016_3_02 mix_i_c016_3 win_3_02 0) relay vt1=-1m vt2=1m ropen=ropen_mix rclosed=rclosed_mix
EMIXQ_c016_3_02 (mix_q_src_c016_3_02 0 bpf_c016_3 0) vcvs gain=8.314696123025e-01
SMIXQ_c016_3_02 (mix_q_src_c016_3_02 mix_q_c016_3 win_3_02 0) relay vt1=-1m vt2=1m ropen=ropen_mix rclosed=rclosed_mix
EMIXI_c016_3_03 (mix_i_src_c016_3_03 0 bpf_c016_3 0) vcvs gain=1.950903220161e-01
SMIXI_c016_3_03 (mix_i_src_c016_3_03 mix_i_c016_3 win_3_03 0) relay vt1=-1m vt2=1m ropen=ropen_mix rclosed=rclosed_mix
EMIXQ_c016_3_03 (mix_q_src_c016_3_03 0 bpf_c016_3 0) vcvs gain=9.807852804032e-01
SMIXQ_c016_3_03 (mix_q_src_c016_3_03 mix_q_c016_3 win_3_03 0) relay vt1=-1m vt2=1m ropen=ropen_mix rclosed=rclosed_mix
EMIXI_c016_3_04 (mix_i_src_c016_3_04 0 bpf_c016_3 0) vcvs gain=-1.950903220161e-01
SMIXI_c016_3_04 (mix_i_src_c016_3_04 mix_i_c016_3 win_3_04 0) relay vt1=-1m vt2=1m ropen=ropen_mix rclosed=rclosed_mix
EMIXQ_c016_3_04 (mix_q_src_c016_3_04 0 bpf_c016_3 0) vcvs gain=9.807852804032e-01
SMIXQ_c016_3_04 (mix_q_src_c016_3_04 mix_q_c016_3 win_3_04 0) relay vt1=-1m vt2=1m ropen=ropen_mix rclosed=rclosed_mix
EMIXI_c016_3_05 (mix_i_src_c016_3_05 0 bpf_c016_3 0) vcvs gain=-5.555702330196e-01
SMIXI_c016_3_05 (mix_i_src_c016_3_05 mix_i_c016_3 win_3_05 0) relay vt1=-1m vt2=1m ropen=ropen_mix rclosed=rclosed_mix
EMIXQ_c016_3_05 (mix_q_src_c016_3_05 0 bpf_c016_3 0) vcvs gain=8.314696123025e-01
SMIXQ_c016_3_05 (mix_q_src_c016_3_05 mix_q_c016_3 win_3_05 0) relay vt1=-1m vt2=1m ropen=ropen_mix rclosed=rclosed_mix
EMIXI_c016_3_06 (mix_i_src_c016_3_06 0 bpf_c016_3 0) vcvs gain=-8.314696123025e-01
SMIXI_c016_3_06 (mix_i_src_c016_3_06 mix_i_c016_3 win_3_06 0) relay vt1=-1m vt2=1m ropen=ropen_mix rclosed=rclosed_mix
EMIXQ_c016_3_06 (mix_q_src_c016_3_06 0 bpf_c016_3 0) vcvs gain=5.555702330196e-01
SMIXQ_c016_3_06 (mix_q_src_c016_3_06 mix_q_c016_3 win_3_06 0) relay vt1=-1m vt2=1m ropen=ropen_mix rclosed=rclosed_mix
EMIXI_c016_3_07 (mix_i_src_c016_3_07 0 bpf_c016_3 0) vcvs gain=-9.807852804032e-01
SMIXI_c016_3_07 (mix_i_src_c016_3_07 mix_i_c016_3 win_3_07 0) relay vt1=-1m vt2=1m ropen=ropen_mix rclosed=rclosed_mix
EMIXQ_c016_3_07 (mix_q_src_c016_3_07 0 bpf_c016_3 0) vcvs gain=1.950903220161e-01
SMIXQ_c016_3_07 (mix_q_src_c016_3_07 mix_q_c016_3 win_3_07 0) relay vt1=-1m vt2=1m ropen=ropen_mix rclosed=rclosed_mix
EMIXI_c016_3_08 (mix_i_src_c016_3_08 0 bpf_c016_3 0) vcvs gain=-9.807852804032e-01
SMIXI_c016_3_08 (mix_i_src_c016_3_08 mix_i_c016_3 win_3_08 0) relay vt1=-1m vt2=1m ropen=ropen_mix rclosed=rclosed_mix
EMIXQ_c016_3_08 (mix_q_src_c016_3_08 0 bpf_c016_3 0) vcvs gain=-1.950903220161e-01
SMIXQ_c016_3_08 (mix_q_src_c016_3_08 mix_q_c016_3 win_3_08 0) relay vt1=-1m vt2=1m ropen=ropen_mix rclosed=rclosed_mix
EMIXI_c016_3_09 (mix_i_src_c016_3_09 0 bpf_c016_3 0) vcvs gain=-8.314696123025e-01
SMIXI_c016_3_09 (mix_i_src_c016_3_09 mix_i_c016_3 win_3_09 0) relay vt1=-1m vt2=1m ropen=ropen_mix rclosed=rclosed_mix
EMIXQ_c016_3_09 (mix_q_src_c016_3_09 0 bpf_c016_3 0) vcvs gain=-5.555702330196e-01
SMIXQ_c016_3_09 (mix_q_src_c016_3_09 mix_q_c016_3 win_3_09 0) relay vt1=-1m vt2=1m ropen=ropen_mix rclosed=rclosed_mix
EMIXI_c016_3_10 (mix_i_src_c016_3_10 0 bpf_c016_3 0) vcvs gain=-5.555702330196e-01
SMIXI_c016_3_10 (mix_i_src_c016_3_10 mix_i_c016_3 win_3_10 0) relay vt1=-1m vt2=1m ropen=ropen_mix rclosed=rclosed_mix
EMIXQ_c016_3_10 (mix_q_src_c016_3_10 0 bpf_c016_3 0) vcvs gain=-8.314696123025e-01
SMIXQ_c016_3_10 (mix_q_src_c016_3_10 mix_q_c016_3 win_3_10 0) relay vt1=-1m vt2=1m ropen=ropen_mix rclosed=rclosed_mix
EMIXI_c016_3_11 (mix_i_src_c016_3_11 0 bpf_c016_3 0) vcvs gain=-1.950903220161e-01
SMIXI_c016_3_11 (mix_i_src_c016_3_11 mix_i_c016_3 win_3_11 0) relay vt1=-1m vt2=1m ropen=ropen_mix rclosed=rclosed_mix
EMIXQ_c016_3_11 (mix_q_src_c016_3_11 0 bpf_c016_3 0) vcvs gain=-9.807852804032e-01
SMIXQ_c016_3_11 (mix_q_src_c016_3_11 mix_q_c016_3 win_3_11 0) relay vt1=-1m vt2=1m ropen=ropen_mix rclosed=rclosed_mix
EMIXI_c016_3_12 (mix_i_src_c016_3_12 0 bpf_c016_3 0) vcvs gain=1.950903220161e-01
SMIXI_c016_3_12 (mix_i_src_c016_3_12 mix_i_c016_3 win_3_12 0) relay vt1=-1m vt2=1m ropen=ropen_mix rclosed=rclosed_mix
EMIXQ_c016_3_12 (mix_q_src_c016_3_12 0 bpf_c016_3 0) vcvs gain=-9.807852804032e-01
SMIXQ_c016_3_12 (mix_q_src_c016_3_12 mix_q_c016_3 win_3_12 0) relay vt1=-1m vt2=1m ropen=ropen_mix rclosed=rclosed_mix
EMIXI_c016_3_13 (mix_i_src_c016_3_13 0 bpf_c016_3 0) vcvs gain=5.555702330196e-01
SMIXI_c016_3_13 (mix_i_src_c016_3_13 mix_i_c016_3 win_3_13 0) relay vt1=-1m vt2=1m ropen=ropen_mix rclosed=rclosed_mix
EMIXQ_c016_3_13 (mix_q_src_c016_3_13 0 bpf_c016_3 0) vcvs gain=-8.314696123025e-01
SMIXQ_c016_3_13 (mix_q_src_c016_3_13 mix_q_c016_3 win_3_13 0) relay vt1=-1m vt2=1m ropen=ropen_mix rclosed=rclosed_mix
EMIXI_c016_3_14 (mix_i_src_c016_3_14 0 bpf_c016_3 0) vcvs gain=8.314696123025e-01
SMIXI_c016_3_14 (mix_i_src_c016_3_14 mix_i_c016_3 win_3_14 0) relay vt1=-1m vt2=1m ropen=ropen_mix rclosed=rclosed_mix
EMIXQ_c016_3_14 (mix_q_src_c016_3_14 0 bpf_c016_3 0) vcvs gain=-5.555702330196e-01
SMIXQ_c016_3_14 (mix_q_src_c016_3_14 mix_q_c016_3 win_3_14 0) relay vt1=-1m vt2=1m ropen=ropen_mix rclosed=rclosed_mix
EMIXI_c016_3_15 (mix_i_src_c016_3_15 0 bpf_c016_3 0) vcvs gain=9.807852804032e-01
SMIXI_c016_3_15 (mix_i_src_c016_3_15 mix_i_c016_3 win_3_15 0) relay vt1=-1m vt2=1m ropen=ropen_mix rclosed=rclosed_mix
EMIXQ_c016_3_15 (mix_q_src_c016_3_15 0 bpf_c016_3 0) vcvs gain=-1.950903220161e-01
SMIXQ_c016_3_15 (mix_q_src_c016_3_15 mix_q_c016_3 win_3_15 0) relay vt1=-1m vt2=1m ropen=ropen_mix rclosed=rclosed_mix
RMIXI_c016_3 (mix_i_c016_3 0) resistor r=1G
RMIXQ_c016_3 (mix_q_c016_3 0) resistor r=1G
RINTI_c016_3 (mix_i_c016_3 Icar_c016_3) resistor r=1k
CINTI_c016_3 (Icar_c016_3 0) capacitor c=80p
RINTQ_c016_3 (mix_q_c016_3 Qcar_c016_3) resistor r=1k
CINTQ_c016_3 (Qcar_c016_3 0) capacitor c=80p
save bpf_c016_3 Icar_c016_3 Qcar_c016_3

// bl017, carrier_0: 250000000 Hz coherent I/Q phase-window verification-demod path
CBPF_c017_0 (bl017 n_cbpf_c017_0) capacitor c=4.052847345694e-13
LBPF_c017_0 (n_cbpf_c017_0 bpf_c017_0) inductor l=1.000000000000e-06
RBPF_c017_0 (bpf_c017_0 0) resistor r=7.853981633974e+01
EMIXI_c017_0_00 (mix_i_src_c017_0_00 0 bpf_c017_0 0) vcvs gain=9.807852804032e-01
SMIXI_c017_0_00 (mix_i_src_c017_0_00 mix_i_c017_0 win_0_00 0) relay vt1=-1m vt2=1m ropen=ropen_mix rclosed=rclosed_mix
EMIXQ_c017_0_00 (mix_q_src_c017_0_00 0 bpf_c017_0 0) vcvs gain=1.950903220161e-01
SMIXQ_c017_0_00 (mix_q_src_c017_0_00 mix_q_c017_0 win_0_00 0) relay vt1=-1m vt2=1m ropen=ropen_mix rclosed=rclosed_mix
EMIXI_c017_0_01 (mix_i_src_c017_0_01 0 bpf_c017_0 0) vcvs gain=8.314696123025e-01
SMIXI_c017_0_01 (mix_i_src_c017_0_01 mix_i_c017_0 win_0_01 0) relay vt1=-1m vt2=1m ropen=ropen_mix rclosed=rclosed_mix
EMIXQ_c017_0_01 (mix_q_src_c017_0_01 0 bpf_c017_0 0) vcvs gain=5.555702330196e-01
SMIXQ_c017_0_01 (mix_q_src_c017_0_01 mix_q_c017_0 win_0_01 0) relay vt1=-1m vt2=1m ropen=ropen_mix rclosed=rclosed_mix
EMIXI_c017_0_02 (mix_i_src_c017_0_02 0 bpf_c017_0 0) vcvs gain=5.555702330196e-01
SMIXI_c017_0_02 (mix_i_src_c017_0_02 mix_i_c017_0 win_0_02 0) relay vt1=-1m vt2=1m ropen=ropen_mix rclosed=rclosed_mix
EMIXQ_c017_0_02 (mix_q_src_c017_0_02 0 bpf_c017_0 0) vcvs gain=8.314696123025e-01
SMIXQ_c017_0_02 (mix_q_src_c017_0_02 mix_q_c017_0 win_0_02 0) relay vt1=-1m vt2=1m ropen=ropen_mix rclosed=rclosed_mix
EMIXI_c017_0_03 (mix_i_src_c017_0_03 0 bpf_c017_0 0) vcvs gain=1.950903220161e-01
SMIXI_c017_0_03 (mix_i_src_c017_0_03 mix_i_c017_0 win_0_03 0) relay vt1=-1m vt2=1m ropen=ropen_mix rclosed=rclosed_mix
EMIXQ_c017_0_03 (mix_q_src_c017_0_03 0 bpf_c017_0 0) vcvs gain=9.807852804032e-01
SMIXQ_c017_0_03 (mix_q_src_c017_0_03 mix_q_c017_0 win_0_03 0) relay vt1=-1m vt2=1m ropen=ropen_mix rclosed=rclosed_mix
EMIXI_c017_0_04 (mix_i_src_c017_0_04 0 bpf_c017_0 0) vcvs gain=-1.950903220161e-01
SMIXI_c017_0_04 (mix_i_src_c017_0_04 mix_i_c017_0 win_0_04 0) relay vt1=-1m vt2=1m ropen=ropen_mix rclosed=rclosed_mix
EMIXQ_c017_0_04 (mix_q_src_c017_0_04 0 bpf_c017_0 0) vcvs gain=9.807852804032e-01
SMIXQ_c017_0_04 (mix_q_src_c017_0_04 mix_q_c017_0 win_0_04 0) relay vt1=-1m vt2=1m ropen=ropen_mix rclosed=rclosed_mix
EMIXI_c017_0_05 (mix_i_src_c017_0_05 0 bpf_c017_0 0) vcvs gain=-5.555702330196e-01
SMIXI_c017_0_05 (mix_i_src_c017_0_05 mix_i_c017_0 win_0_05 0) relay vt1=-1m vt2=1m ropen=ropen_mix rclosed=rclosed_mix
EMIXQ_c017_0_05 (mix_q_src_c017_0_05 0 bpf_c017_0 0) vcvs gain=8.314696123025e-01
SMIXQ_c017_0_05 (mix_q_src_c017_0_05 mix_q_c017_0 win_0_05 0) relay vt1=-1m vt2=1m ropen=ropen_mix rclosed=rclosed_mix
EMIXI_c017_0_06 (mix_i_src_c017_0_06 0 bpf_c017_0 0) vcvs gain=-8.314696123025e-01
SMIXI_c017_0_06 (mix_i_src_c017_0_06 mix_i_c017_0 win_0_06 0) relay vt1=-1m vt2=1m ropen=ropen_mix rclosed=rclosed_mix
EMIXQ_c017_0_06 (mix_q_src_c017_0_06 0 bpf_c017_0 0) vcvs gain=5.555702330196e-01
SMIXQ_c017_0_06 (mix_q_src_c017_0_06 mix_q_c017_0 win_0_06 0) relay vt1=-1m vt2=1m ropen=ropen_mix rclosed=rclosed_mix
EMIXI_c017_0_07 (mix_i_src_c017_0_07 0 bpf_c017_0 0) vcvs gain=-9.807852804032e-01
SMIXI_c017_0_07 (mix_i_src_c017_0_07 mix_i_c017_0 win_0_07 0) relay vt1=-1m vt2=1m ropen=ropen_mix rclosed=rclosed_mix
EMIXQ_c017_0_07 (mix_q_src_c017_0_07 0 bpf_c017_0 0) vcvs gain=1.950903220161e-01
SMIXQ_c017_0_07 (mix_q_src_c017_0_07 mix_q_c017_0 win_0_07 0) relay vt1=-1m vt2=1m ropen=ropen_mix rclosed=rclosed_mix
EMIXI_c017_0_08 (mix_i_src_c017_0_08 0 bpf_c017_0 0) vcvs gain=-9.807852804032e-01
SMIXI_c017_0_08 (mix_i_src_c017_0_08 mix_i_c017_0 win_0_08 0) relay vt1=-1m vt2=1m ropen=ropen_mix rclosed=rclosed_mix
EMIXQ_c017_0_08 (mix_q_src_c017_0_08 0 bpf_c017_0 0) vcvs gain=-1.950903220161e-01
SMIXQ_c017_0_08 (mix_q_src_c017_0_08 mix_q_c017_0 win_0_08 0) relay vt1=-1m vt2=1m ropen=ropen_mix rclosed=rclosed_mix
EMIXI_c017_0_09 (mix_i_src_c017_0_09 0 bpf_c017_0 0) vcvs gain=-8.314696123025e-01
SMIXI_c017_0_09 (mix_i_src_c017_0_09 mix_i_c017_0 win_0_09 0) relay vt1=-1m vt2=1m ropen=ropen_mix rclosed=rclosed_mix
EMIXQ_c017_0_09 (mix_q_src_c017_0_09 0 bpf_c017_0 0) vcvs gain=-5.555702330196e-01
SMIXQ_c017_0_09 (mix_q_src_c017_0_09 mix_q_c017_0 win_0_09 0) relay vt1=-1m vt2=1m ropen=ropen_mix rclosed=rclosed_mix
EMIXI_c017_0_10 (mix_i_src_c017_0_10 0 bpf_c017_0 0) vcvs gain=-5.555702330196e-01
SMIXI_c017_0_10 (mix_i_src_c017_0_10 mix_i_c017_0 win_0_10 0) relay vt1=-1m vt2=1m ropen=ropen_mix rclosed=rclosed_mix
EMIXQ_c017_0_10 (mix_q_src_c017_0_10 0 bpf_c017_0 0) vcvs gain=-8.314696123025e-01
SMIXQ_c017_0_10 (mix_q_src_c017_0_10 mix_q_c017_0 win_0_10 0) relay vt1=-1m vt2=1m ropen=ropen_mix rclosed=rclosed_mix
EMIXI_c017_0_11 (mix_i_src_c017_0_11 0 bpf_c017_0 0) vcvs gain=-1.950903220161e-01
SMIXI_c017_0_11 (mix_i_src_c017_0_11 mix_i_c017_0 win_0_11 0) relay vt1=-1m vt2=1m ropen=ropen_mix rclosed=rclosed_mix
EMIXQ_c017_0_11 (mix_q_src_c017_0_11 0 bpf_c017_0 0) vcvs gain=-9.807852804032e-01
SMIXQ_c017_0_11 (mix_q_src_c017_0_11 mix_q_c017_0 win_0_11 0) relay vt1=-1m vt2=1m ropen=ropen_mix rclosed=rclosed_mix
EMIXI_c017_0_12 (mix_i_src_c017_0_12 0 bpf_c017_0 0) vcvs gain=1.950903220161e-01
SMIXI_c017_0_12 (mix_i_src_c017_0_12 mix_i_c017_0 win_0_12 0) relay vt1=-1m vt2=1m ropen=ropen_mix rclosed=rclosed_mix
EMIXQ_c017_0_12 (mix_q_src_c017_0_12 0 bpf_c017_0 0) vcvs gain=-9.807852804032e-01
SMIXQ_c017_0_12 (mix_q_src_c017_0_12 mix_q_c017_0 win_0_12 0) relay vt1=-1m vt2=1m ropen=ropen_mix rclosed=rclosed_mix
EMIXI_c017_0_13 (mix_i_src_c017_0_13 0 bpf_c017_0 0) vcvs gain=5.555702330196e-01
SMIXI_c017_0_13 (mix_i_src_c017_0_13 mix_i_c017_0 win_0_13 0) relay vt1=-1m vt2=1m ropen=ropen_mix rclosed=rclosed_mix
EMIXQ_c017_0_13 (mix_q_src_c017_0_13 0 bpf_c017_0 0) vcvs gain=-8.314696123025e-01
SMIXQ_c017_0_13 (mix_q_src_c017_0_13 mix_q_c017_0 win_0_13 0) relay vt1=-1m vt2=1m ropen=ropen_mix rclosed=rclosed_mix
EMIXI_c017_0_14 (mix_i_src_c017_0_14 0 bpf_c017_0 0) vcvs gain=8.314696123025e-01
SMIXI_c017_0_14 (mix_i_src_c017_0_14 mix_i_c017_0 win_0_14 0) relay vt1=-1m vt2=1m ropen=ropen_mix rclosed=rclosed_mix
EMIXQ_c017_0_14 (mix_q_src_c017_0_14 0 bpf_c017_0 0) vcvs gain=-5.555702330196e-01
SMIXQ_c017_0_14 (mix_q_src_c017_0_14 mix_q_c017_0 win_0_14 0) relay vt1=-1m vt2=1m ropen=ropen_mix rclosed=rclosed_mix
EMIXI_c017_0_15 (mix_i_src_c017_0_15 0 bpf_c017_0 0) vcvs gain=9.807852804032e-01
SMIXI_c017_0_15 (mix_i_src_c017_0_15 mix_i_c017_0 win_0_15 0) relay vt1=-1m vt2=1m ropen=ropen_mix rclosed=rclosed_mix
EMIXQ_c017_0_15 (mix_q_src_c017_0_15 0 bpf_c017_0 0) vcvs gain=-1.950903220161e-01
SMIXQ_c017_0_15 (mix_q_src_c017_0_15 mix_q_c017_0 win_0_15 0) relay vt1=-1m vt2=1m ropen=ropen_mix rclosed=rclosed_mix
RMIXI_c017_0 (mix_i_c017_0 0) resistor r=1G
RMIXQ_c017_0 (mix_q_c017_0 0) resistor r=1G
RINTI_c017_0 (mix_i_c017_0 Icar_c017_0) resistor r=1k
CINTI_c017_0 (Icar_c017_0 0) capacitor c=80p
RINTQ_c017_0 (mix_q_c017_0 Qcar_c017_0) resistor r=1k
CINTQ_c017_0 (Qcar_c017_0 0) capacitor c=80p
save bpf_c017_0 Icar_c017_0 Qcar_c017_0

// bl017, carrier_1: 500000000 Hz coherent I/Q phase-window verification-demod path
CBPF_c017_1 (bl017 n_cbpf_c017_1) capacitor c=1.013211836423e-13
LBPF_c017_1 (n_cbpf_c017_1 bpf_c017_1) inductor l=1.000000000000e-06
RBPF_c017_1 (bpf_c017_1 0) resistor r=1.570796326795e+02
EMIXI_c017_1_00 (mix_i_src_c017_1_00 0 bpf_c017_1 0) vcvs gain=9.807852804032e-01
SMIXI_c017_1_00 (mix_i_src_c017_1_00 mix_i_c017_1 win_1_00 0) relay vt1=-1m vt2=1m ropen=ropen_mix rclosed=rclosed_mix
EMIXQ_c017_1_00 (mix_q_src_c017_1_00 0 bpf_c017_1 0) vcvs gain=1.950903220161e-01
SMIXQ_c017_1_00 (mix_q_src_c017_1_00 mix_q_c017_1 win_1_00 0) relay vt1=-1m vt2=1m ropen=ropen_mix rclosed=rclosed_mix
EMIXI_c017_1_01 (mix_i_src_c017_1_01 0 bpf_c017_1 0) vcvs gain=8.314696123025e-01
SMIXI_c017_1_01 (mix_i_src_c017_1_01 mix_i_c017_1 win_1_01 0) relay vt1=-1m vt2=1m ropen=ropen_mix rclosed=rclosed_mix
EMIXQ_c017_1_01 (mix_q_src_c017_1_01 0 bpf_c017_1 0) vcvs gain=5.555702330196e-01
SMIXQ_c017_1_01 (mix_q_src_c017_1_01 mix_q_c017_1 win_1_01 0) relay vt1=-1m vt2=1m ropen=ropen_mix rclosed=rclosed_mix
EMIXI_c017_1_02 (mix_i_src_c017_1_02 0 bpf_c017_1 0) vcvs gain=5.555702330196e-01
SMIXI_c017_1_02 (mix_i_src_c017_1_02 mix_i_c017_1 win_1_02 0) relay vt1=-1m vt2=1m ropen=ropen_mix rclosed=rclosed_mix
EMIXQ_c017_1_02 (mix_q_src_c017_1_02 0 bpf_c017_1 0) vcvs gain=8.314696123025e-01
SMIXQ_c017_1_02 (mix_q_src_c017_1_02 mix_q_c017_1 win_1_02 0) relay vt1=-1m vt2=1m ropen=ropen_mix rclosed=rclosed_mix
EMIXI_c017_1_03 (mix_i_src_c017_1_03 0 bpf_c017_1 0) vcvs gain=1.950903220161e-01
SMIXI_c017_1_03 (mix_i_src_c017_1_03 mix_i_c017_1 win_1_03 0) relay vt1=-1m vt2=1m ropen=ropen_mix rclosed=rclosed_mix
EMIXQ_c017_1_03 (mix_q_src_c017_1_03 0 bpf_c017_1 0) vcvs gain=9.807852804032e-01
SMIXQ_c017_1_03 (mix_q_src_c017_1_03 mix_q_c017_1 win_1_03 0) relay vt1=-1m vt2=1m ropen=ropen_mix rclosed=rclosed_mix
EMIXI_c017_1_04 (mix_i_src_c017_1_04 0 bpf_c017_1 0) vcvs gain=-1.950903220161e-01
SMIXI_c017_1_04 (mix_i_src_c017_1_04 mix_i_c017_1 win_1_04 0) relay vt1=-1m vt2=1m ropen=ropen_mix rclosed=rclosed_mix
EMIXQ_c017_1_04 (mix_q_src_c017_1_04 0 bpf_c017_1 0) vcvs gain=9.807852804032e-01
SMIXQ_c017_1_04 (mix_q_src_c017_1_04 mix_q_c017_1 win_1_04 0) relay vt1=-1m vt2=1m ropen=ropen_mix rclosed=rclosed_mix
EMIXI_c017_1_05 (mix_i_src_c017_1_05 0 bpf_c017_1 0) vcvs gain=-5.555702330196e-01
SMIXI_c017_1_05 (mix_i_src_c017_1_05 mix_i_c017_1 win_1_05 0) relay vt1=-1m vt2=1m ropen=ropen_mix rclosed=rclosed_mix
EMIXQ_c017_1_05 (mix_q_src_c017_1_05 0 bpf_c017_1 0) vcvs gain=8.314696123025e-01
SMIXQ_c017_1_05 (mix_q_src_c017_1_05 mix_q_c017_1 win_1_05 0) relay vt1=-1m vt2=1m ropen=ropen_mix rclosed=rclosed_mix
EMIXI_c017_1_06 (mix_i_src_c017_1_06 0 bpf_c017_1 0) vcvs gain=-8.314696123025e-01
SMIXI_c017_1_06 (mix_i_src_c017_1_06 mix_i_c017_1 win_1_06 0) relay vt1=-1m vt2=1m ropen=ropen_mix rclosed=rclosed_mix
EMIXQ_c017_1_06 (mix_q_src_c017_1_06 0 bpf_c017_1 0) vcvs gain=5.555702330196e-01
SMIXQ_c017_1_06 (mix_q_src_c017_1_06 mix_q_c017_1 win_1_06 0) relay vt1=-1m vt2=1m ropen=ropen_mix rclosed=rclosed_mix
EMIXI_c017_1_07 (mix_i_src_c017_1_07 0 bpf_c017_1 0) vcvs gain=-9.807852804032e-01
SMIXI_c017_1_07 (mix_i_src_c017_1_07 mix_i_c017_1 win_1_07 0) relay vt1=-1m vt2=1m ropen=ropen_mix rclosed=rclosed_mix
EMIXQ_c017_1_07 (mix_q_src_c017_1_07 0 bpf_c017_1 0) vcvs gain=1.950903220161e-01
SMIXQ_c017_1_07 (mix_q_src_c017_1_07 mix_q_c017_1 win_1_07 0) relay vt1=-1m vt2=1m ropen=ropen_mix rclosed=rclosed_mix
EMIXI_c017_1_08 (mix_i_src_c017_1_08 0 bpf_c017_1 0) vcvs gain=-9.807852804032e-01
SMIXI_c017_1_08 (mix_i_src_c017_1_08 mix_i_c017_1 win_1_08 0) relay vt1=-1m vt2=1m ropen=ropen_mix rclosed=rclosed_mix
EMIXQ_c017_1_08 (mix_q_src_c017_1_08 0 bpf_c017_1 0) vcvs gain=-1.950903220161e-01
SMIXQ_c017_1_08 (mix_q_src_c017_1_08 mix_q_c017_1 win_1_08 0) relay vt1=-1m vt2=1m ropen=ropen_mix rclosed=rclosed_mix
EMIXI_c017_1_09 (mix_i_src_c017_1_09 0 bpf_c017_1 0) vcvs gain=-8.314696123025e-01
SMIXI_c017_1_09 (mix_i_src_c017_1_09 mix_i_c017_1 win_1_09 0) relay vt1=-1m vt2=1m ropen=ropen_mix rclosed=rclosed_mix
EMIXQ_c017_1_09 (mix_q_src_c017_1_09 0 bpf_c017_1 0) vcvs gain=-5.555702330196e-01
SMIXQ_c017_1_09 (mix_q_src_c017_1_09 mix_q_c017_1 win_1_09 0) relay vt1=-1m vt2=1m ropen=ropen_mix rclosed=rclosed_mix
EMIXI_c017_1_10 (mix_i_src_c017_1_10 0 bpf_c017_1 0) vcvs gain=-5.555702330196e-01
SMIXI_c017_1_10 (mix_i_src_c017_1_10 mix_i_c017_1 win_1_10 0) relay vt1=-1m vt2=1m ropen=ropen_mix rclosed=rclosed_mix
EMIXQ_c017_1_10 (mix_q_src_c017_1_10 0 bpf_c017_1 0) vcvs gain=-8.314696123025e-01
SMIXQ_c017_1_10 (mix_q_src_c017_1_10 mix_q_c017_1 win_1_10 0) relay vt1=-1m vt2=1m ropen=ropen_mix rclosed=rclosed_mix
EMIXI_c017_1_11 (mix_i_src_c017_1_11 0 bpf_c017_1 0) vcvs gain=-1.950903220161e-01
SMIXI_c017_1_11 (mix_i_src_c017_1_11 mix_i_c017_1 win_1_11 0) relay vt1=-1m vt2=1m ropen=ropen_mix rclosed=rclosed_mix
EMIXQ_c017_1_11 (mix_q_src_c017_1_11 0 bpf_c017_1 0) vcvs gain=-9.807852804032e-01
SMIXQ_c017_1_11 (mix_q_src_c017_1_11 mix_q_c017_1 win_1_11 0) relay vt1=-1m vt2=1m ropen=ropen_mix rclosed=rclosed_mix
EMIXI_c017_1_12 (mix_i_src_c017_1_12 0 bpf_c017_1 0) vcvs gain=1.950903220161e-01
SMIXI_c017_1_12 (mix_i_src_c017_1_12 mix_i_c017_1 win_1_12 0) relay vt1=-1m vt2=1m ropen=ropen_mix rclosed=rclosed_mix
EMIXQ_c017_1_12 (mix_q_src_c017_1_12 0 bpf_c017_1 0) vcvs gain=-9.807852804032e-01
SMIXQ_c017_1_12 (mix_q_src_c017_1_12 mix_q_c017_1 win_1_12 0) relay vt1=-1m vt2=1m ropen=ropen_mix rclosed=rclosed_mix
EMIXI_c017_1_13 (mix_i_src_c017_1_13 0 bpf_c017_1 0) vcvs gain=5.555702330196e-01
SMIXI_c017_1_13 (mix_i_src_c017_1_13 mix_i_c017_1 win_1_13 0) relay vt1=-1m vt2=1m ropen=ropen_mix rclosed=rclosed_mix
EMIXQ_c017_1_13 (mix_q_src_c017_1_13 0 bpf_c017_1 0) vcvs gain=-8.314696123025e-01
SMIXQ_c017_1_13 (mix_q_src_c017_1_13 mix_q_c017_1 win_1_13 0) relay vt1=-1m vt2=1m ropen=ropen_mix rclosed=rclosed_mix
EMIXI_c017_1_14 (mix_i_src_c017_1_14 0 bpf_c017_1 0) vcvs gain=8.314696123025e-01
SMIXI_c017_1_14 (mix_i_src_c017_1_14 mix_i_c017_1 win_1_14 0) relay vt1=-1m vt2=1m ropen=ropen_mix rclosed=rclosed_mix
EMIXQ_c017_1_14 (mix_q_src_c017_1_14 0 bpf_c017_1 0) vcvs gain=-5.555702330196e-01
SMIXQ_c017_1_14 (mix_q_src_c017_1_14 mix_q_c017_1 win_1_14 0) relay vt1=-1m vt2=1m ropen=ropen_mix rclosed=rclosed_mix
EMIXI_c017_1_15 (mix_i_src_c017_1_15 0 bpf_c017_1 0) vcvs gain=9.807852804032e-01
SMIXI_c017_1_15 (mix_i_src_c017_1_15 mix_i_c017_1 win_1_15 0) relay vt1=-1m vt2=1m ropen=ropen_mix rclosed=rclosed_mix
EMIXQ_c017_1_15 (mix_q_src_c017_1_15 0 bpf_c017_1 0) vcvs gain=-1.950903220161e-01
SMIXQ_c017_1_15 (mix_q_src_c017_1_15 mix_q_c017_1 win_1_15 0) relay vt1=-1m vt2=1m ropen=ropen_mix rclosed=rclosed_mix
RMIXI_c017_1 (mix_i_c017_1 0) resistor r=1G
RMIXQ_c017_1 (mix_q_c017_1 0) resistor r=1G
RINTI_c017_1 (mix_i_c017_1 Icar_c017_1) resistor r=1k
CINTI_c017_1 (Icar_c017_1 0) capacitor c=80p
RINTQ_c017_1 (mix_q_c017_1 Qcar_c017_1) resistor r=1k
CINTQ_c017_1 (Qcar_c017_1 0) capacitor c=80p
save bpf_c017_1 Icar_c017_1 Qcar_c017_1

// bl017, carrier_2: 750000000 Hz coherent I/Q phase-window verification-demod path
CBPF_c017_2 (bl017 n_cbpf_c017_2) capacitor c=4.503163717437e-14
LBPF_c017_2 (n_cbpf_c017_2 bpf_c017_2) inductor l=1.000000000000e-06
RBPF_c017_2 (bpf_c017_2 0) resistor r=2.356194490192e+02
EMIXI_c017_2_00 (mix_i_src_c017_2_00 0 bpf_c017_2 0) vcvs gain=9.807852804032e-01
SMIXI_c017_2_00 (mix_i_src_c017_2_00 mix_i_c017_2 win_2_00 0) relay vt1=-1m vt2=1m ropen=ropen_mix rclosed=rclosed_mix
EMIXQ_c017_2_00 (mix_q_src_c017_2_00 0 bpf_c017_2 0) vcvs gain=1.950903220161e-01
SMIXQ_c017_2_00 (mix_q_src_c017_2_00 mix_q_c017_2 win_2_00 0) relay vt1=-1m vt2=1m ropen=ropen_mix rclosed=rclosed_mix
EMIXI_c017_2_01 (mix_i_src_c017_2_01 0 bpf_c017_2 0) vcvs gain=8.314696123025e-01
SMIXI_c017_2_01 (mix_i_src_c017_2_01 mix_i_c017_2 win_2_01 0) relay vt1=-1m vt2=1m ropen=ropen_mix rclosed=rclosed_mix
EMIXQ_c017_2_01 (mix_q_src_c017_2_01 0 bpf_c017_2 0) vcvs gain=5.555702330196e-01
SMIXQ_c017_2_01 (mix_q_src_c017_2_01 mix_q_c017_2 win_2_01 0) relay vt1=-1m vt2=1m ropen=ropen_mix rclosed=rclosed_mix
EMIXI_c017_2_02 (mix_i_src_c017_2_02 0 bpf_c017_2 0) vcvs gain=5.555702330196e-01
SMIXI_c017_2_02 (mix_i_src_c017_2_02 mix_i_c017_2 win_2_02 0) relay vt1=-1m vt2=1m ropen=ropen_mix rclosed=rclosed_mix
EMIXQ_c017_2_02 (mix_q_src_c017_2_02 0 bpf_c017_2 0) vcvs gain=8.314696123025e-01
SMIXQ_c017_2_02 (mix_q_src_c017_2_02 mix_q_c017_2 win_2_02 0) relay vt1=-1m vt2=1m ropen=ropen_mix rclosed=rclosed_mix
EMIXI_c017_2_03 (mix_i_src_c017_2_03 0 bpf_c017_2 0) vcvs gain=1.950903220161e-01
SMIXI_c017_2_03 (mix_i_src_c017_2_03 mix_i_c017_2 win_2_03 0) relay vt1=-1m vt2=1m ropen=ropen_mix rclosed=rclosed_mix
EMIXQ_c017_2_03 (mix_q_src_c017_2_03 0 bpf_c017_2 0) vcvs gain=9.807852804032e-01
SMIXQ_c017_2_03 (mix_q_src_c017_2_03 mix_q_c017_2 win_2_03 0) relay vt1=-1m vt2=1m ropen=ropen_mix rclosed=rclosed_mix
EMIXI_c017_2_04 (mix_i_src_c017_2_04 0 bpf_c017_2 0) vcvs gain=-1.950903220161e-01
SMIXI_c017_2_04 (mix_i_src_c017_2_04 mix_i_c017_2 win_2_04 0) relay vt1=-1m vt2=1m ropen=ropen_mix rclosed=rclosed_mix
EMIXQ_c017_2_04 (mix_q_src_c017_2_04 0 bpf_c017_2 0) vcvs gain=9.807852804032e-01
SMIXQ_c017_2_04 (mix_q_src_c017_2_04 mix_q_c017_2 win_2_04 0) relay vt1=-1m vt2=1m ropen=ropen_mix rclosed=rclosed_mix
EMIXI_c017_2_05 (mix_i_src_c017_2_05 0 bpf_c017_2 0) vcvs gain=-5.555702330196e-01
SMIXI_c017_2_05 (mix_i_src_c017_2_05 mix_i_c017_2 win_2_05 0) relay vt1=-1m vt2=1m ropen=ropen_mix rclosed=rclosed_mix
EMIXQ_c017_2_05 (mix_q_src_c017_2_05 0 bpf_c017_2 0) vcvs gain=8.314696123025e-01
SMIXQ_c017_2_05 (mix_q_src_c017_2_05 mix_q_c017_2 win_2_05 0) relay vt1=-1m vt2=1m ropen=ropen_mix rclosed=rclosed_mix
EMIXI_c017_2_06 (mix_i_src_c017_2_06 0 bpf_c017_2 0) vcvs gain=-8.314696123025e-01
SMIXI_c017_2_06 (mix_i_src_c017_2_06 mix_i_c017_2 win_2_06 0) relay vt1=-1m vt2=1m ropen=ropen_mix rclosed=rclosed_mix
EMIXQ_c017_2_06 (mix_q_src_c017_2_06 0 bpf_c017_2 0) vcvs gain=5.555702330196e-01
SMIXQ_c017_2_06 (mix_q_src_c017_2_06 mix_q_c017_2 win_2_06 0) relay vt1=-1m vt2=1m ropen=ropen_mix rclosed=rclosed_mix
EMIXI_c017_2_07 (mix_i_src_c017_2_07 0 bpf_c017_2 0) vcvs gain=-9.807852804032e-01
SMIXI_c017_2_07 (mix_i_src_c017_2_07 mix_i_c017_2 win_2_07 0) relay vt1=-1m vt2=1m ropen=ropen_mix rclosed=rclosed_mix
EMIXQ_c017_2_07 (mix_q_src_c017_2_07 0 bpf_c017_2 0) vcvs gain=1.950903220161e-01
SMIXQ_c017_2_07 (mix_q_src_c017_2_07 mix_q_c017_2 win_2_07 0) relay vt1=-1m vt2=1m ropen=ropen_mix rclosed=rclosed_mix
EMIXI_c017_2_08 (mix_i_src_c017_2_08 0 bpf_c017_2 0) vcvs gain=-9.807852804032e-01
SMIXI_c017_2_08 (mix_i_src_c017_2_08 mix_i_c017_2 win_2_08 0) relay vt1=-1m vt2=1m ropen=ropen_mix rclosed=rclosed_mix
EMIXQ_c017_2_08 (mix_q_src_c017_2_08 0 bpf_c017_2 0) vcvs gain=-1.950903220161e-01
SMIXQ_c017_2_08 (mix_q_src_c017_2_08 mix_q_c017_2 win_2_08 0) relay vt1=-1m vt2=1m ropen=ropen_mix rclosed=rclosed_mix
EMIXI_c017_2_09 (mix_i_src_c017_2_09 0 bpf_c017_2 0) vcvs gain=-8.314696123025e-01
SMIXI_c017_2_09 (mix_i_src_c017_2_09 mix_i_c017_2 win_2_09 0) relay vt1=-1m vt2=1m ropen=ropen_mix rclosed=rclosed_mix
EMIXQ_c017_2_09 (mix_q_src_c017_2_09 0 bpf_c017_2 0) vcvs gain=-5.555702330196e-01
SMIXQ_c017_2_09 (mix_q_src_c017_2_09 mix_q_c017_2 win_2_09 0) relay vt1=-1m vt2=1m ropen=ropen_mix rclosed=rclosed_mix
EMIXI_c017_2_10 (mix_i_src_c017_2_10 0 bpf_c017_2 0) vcvs gain=-5.555702330196e-01
SMIXI_c017_2_10 (mix_i_src_c017_2_10 mix_i_c017_2 win_2_10 0) relay vt1=-1m vt2=1m ropen=ropen_mix rclosed=rclosed_mix
EMIXQ_c017_2_10 (mix_q_src_c017_2_10 0 bpf_c017_2 0) vcvs gain=-8.314696123025e-01
SMIXQ_c017_2_10 (mix_q_src_c017_2_10 mix_q_c017_2 win_2_10 0) relay vt1=-1m vt2=1m ropen=ropen_mix rclosed=rclosed_mix
EMIXI_c017_2_11 (mix_i_src_c017_2_11 0 bpf_c017_2 0) vcvs gain=-1.950903220161e-01
SMIXI_c017_2_11 (mix_i_src_c017_2_11 mix_i_c017_2 win_2_11 0) relay vt1=-1m vt2=1m ropen=ropen_mix rclosed=rclosed_mix
EMIXQ_c017_2_11 (mix_q_src_c017_2_11 0 bpf_c017_2 0) vcvs gain=-9.807852804032e-01
SMIXQ_c017_2_11 (mix_q_src_c017_2_11 mix_q_c017_2 win_2_11 0) relay vt1=-1m vt2=1m ropen=ropen_mix rclosed=rclosed_mix
EMIXI_c017_2_12 (mix_i_src_c017_2_12 0 bpf_c017_2 0) vcvs gain=1.950903220161e-01
SMIXI_c017_2_12 (mix_i_src_c017_2_12 mix_i_c017_2 win_2_12 0) relay vt1=-1m vt2=1m ropen=ropen_mix rclosed=rclosed_mix
EMIXQ_c017_2_12 (mix_q_src_c017_2_12 0 bpf_c017_2 0) vcvs gain=-9.807852804032e-01
SMIXQ_c017_2_12 (mix_q_src_c017_2_12 mix_q_c017_2 win_2_12 0) relay vt1=-1m vt2=1m ropen=ropen_mix rclosed=rclosed_mix
EMIXI_c017_2_13 (mix_i_src_c017_2_13 0 bpf_c017_2 0) vcvs gain=5.555702330196e-01
SMIXI_c017_2_13 (mix_i_src_c017_2_13 mix_i_c017_2 win_2_13 0) relay vt1=-1m vt2=1m ropen=ropen_mix rclosed=rclosed_mix
EMIXQ_c017_2_13 (mix_q_src_c017_2_13 0 bpf_c017_2 0) vcvs gain=-8.314696123025e-01
SMIXQ_c017_2_13 (mix_q_src_c017_2_13 mix_q_c017_2 win_2_13 0) relay vt1=-1m vt2=1m ropen=ropen_mix rclosed=rclosed_mix
EMIXI_c017_2_14 (mix_i_src_c017_2_14 0 bpf_c017_2 0) vcvs gain=8.314696123025e-01
SMIXI_c017_2_14 (mix_i_src_c017_2_14 mix_i_c017_2 win_2_14 0) relay vt1=-1m vt2=1m ropen=ropen_mix rclosed=rclosed_mix
EMIXQ_c017_2_14 (mix_q_src_c017_2_14 0 bpf_c017_2 0) vcvs gain=-5.555702330196e-01
SMIXQ_c017_2_14 (mix_q_src_c017_2_14 mix_q_c017_2 win_2_14 0) relay vt1=-1m vt2=1m ropen=ropen_mix rclosed=rclosed_mix
EMIXI_c017_2_15 (mix_i_src_c017_2_15 0 bpf_c017_2 0) vcvs gain=9.807852804032e-01
SMIXI_c017_2_15 (mix_i_src_c017_2_15 mix_i_c017_2 win_2_15 0) relay vt1=-1m vt2=1m ropen=ropen_mix rclosed=rclosed_mix
EMIXQ_c017_2_15 (mix_q_src_c017_2_15 0 bpf_c017_2 0) vcvs gain=-1.950903220161e-01
SMIXQ_c017_2_15 (mix_q_src_c017_2_15 mix_q_c017_2 win_2_15 0) relay vt1=-1m vt2=1m ropen=ropen_mix rclosed=rclosed_mix
RMIXI_c017_2 (mix_i_c017_2 0) resistor r=1G
RMIXQ_c017_2 (mix_q_c017_2 0) resistor r=1G
RINTI_c017_2 (mix_i_c017_2 Icar_c017_2) resistor r=1k
CINTI_c017_2 (Icar_c017_2 0) capacitor c=80p
RINTQ_c017_2 (mix_q_c017_2 Qcar_c017_2) resistor r=1k
CINTQ_c017_2 (Qcar_c017_2 0) capacitor c=80p
save bpf_c017_2 Icar_c017_2 Qcar_c017_2

// bl017, carrier_3: 1000000000 Hz coherent I/Q phase-window verification-demod path
CBPF_c017_3 (bl017 n_cbpf_c017_3) capacitor c=2.533029591058e-14
LBPF_c017_3 (n_cbpf_c017_3 bpf_c017_3) inductor l=1.000000000000e-06
RBPF_c017_3 (bpf_c017_3 0) resistor r=3.141592653590e+02
EMIXI_c017_3_00 (mix_i_src_c017_3_00 0 bpf_c017_3 0) vcvs gain=9.807852804032e-01
SMIXI_c017_3_00 (mix_i_src_c017_3_00 mix_i_c017_3 win_3_00 0) relay vt1=-1m vt2=1m ropen=ropen_mix rclosed=rclosed_mix
EMIXQ_c017_3_00 (mix_q_src_c017_3_00 0 bpf_c017_3 0) vcvs gain=1.950903220161e-01
SMIXQ_c017_3_00 (mix_q_src_c017_3_00 mix_q_c017_3 win_3_00 0) relay vt1=-1m vt2=1m ropen=ropen_mix rclosed=rclosed_mix
EMIXI_c017_3_01 (mix_i_src_c017_3_01 0 bpf_c017_3 0) vcvs gain=8.314696123025e-01
SMIXI_c017_3_01 (mix_i_src_c017_3_01 mix_i_c017_3 win_3_01 0) relay vt1=-1m vt2=1m ropen=ropen_mix rclosed=rclosed_mix
EMIXQ_c017_3_01 (mix_q_src_c017_3_01 0 bpf_c017_3 0) vcvs gain=5.555702330196e-01
SMIXQ_c017_3_01 (mix_q_src_c017_3_01 mix_q_c017_3 win_3_01 0) relay vt1=-1m vt2=1m ropen=ropen_mix rclosed=rclosed_mix
EMIXI_c017_3_02 (mix_i_src_c017_3_02 0 bpf_c017_3 0) vcvs gain=5.555702330196e-01
SMIXI_c017_3_02 (mix_i_src_c017_3_02 mix_i_c017_3 win_3_02 0) relay vt1=-1m vt2=1m ropen=ropen_mix rclosed=rclosed_mix
EMIXQ_c017_3_02 (mix_q_src_c017_3_02 0 bpf_c017_3 0) vcvs gain=8.314696123025e-01
SMIXQ_c017_3_02 (mix_q_src_c017_3_02 mix_q_c017_3 win_3_02 0) relay vt1=-1m vt2=1m ropen=ropen_mix rclosed=rclosed_mix
EMIXI_c017_3_03 (mix_i_src_c017_3_03 0 bpf_c017_3 0) vcvs gain=1.950903220161e-01
SMIXI_c017_3_03 (mix_i_src_c017_3_03 mix_i_c017_3 win_3_03 0) relay vt1=-1m vt2=1m ropen=ropen_mix rclosed=rclosed_mix
EMIXQ_c017_3_03 (mix_q_src_c017_3_03 0 bpf_c017_3 0) vcvs gain=9.807852804032e-01
SMIXQ_c017_3_03 (mix_q_src_c017_3_03 mix_q_c017_3 win_3_03 0) relay vt1=-1m vt2=1m ropen=ropen_mix rclosed=rclosed_mix
EMIXI_c017_3_04 (mix_i_src_c017_3_04 0 bpf_c017_3 0) vcvs gain=-1.950903220161e-01
SMIXI_c017_3_04 (mix_i_src_c017_3_04 mix_i_c017_3 win_3_04 0) relay vt1=-1m vt2=1m ropen=ropen_mix rclosed=rclosed_mix
EMIXQ_c017_3_04 (mix_q_src_c017_3_04 0 bpf_c017_3 0) vcvs gain=9.807852804032e-01
SMIXQ_c017_3_04 (mix_q_src_c017_3_04 mix_q_c017_3 win_3_04 0) relay vt1=-1m vt2=1m ropen=ropen_mix rclosed=rclosed_mix
EMIXI_c017_3_05 (mix_i_src_c017_3_05 0 bpf_c017_3 0) vcvs gain=-5.555702330196e-01
SMIXI_c017_3_05 (mix_i_src_c017_3_05 mix_i_c017_3 win_3_05 0) relay vt1=-1m vt2=1m ropen=ropen_mix rclosed=rclosed_mix
EMIXQ_c017_3_05 (mix_q_src_c017_3_05 0 bpf_c017_3 0) vcvs gain=8.314696123025e-01
SMIXQ_c017_3_05 (mix_q_src_c017_3_05 mix_q_c017_3 win_3_05 0) relay vt1=-1m vt2=1m ropen=ropen_mix rclosed=rclosed_mix
EMIXI_c017_3_06 (mix_i_src_c017_3_06 0 bpf_c017_3 0) vcvs gain=-8.314696123025e-01
SMIXI_c017_3_06 (mix_i_src_c017_3_06 mix_i_c017_3 win_3_06 0) relay vt1=-1m vt2=1m ropen=ropen_mix rclosed=rclosed_mix
EMIXQ_c017_3_06 (mix_q_src_c017_3_06 0 bpf_c017_3 0) vcvs gain=5.555702330196e-01
SMIXQ_c017_3_06 (mix_q_src_c017_3_06 mix_q_c017_3 win_3_06 0) relay vt1=-1m vt2=1m ropen=ropen_mix rclosed=rclosed_mix
EMIXI_c017_3_07 (mix_i_src_c017_3_07 0 bpf_c017_3 0) vcvs gain=-9.807852804032e-01
SMIXI_c017_3_07 (mix_i_src_c017_3_07 mix_i_c017_3 win_3_07 0) relay vt1=-1m vt2=1m ropen=ropen_mix rclosed=rclosed_mix
EMIXQ_c017_3_07 (mix_q_src_c017_3_07 0 bpf_c017_3 0) vcvs gain=1.950903220161e-01
SMIXQ_c017_3_07 (mix_q_src_c017_3_07 mix_q_c017_3 win_3_07 0) relay vt1=-1m vt2=1m ropen=ropen_mix rclosed=rclosed_mix
EMIXI_c017_3_08 (mix_i_src_c017_3_08 0 bpf_c017_3 0) vcvs gain=-9.807852804032e-01
SMIXI_c017_3_08 (mix_i_src_c017_3_08 mix_i_c017_3 win_3_08 0) relay vt1=-1m vt2=1m ropen=ropen_mix rclosed=rclosed_mix
EMIXQ_c017_3_08 (mix_q_src_c017_3_08 0 bpf_c017_3 0) vcvs gain=-1.950903220161e-01
SMIXQ_c017_3_08 (mix_q_src_c017_3_08 mix_q_c017_3 win_3_08 0) relay vt1=-1m vt2=1m ropen=ropen_mix rclosed=rclosed_mix
EMIXI_c017_3_09 (mix_i_src_c017_3_09 0 bpf_c017_3 0) vcvs gain=-8.314696123025e-01
SMIXI_c017_3_09 (mix_i_src_c017_3_09 mix_i_c017_3 win_3_09 0) relay vt1=-1m vt2=1m ropen=ropen_mix rclosed=rclosed_mix
EMIXQ_c017_3_09 (mix_q_src_c017_3_09 0 bpf_c017_3 0) vcvs gain=-5.555702330196e-01
SMIXQ_c017_3_09 (mix_q_src_c017_3_09 mix_q_c017_3 win_3_09 0) relay vt1=-1m vt2=1m ropen=ropen_mix rclosed=rclosed_mix
EMIXI_c017_3_10 (mix_i_src_c017_3_10 0 bpf_c017_3 0) vcvs gain=-5.555702330196e-01
SMIXI_c017_3_10 (mix_i_src_c017_3_10 mix_i_c017_3 win_3_10 0) relay vt1=-1m vt2=1m ropen=ropen_mix rclosed=rclosed_mix
EMIXQ_c017_3_10 (mix_q_src_c017_3_10 0 bpf_c017_3 0) vcvs gain=-8.314696123025e-01
SMIXQ_c017_3_10 (mix_q_src_c017_3_10 mix_q_c017_3 win_3_10 0) relay vt1=-1m vt2=1m ropen=ropen_mix rclosed=rclosed_mix
EMIXI_c017_3_11 (mix_i_src_c017_3_11 0 bpf_c017_3 0) vcvs gain=-1.950903220161e-01
SMIXI_c017_3_11 (mix_i_src_c017_3_11 mix_i_c017_3 win_3_11 0) relay vt1=-1m vt2=1m ropen=ropen_mix rclosed=rclosed_mix
EMIXQ_c017_3_11 (mix_q_src_c017_3_11 0 bpf_c017_3 0) vcvs gain=-9.807852804032e-01
SMIXQ_c017_3_11 (mix_q_src_c017_3_11 mix_q_c017_3 win_3_11 0) relay vt1=-1m vt2=1m ropen=ropen_mix rclosed=rclosed_mix
EMIXI_c017_3_12 (mix_i_src_c017_3_12 0 bpf_c017_3 0) vcvs gain=1.950903220161e-01
SMIXI_c017_3_12 (mix_i_src_c017_3_12 mix_i_c017_3 win_3_12 0) relay vt1=-1m vt2=1m ropen=ropen_mix rclosed=rclosed_mix
EMIXQ_c017_3_12 (mix_q_src_c017_3_12 0 bpf_c017_3 0) vcvs gain=-9.807852804032e-01
SMIXQ_c017_3_12 (mix_q_src_c017_3_12 mix_q_c017_3 win_3_12 0) relay vt1=-1m vt2=1m ropen=ropen_mix rclosed=rclosed_mix
EMIXI_c017_3_13 (mix_i_src_c017_3_13 0 bpf_c017_3 0) vcvs gain=5.555702330196e-01
SMIXI_c017_3_13 (mix_i_src_c017_3_13 mix_i_c017_3 win_3_13 0) relay vt1=-1m vt2=1m ropen=ropen_mix rclosed=rclosed_mix
EMIXQ_c017_3_13 (mix_q_src_c017_3_13 0 bpf_c017_3 0) vcvs gain=-8.314696123025e-01
SMIXQ_c017_3_13 (mix_q_src_c017_3_13 mix_q_c017_3 win_3_13 0) relay vt1=-1m vt2=1m ropen=ropen_mix rclosed=rclosed_mix
EMIXI_c017_3_14 (mix_i_src_c017_3_14 0 bpf_c017_3 0) vcvs gain=8.314696123025e-01
SMIXI_c017_3_14 (mix_i_src_c017_3_14 mix_i_c017_3 win_3_14 0) relay vt1=-1m vt2=1m ropen=ropen_mix rclosed=rclosed_mix
EMIXQ_c017_3_14 (mix_q_src_c017_3_14 0 bpf_c017_3 0) vcvs gain=-5.555702330196e-01
SMIXQ_c017_3_14 (mix_q_src_c017_3_14 mix_q_c017_3 win_3_14 0) relay vt1=-1m vt2=1m ropen=ropen_mix rclosed=rclosed_mix
EMIXI_c017_3_15 (mix_i_src_c017_3_15 0 bpf_c017_3 0) vcvs gain=9.807852804032e-01
SMIXI_c017_3_15 (mix_i_src_c017_3_15 mix_i_c017_3 win_3_15 0) relay vt1=-1m vt2=1m ropen=ropen_mix rclosed=rclosed_mix
EMIXQ_c017_3_15 (mix_q_src_c017_3_15 0 bpf_c017_3 0) vcvs gain=-1.950903220161e-01
SMIXQ_c017_3_15 (mix_q_src_c017_3_15 mix_q_c017_3 win_3_15 0) relay vt1=-1m vt2=1m ropen=ropen_mix rclosed=rclosed_mix
RMIXI_c017_3 (mix_i_c017_3 0) resistor r=1G
RMIXQ_c017_3 (mix_q_c017_3 0) resistor r=1G
RINTI_c017_3 (mix_i_c017_3 Icar_c017_3) resistor r=1k
CINTI_c017_3 (Icar_c017_3 0) capacitor c=80p
RINTQ_c017_3 (mix_q_c017_3 Qcar_c017_3) resistor r=1k
CINTQ_c017_3 (Qcar_c017_3 0) capacitor c=80p
save bpf_c017_3 Icar_c017_3 Qcar_c017_3

// bl018, carrier_0: 250000000 Hz coherent I/Q phase-window verification-demod path
CBPF_c018_0 (bl018 n_cbpf_c018_0) capacitor c=4.052847345694e-13
LBPF_c018_0 (n_cbpf_c018_0 bpf_c018_0) inductor l=1.000000000000e-06
RBPF_c018_0 (bpf_c018_0 0) resistor r=7.853981633974e+01
EMIXI_c018_0_00 (mix_i_src_c018_0_00 0 bpf_c018_0 0) vcvs gain=9.807852804032e-01
SMIXI_c018_0_00 (mix_i_src_c018_0_00 mix_i_c018_0 win_0_00 0) relay vt1=-1m vt2=1m ropen=ropen_mix rclosed=rclosed_mix
EMIXQ_c018_0_00 (mix_q_src_c018_0_00 0 bpf_c018_0 0) vcvs gain=1.950903220161e-01
SMIXQ_c018_0_00 (mix_q_src_c018_0_00 mix_q_c018_0 win_0_00 0) relay vt1=-1m vt2=1m ropen=ropen_mix rclosed=rclosed_mix
EMIXI_c018_0_01 (mix_i_src_c018_0_01 0 bpf_c018_0 0) vcvs gain=8.314696123025e-01
SMIXI_c018_0_01 (mix_i_src_c018_0_01 mix_i_c018_0 win_0_01 0) relay vt1=-1m vt2=1m ropen=ropen_mix rclosed=rclosed_mix
EMIXQ_c018_0_01 (mix_q_src_c018_0_01 0 bpf_c018_0 0) vcvs gain=5.555702330196e-01
SMIXQ_c018_0_01 (mix_q_src_c018_0_01 mix_q_c018_0 win_0_01 0) relay vt1=-1m vt2=1m ropen=ropen_mix rclosed=rclosed_mix
EMIXI_c018_0_02 (mix_i_src_c018_0_02 0 bpf_c018_0 0) vcvs gain=5.555702330196e-01
SMIXI_c018_0_02 (mix_i_src_c018_0_02 mix_i_c018_0 win_0_02 0) relay vt1=-1m vt2=1m ropen=ropen_mix rclosed=rclosed_mix
EMIXQ_c018_0_02 (mix_q_src_c018_0_02 0 bpf_c018_0 0) vcvs gain=8.314696123025e-01
SMIXQ_c018_0_02 (mix_q_src_c018_0_02 mix_q_c018_0 win_0_02 0) relay vt1=-1m vt2=1m ropen=ropen_mix rclosed=rclosed_mix
EMIXI_c018_0_03 (mix_i_src_c018_0_03 0 bpf_c018_0 0) vcvs gain=1.950903220161e-01
SMIXI_c018_0_03 (mix_i_src_c018_0_03 mix_i_c018_0 win_0_03 0) relay vt1=-1m vt2=1m ropen=ropen_mix rclosed=rclosed_mix
EMIXQ_c018_0_03 (mix_q_src_c018_0_03 0 bpf_c018_0 0) vcvs gain=9.807852804032e-01
SMIXQ_c018_0_03 (mix_q_src_c018_0_03 mix_q_c018_0 win_0_03 0) relay vt1=-1m vt2=1m ropen=ropen_mix rclosed=rclosed_mix
EMIXI_c018_0_04 (mix_i_src_c018_0_04 0 bpf_c018_0 0) vcvs gain=-1.950903220161e-01
SMIXI_c018_0_04 (mix_i_src_c018_0_04 mix_i_c018_0 win_0_04 0) relay vt1=-1m vt2=1m ropen=ropen_mix rclosed=rclosed_mix
EMIXQ_c018_0_04 (mix_q_src_c018_0_04 0 bpf_c018_0 0) vcvs gain=9.807852804032e-01
SMIXQ_c018_0_04 (mix_q_src_c018_0_04 mix_q_c018_0 win_0_04 0) relay vt1=-1m vt2=1m ropen=ropen_mix rclosed=rclosed_mix
EMIXI_c018_0_05 (mix_i_src_c018_0_05 0 bpf_c018_0 0) vcvs gain=-5.555702330196e-01
SMIXI_c018_0_05 (mix_i_src_c018_0_05 mix_i_c018_0 win_0_05 0) relay vt1=-1m vt2=1m ropen=ropen_mix rclosed=rclosed_mix
EMIXQ_c018_0_05 (mix_q_src_c018_0_05 0 bpf_c018_0 0) vcvs gain=8.314696123025e-01
SMIXQ_c018_0_05 (mix_q_src_c018_0_05 mix_q_c018_0 win_0_05 0) relay vt1=-1m vt2=1m ropen=ropen_mix rclosed=rclosed_mix
EMIXI_c018_0_06 (mix_i_src_c018_0_06 0 bpf_c018_0 0) vcvs gain=-8.314696123025e-01
SMIXI_c018_0_06 (mix_i_src_c018_0_06 mix_i_c018_0 win_0_06 0) relay vt1=-1m vt2=1m ropen=ropen_mix rclosed=rclosed_mix
EMIXQ_c018_0_06 (mix_q_src_c018_0_06 0 bpf_c018_0 0) vcvs gain=5.555702330196e-01
SMIXQ_c018_0_06 (mix_q_src_c018_0_06 mix_q_c018_0 win_0_06 0) relay vt1=-1m vt2=1m ropen=ropen_mix rclosed=rclosed_mix
EMIXI_c018_0_07 (mix_i_src_c018_0_07 0 bpf_c018_0 0) vcvs gain=-9.807852804032e-01
SMIXI_c018_0_07 (mix_i_src_c018_0_07 mix_i_c018_0 win_0_07 0) relay vt1=-1m vt2=1m ropen=ropen_mix rclosed=rclosed_mix
EMIXQ_c018_0_07 (mix_q_src_c018_0_07 0 bpf_c018_0 0) vcvs gain=1.950903220161e-01
SMIXQ_c018_0_07 (mix_q_src_c018_0_07 mix_q_c018_0 win_0_07 0) relay vt1=-1m vt2=1m ropen=ropen_mix rclosed=rclosed_mix
EMIXI_c018_0_08 (mix_i_src_c018_0_08 0 bpf_c018_0 0) vcvs gain=-9.807852804032e-01
SMIXI_c018_0_08 (mix_i_src_c018_0_08 mix_i_c018_0 win_0_08 0) relay vt1=-1m vt2=1m ropen=ropen_mix rclosed=rclosed_mix
EMIXQ_c018_0_08 (mix_q_src_c018_0_08 0 bpf_c018_0 0) vcvs gain=-1.950903220161e-01
SMIXQ_c018_0_08 (mix_q_src_c018_0_08 mix_q_c018_0 win_0_08 0) relay vt1=-1m vt2=1m ropen=ropen_mix rclosed=rclosed_mix
EMIXI_c018_0_09 (mix_i_src_c018_0_09 0 bpf_c018_0 0) vcvs gain=-8.314696123025e-01
SMIXI_c018_0_09 (mix_i_src_c018_0_09 mix_i_c018_0 win_0_09 0) relay vt1=-1m vt2=1m ropen=ropen_mix rclosed=rclosed_mix
EMIXQ_c018_0_09 (mix_q_src_c018_0_09 0 bpf_c018_0 0) vcvs gain=-5.555702330196e-01
SMIXQ_c018_0_09 (mix_q_src_c018_0_09 mix_q_c018_0 win_0_09 0) relay vt1=-1m vt2=1m ropen=ropen_mix rclosed=rclosed_mix
EMIXI_c018_0_10 (mix_i_src_c018_0_10 0 bpf_c018_0 0) vcvs gain=-5.555702330196e-01
SMIXI_c018_0_10 (mix_i_src_c018_0_10 mix_i_c018_0 win_0_10 0) relay vt1=-1m vt2=1m ropen=ropen_mix rclosed=rclosed_mix
EMIXQ_c018_0_10 (mix_q_src_c018_0_10 0 bpf_c018_0 0) vcvs gain=-8.314696123025e-01
SMIXQ_c018_0_10 (mix_q_src_c018_0_10 mix_q_c018_0 win_0_10 0) relay vt1=-1m vt2=1m ropen=ropen_mix rclosed=rclosed_mix
EMIXI_c018_0_11 (mix_i_src_c018_0_11 0 bpf_c018_0 0) vcvs gain=-1.950903220161e-01
SMIXI_c018_0_11 (mix_i_src_c018_0_11 mix_i_c018_0 win_0_11 0) relay vt1=-1m vt2=1m ropen=ropen_mix rclosed=rclosed_mix
EMIXQ_c018_0_11 (mix_q_src_c018_0_11 0 bpf_c018_0 0) vcvs gain=-9.807852804032e-01
SMIXQ_c018_0_11 (mix_q_src_c018_0_11 mix_q_c018_0 win_0_11 0) relay vt1=-1m vt2=1m ropen=ropen_mix rclosed=rclosed_mix
EMIXI_c018_0_12 (mix_i_src_c018_0_12 0 bpf_c018_0 0) vcvs gain=1.950903220161e-01
SMIXI_c018_0_12 (mix_i_src_c018_0_12 mix_i_c018_0 win_0_12 0) relay vt1=-1m vt2=1m ropen=ropen_mix rclosed=rclosed_mix
EMIXQ_c018_0_12 (mix_q_src_c018_0_12 0 bpf_c018_0 0) vcvs gain=-9.807852804032e-01
SMIXQ_c018_0_12 (mix_q_src_c018_0_12 mix_q_c018_0 win_0_12 0) relay vt1=-1m vt2=1m ropen=ropen_mix rclosed=rclosed_mix
EMIXI_c018_0_13 (mix_i_src_c018_0_13 0 bpf_c018_0 0) vcvs gain=5.555702330196e-01
SMIXI_c018_0_13 (mix_i_src_c018_0_13 mix_i_c018_0 win_0_13 0) relay vt1=-1m vt2=1m ropen=ropen_mix rclosed=rclosed_mix
EMIXQ_c018_0_13 (mix_q_src_c018_0_13 0 bpf_c018_0 0) vcvs gain=-8.314696123025e-01
SMIXQ_c018_0_13 (mix_q_src_c018_0_13 mix_q_c018_0 win_0_13 0) relay vt1=-1m vt2=1m ropen=ropen_mix rclosed=rclosed_mix
EMIXI_c018_0_14 (mix_i_src_c018_0_14 0 bpf_c018_0 0) vcvs gain=8.314696123025e-01
SMIXI_c018_0_14 (mix_i_src_c018_0_14 mix_i_c018_0 win_0_14 0) relay vt1=-1m vt2=1m ropen=ropen_mix rclosed=rclosed_mix
EMIXQ_c018_0_14 (mix_q_src_c018_0_14 0 bpf_c018_0 0) vcvs gain=-5.555702330196e-01
SMIXQ_c018_0_14 (mix_q_src_c018_0_14 mix_q_c018_0 win_0_14 0) relay vt1=-1m vt2=1m ropen=ropen_mix rclosed=rclosed_mix
EMIXI_c018_0_15 (mix_i_src_c018_0_15 0 bpf_c018_0 0) vcvs gain=9.807852804032e-01
SMIXI_c018_0_15 (mix_i_src_c018_0_15 mix_i_c018_0 win_0_15 0) relay vt1=-1m vt2=1m ropen=ropen_mix rclosed=rclosed_mix
EMIXQ_c018_0_15 (mix_q_src_c018_0_15 0 bpf_c018_0 0) vcvs gain=-1.950903220161e-01
SMIXQ_c018_0_15 (mix_q_src_c018_0_15 mix_q_c018_0 win_0_15 0) relay vt1=-1m vt2=1m ropen=ropen_mix rclosed=rclosed_mix
RMIXI_c018_0 (mix_i_c018_0 0) resistor r=1G
RMIXQ_c018_0 (mix_q_c018_0 0) resistor r=1G
RINTI_c018_0 (mix_i_c018_0 Icar_c018_0) resistor r=1k
CINTI_c018_0 (Icar_c018_0 0) capacitor c=80p
RINTQ_c018_0 (mix_q_c018_0 Qcar_c018_0) resistor r=1k
CINTQ_c018_0 (Qcar_c018_0 0) capacitor c=80p
save bpf_c018_0 Icar_c018_0 Qcar_c018_0

// bl018, carrier_1: 500000000 Hz coherent I/Q phase-window verification-demod path
CBPF_c018_1 (bl018 n_cbpf_c018_1) capacitor c=1.013211836423e-13
LBPF_c018_1 (n_cbpf_c018_1 bpf_c018_1) inductor l=1.000000000000e-06
RBPF_c018_1 (bpf_c018_1 0) resistor r=1.570796326795e+02
EMIXI_c018_1_00 (mix_i_src_c018_1_00 0 bpf_c018_1 0) vcvs gain=9.807852804032e-01
SMIXI_c018_1_00 (mix_i_src_c018_1_00 mix_i_c018_1 win_1_00 0) relay vt1=-1m vt2=1m ropen=ropen_mix rclosed=rclosed_mix
EMIXQ_c018_1_00 (mix_q_src_c018_1_00 0 bpf_c018_1 0) vcvs gain=1.950903220161e-01
SMIXQ_c018_1_00 (mix_q_src_c018_1_00 mix_q_c018_1 win_1_00 0) relay vt1=-1m vt2=1m ropen=ropen_mix rclosed=rclosed_mix
EMIXI_c018_1_01 (mix_i_src_c018_1_01 0 bpf_c018_1 0) vcvs gain=8.314696123025e-01
SMIXI_c018_1_01 (mix_i_src_c018_1_01 mix_i_c018_1 win_1_01 0) relay vt1=-1m vt2=1m ropen=ropen_mix rclosed=rclosed_mix
EMIXQ_c018_1_01 (mix_q_src_c018_1_01 0 bpf_c018_1 0) vcvs gain=5.555702330196e-01
SMIXQ_c018_1_01 (mix_q_src_c018_1_01 mix_q_c018_1 win_1_01 0) relay vt1=-1m vt2=1m ropen=ropen_mix rclosed=rclosed_mix
EMIXI_c018_1_02 (mix_i_src_c018_1_02 0 bpf_c018_1 0) vcvs gain=5.555702330196e-01
SMIXI_c018_1_02 (mix_i_src_c018_1_02 mix_i_c018_1 win_1_02 0) relay vt1=-1m vt2=1m ropen=ropen_mix rclosed=rclosed_mix
EMIXQ_c018_1_02 (mix_q_src_c018_1_02 0 bpf_c018_1 0) vcvs gain=8.314696123025e-01
SMIXQ_c018_1_02 (mix_q_src_c018_1_02 mix_q_c018_1 win_1_02 0) relay vt1=-1m vt2=1m ropen=ropen_mix rclosed=rclosed_mix
EMIXI_c018_1_03 (mix_i_src_c018_1_03 0 bpf_c018_1 0) vcvs gain=1.950903220161e-01
SMIXI_c018_1_03 (mix_i_src_c018_1_03 mix_i_c018_1 win_1_03 0) relay vt1=-1m vt2=1m ropen=ropen_mix rclosed=rclosed_mix
EMIXQ_c018_1_03 (mix_q_src_c018_1_03 0 bpf_c018_1 0) vcvs gain=9.807852804032e-01
SMIXQ_c018_1_03 (mix_q_src_c018_1_03 mix_q_c018_1 win_1_03 0) relay vt1=-1m vt2=1m ropen=ropen_mix rclosed=rclosed_mix
EMIXI_c018_1_04 (mix_i_src_c018_1_04 0 bpf_c018_1 0) vcvs gain=-1.950903220161e-01
SMIXI_c018_1_04 (mix_i_src_c018_1_04 mix_i_c018_1 win_1_04 0) relay vt1=-1m vt2=1m ropen=ropen_mix rclosed=rclosed_mix
EMIXQ_c018_1_04 (mix_q_src_c018_1_04 0 bpf_c018_1 0) vcvs gain=9.807852804032e-01
SMIXQ_c018_1_04 (mix_q_src_c018_1_04 mix_q_c018_1 win_1_04 0) relay vt1=-1m vt2=1m ropen=ropen_mix rclosed=rclosed_mix
EMIXI_c018_1_05 (mix_i_src_c018_1_05 0 bpf_c018_1 0) vcvs gain=-5.555702330196e-01
SMIXI_c018_1_05 (mix_i_src_c018_1_05 mix_i_c018_1 win_1_05 0) relay vt1=-1m vt2=1m ropen=ropen_mix rclosed=rclosed_mix
EMIXQ_c018_1_05 (mix_q_src_c018_1_05 0 bpf_c018_1 0) vcvs gain=8.314696123025e-01
SMIXQ_c018_1_05 (mix_q_src_c018_1_05 mix_q_c018_1 win_1_05 0) relay vt1=-1m vt2=1m ropen=ropen_mix rclosed=rclosed_mix
EMIXI_c018_1_06 (mix_i_src_c018_1_06 0 bpf_c018_1 0) vcvs gain=-8.314696123025e-01
SMIXI_c018_1_06 (mix_i_src_c018_1_06 mix_i_c018_1 win_1_06 0) relay vt1=-1m vt2=1m ropen=ropen_mix rclosed=rclosed_mix
EMIXQ_c018_1_06 (mix_q_src_c018_1_06 0 bpf_c018_1 0) vcvs gain=5.555702330196e-01
SMIXQ_c018_1_06 (mix_q_src_c018_1_06 mix_q_c018_1 win_1_06 0) relay vt1=-1m vt2=1m ropen=ropen_mix rclosed=rclosed_mix
EMIXI_c018_1_07 (mix_i_src_c018_1_07 0 bpf_c018_1 0) vcvs gain=-9.807852804032e-01
SMIXI_c018_1_07 (mix_i_src_c018_1_07 mix_i_c018_1 win_1_07 0) relay vt1=-1m vt2=1m ropen=ropen_mix rclosed=rclosed_mix
EMIXQ_c018_1_07 (mix_q_src_c018_1_07 0 bpf_c018_1 0) vcvs gain=1.950903220161e-01
SMIXQ_c018_1_07 (mix_q_src_c018_1_07 mix_q_c018_1 win_1_07 0) relay vt1=-1m vt2=1m ropen=ropen_mix rclosed=rclosed_mix
EMIXI_c018_1_08 (mix_i_src_c018_1_08 0 bpf_c018_1 0) vcvs gain=-9.807852804032e-01
SMIXI_c018_1_08 (mix_i_src_c018_1_08 mix_i_c018_1 win_1_08 0) relay vt1=-1m vt2=1m ropen=ropen_mix rclosed=rclosed_mix
EMIXQ_c018_1_08 (mix_q_src_c018_1_08 0 bpf_c018_1 0) vcvs gain=-1.950903220161e-01
SMIXQ_c018_1_08 (mix_q_src_c018_1_08 mix_q_c018_1 win_1_08 0) relay vt1=-1m vt2=1m ropen=ropen_mix rclosed=rclosed_mix
EMIXI_c018_1_09 (mix_i_src_c018_1_09 0 bpf_c018_1 0) vcvs gain=-8.314696123025e-01
SMIXI_c018_1_09 (mix_i_src_c018_1_09 mix_i_c018_1 win_1_09 0) relay vt1=-1m vt2=1m ropen=ropen_mix rclosed=rclosed_mix
EMIXQ_c018_1_09 (mix_q_src_c018_1_09 0 bpf_c018_1 0) vcvs gain=-5.555702330196e-01
SMIXQ_c018_1_09 (mix_q_src_c018_1_09 mix_q_c018_1 win_1_09 0) relay vt1=-1m vt2=1m ropen=ropen_mix rclosed=rclosed_mix
EMIXI_c018_1_10 (mix_i_src_c018_1_10 0 bpf_c018_1 0) vcvs gain=-5.555702330196e-01
SMIXI_c018_1_10 (mix_i_src_c018_1_10 mix_i_c018_1 win_1_10 0) relay vt1=-1m vt2=1m ropen=ropen_mix rclosed=rclosed_mix
EMIXQ_c018_1_10 (mix_q_src_c018_1_10 0 bpf_c018_1 0) vcvs gain=-8.314696123025e-01
SMIXQ_c018_1_10 (mix_q_src_c018_1_10 mix_q_c018_1 win_1_10 0) relay vt1=-1m vt2=1m ropen=ropen_mix rclosed=rclosed_mix
EMIXI_c018_1_11 (mix_i_src_c018_1_11 0 bpf_c018_1 0) vcvs gain=-1.950903220161e-01
SMIXI_c018_1_11 (mix_i_src_c018_1_11 mix_i_c018_1 win_1_11 0) relay vt1=-1m vt2=1m ropen=ropen_mix rclosed=rclosed_mix
EMIXQ_c018_1_11 (mix_q_src_c018_1_11 0 bpf_c018_1 0) vcvs gain=-9.807852804032e-01
SMIXQ_c018_1_11 (mix_q_src_c018_1_11 mix_q_c018_1 win_1_11 0) relay vt1=-1m vt2=1m ropen=ropen_mix rclosed=rclosed_mix
EMIXI_c018_1_12 (mix_i_src_c018_1_12 0 bpf_c018_1 0) vcvs gain=1.950903220161e-01
SMIXI_c018_1_12 (mix_i_src_c018_1_12 mix_i_c018_1 win_1_12 0) relay vt1=-1m vt2=1m ropen=ropen_mix rclosed=rclosed_mix
EMIXQ_c018_1_12 (mix_q_src_c018_1_12 0 bpf_c018_1 0) vcvs gain=-9.807852804032e-01
SMIXQ_c018_1_12 (mix_q_src_c018_1_12 mix_q_c018_1 win_1_12 0) relay vt1=-1m vt2=1m ropen=ropen_mix rclosed=rclosed_mix
EMIXI_c018_1_13 (mix_i_src_c018_1_13 0 bpf_c018_1 0) vcvs gain=5.555702330196e-01
SMIXI_c018_1_13 (mix_i_src_c018_1_13 mix_i_c018_1 win_1_13 0) relay vt1=-1m vt2=1m ropen=ropen_mix rclosed=rclosed_mix
EMIXQ_c018_1_13 (mix_q_src_c018_1_13 0 bpf_c018_1 0) vcvs gain=-8.314696123025e-01
SMIXQ_c018_1_13 (mix_q_src_c018_1_13 mix_q_c018_1 win_1_13 0) relay vt1=-1m vt2=1m ropen=ropen_mix rclosed=rclosed_mix
EMIXI_c018_1_14 (mix_i_src_c018_1_14 0 bpf_c018_1 0) vcvs gain=8.314696123025e-01
SMIXI_c018_1_14 (mix_i_src_c018_1_14 mix_i_c018_1 win_1_14 0) relay vt1=-1m vt2=1m ropen=ropen_mix rclosed=rclosed_mix
EMIXQ_c018_1_14 (mix_q_src_c018_1_14 0 bpf_c018_1 0) vcvs gain=-5.555702330196e-01
SMIXQ_c018_1_14 (mix_q_src_c018_1_14 mix_q_c018_1 win_1_14 0) relay vt1=-1m vt2=1m ropen=ropen_mix rclosed=rclosed_mix
EMIXI_c018_1_15 (mix_i_src_c018_1_15 0 bpf_c018_1 0) vcvs gain=9.807852804032e-01
SMIXI_c018_1_15 (mix_i_src_c018_1_15 mix_i_c018_1 win_1_15 0) relay vt1=-1m vt2=1m ropen=ropen_mix rclosed=rclosed_mix
EMIXQ_c018_1_15 (mix_q_src_c018_1_15 0 bpf_c018_1 0) vcvs gain=-1.950903220161e-01
SMIXQ_c018_1_15 (mix_q_src_c018_1_15 mix_q_c018_1 win_1_15 0) relay vt1=-1m vt2=1m ropen=ropen_mix rclosed=rclosed_mix
RMIXI_c018_1 (mix_i_c018_1 0) resistor r=1G
RMIXQ_c018_1 (mix_q_c018_1 0) resistor r=1G
RINTI_c018_1 (mix_i_c018_1 Icar_c018_1) resistor r=1k
CINTI_c018_1 (Icar_c018_1 0) capacitor c=80p
RINTQ_c018_1 (mix_q_c018_1 Qcar_c018_1) resistor r=1k
CINTQ_c018_1 (Qcar_c018_1 0) capacitor c=80p
save bpf_c018_1 Icar_c018_1 Qcar_c018_1

// bl018, carrier_2: 750000000 Hz coherent I/Q phase-window verification-demod path
CBPF_c018_2 (bl018 n_cbpf_c018_2) capacitor c=4.503163717437e-14
LBPF_c018_2 (n_cbpf_c018_2 bpf_c018_2) inductor l=1.000000000000e-06
RBPF_c018_2 (bpf_c018_2 0) resistor r=2.356194490192e+02
EMIXI_c018_2_00 (mix_i_src_c018_2_00 0 bpf_c018_2 0) vcvs gain=9.807852804032e-01
SMIXI_c018_2_00 (mix_i_src_c018_2_00 mix_i_c018_2 win_2_00 0) relay vt1=-1m vt2=1m ropen=ropen_mix rclosed=rclosed_mix
EMIXQ_c018_2_00 (mix_q_src_c018_2_00 0 bpf_c018_2 0) vcvs gain=1.950903220161e-01
SMIXQ_c018_2_00 (mix_q_src_c018_2_00 mix_q_c018_2 win_2_00 0) relay vt1=-1m vt2=1m ropen=ropen_mix rclosed=rclosed_mix
EMIXI_c018_2_01 (mix_i_src_c018_2_01 0 bpf_c018_2 0) vcvs gain=8.314696123025e-01
SMIXI_c018_2_01 (mix_i_src_c018_2_01 mix_i_c018_2 win_2_01 0) relay vt1=-1m vt2=1m ropen=ropen_mix rclosed=rclosed_mix
EMIXQ_c018_2_01 (mix_q_src_c018_2_01 0 bpf_c018_2 0) vcvs gain=5.555702330196e-01
SMIXQ_c018_2_01 (mix_q_src_c018_2_01 mix_q_c018_2 win_2_01 0) relay vt1=-1m vt2=1m ropen=ropen_mix rclosed=rclosed_mix
EMIXI_c018_2_02 (mix_i_src_c018_2_02 0 bpf_c018_2 0) vcvs gain=5.555702330196e-01
SMIXI_c018_2_02 (mix_i_src_c018_2_02 mix_i_c018_2 win_2_02 0) relay vt1=-1m vt2=1m ropen=ropen_mix rclosed=rclosed_mix
EMIXQ_c018_2_02 (mix_q_src_c018_2_02 0 bpf_c018_2 0) vcvs gain=8.314696123025e-01
SMIXQ_c018_2_02 (mix_q_src_c018_2_02 mix_q_c018_2 win_2_02 0) relay vt1=-1m vt2=1m ropen=ropen_mix rclosed=rclosed_mix
EMIXI_c018_2_03 (mix_i_src_c018_2_03 0 bpf_c018_2 0) vcvs gain=1.950903220161e-01
SMIXI_c018_2_03 (mix_i_src_c018_2_03 mix_i_c018_2 win_2_03 0) relay vt1=-1m vt2=1m ropen=ropen_mix rclosed=rclosed_mix
EMIXQ_c018_2_03 (mix_q_src_c018_2_03 0 bpf_c018_2 0) vcvs gain=9.807852804032e-01
SMIXQ_c018_2_03 (mix_q_src_c018_2_03 mix_q_c018_2 win_2_03 0) relay vt1=-1m vt2=1m ropen=ropen_mix rclosed=rclosed_mix
EMIXI_c018_2_04 (mix_i_src_c018_2_04 0 bpf_c018_2 0) vcvs gain=-1.950903220161e-01
SMIXI_c018_2_04 (mix_i_src_c018_2_04 mix_i_c018_2 win_2_04 0) relay vt1=-1m vt2=1m ropen=ropen_mix rclosed=rclosed_mix
EMIXQ_c018_2_04 (mix_q_src_c018_2_04 0 bpf_c018_2 0) vcvs gain=9.807852804032e-01
SMIXQ_c018_2_04 (mix_q_src_c018_2_04 mix_q_c018_2 win_2_04 0) relay vt1=-1m vt2=1m ropen=ropen_mix rclosed=rclosed_mix
EMIXI_c018_2_05 (mix_i_src_c018_2_05 0 bpf_c018_2 0) vcvs gain=-5.555702330196e-01
SMIXI_c018_2_05 (mix_i_src_c018_2_05 mix_i_c018_2 win_2_05 0) relay vt1=-1m vt2=1m ropen=ropen_mix rclosed=rclosed_mix
EMIXQ_c018_2_05 (mix_q_src_c018_2_05 0 bpf_c018_2 0) vcvs gain=8.314696123025e-01
SMIXQ_c018_2_05 (mix_q_src_c018_2_05 mix_q_c018_2 win_2_05 0) relay vt1=-1m vt2=1m ropen=ropen_mix rclosed=rclosed_mix
EMIXI_c018_2_06 (mix_i_src_c018_2_06 0 bpf_c018_2 0) vcvs gain=-8.314696123025e-01
SMIXI_c018_2_06 (mix_i_src_c018_2_06 mix_i_c018_2 win_2_06 0) relay vt1=-1m vt2=1m ropen=ropen_mix rclosed=rclosed_mix
EMIXQ_c018_2_06 (mix_q_src_c018_2_06 0 bpf_c018_2 0) vcvs gain=5.555702330196e-01
SMIXQ_c018_2_06 (mix_q_src_c018_2_06 mix_q_c018_2 win_2_06 0) relay vt1=-1m vt2=1m ropen=ropen_mix rclosed=rclosed_mix
EMIXI_c018_2_07 (mix_i_src_c018_2_07 0 bpf_c018_2 0) vcvs gain=-9.807852804032e-01
SMIXI_c018_2_07 (mix_i_src_c018_2_07 mix_i_c018_2 win_2_07 0) relay vt1=-1m vt2=1m ropen=ropen_mix rclosed=rclosed_mix
EMIXQ_c018_2_07 (mix_q_src_c018_2_07 0 bpf_c018_2 0) vcvs gain=1.950903220161e-01
SMIXQ_c018_2_07 (mix_q_src_c018_2_07 mix_q_c018_2 win_2_07 0) relay vt1=-1m vt2=1m ropen=ropen_mix rclosed=rclosed_mix
EMIXI_c018_2_08 (mix_i_src_c018_2_08 0 bpf_c018_2 0) vcvs gain=-9.807852804032e-01
SMIXI_c018_2_08 (mix_i_src_c018_2_08 mix_i_c018_2 win_2_08 0) relay vt1=-1m vt2=1m ropen=ropen_mix rclosed=rclosed_mix
EMIXQ_c018_2_08 (mix_q_src_c018_2_08 0 bpf_c018_2 0) vcvs gain=-1.950903220161e-01
SMIXQ_c018_2_08 (mix_q_src_c018_2_08 mix_q_c018_2 win_2_08 0) relay vt1=-1m vt2=1m ropen=ropen_mix rclosed=rclosed_mix
EMIXI_c018_2_09 (mix_i_src_c018_2_09 0 bpf_c018_2 0) vcvs gain=-8.314696123025e-01
SMIXI_c018_2_09 (mix_i_src_c018_2_09 mix_i_c018_2 win_2_09 0) relay vt1=-1m vt2=1m ropen=ropen_mix rclosed=rclosed_mix
EMIXQ_c018_2_09 (mix_q_src_c018_2_09 0 bpf_c018_2 0) vcvs gain=-5.555702330196e-01
SMIXQ_c018_2_09 (mix_q_src_c018_2_09 mix_q_c018_2 win_2_09 0) relay vt1=-1m vt2=1m ropen=ropen_mix rclosed=rclosed_mix
EMIXI_c018_2_10 (mix_i_src_c018_2_10 0 bpf_c018_2 0) vcvs gain=-5.555702330196e-01
SMIXI_c018_2_10 (mix_i_src_c018_2_10 mix_i_c018_2 win_2_10 0) relay vt1=-1m vt2=1m ropen=ropen_mix rclosed=rclosed_mix
EMIXQ_c018_2_10 (mix_q_src_c018_2_10 0 bpf_c018_2 0) vcvs gain=-8.314696123025e-01
SMIXQ_c018_2_10 (mix_q_src_c018_2_10 mix_q_c018_2 win_2_10 0) relay vt1=-1m vt2=1m ropen=ropen_mix rclosed=rclosed_mix
EMIXI_c018_2_11 (mix_i_src_c018_2_11 0 bpf_c018_2 0) vcvs gain=-1.950903220161e-01
SMIXI_c018_2_11 (mix_i_src_c018_2_11 mix_i_c018_2 win_2_11 0) relay vt1=-1m vt2=1m ropen=ropen_mix rclosed=rclosed_mix
EMIXQ_c018_2_11 (mix_q_src_c018_2_11 0 bpf_c018_2 0) vcvs gain=-9.807852804032e-01
SMIXQ_c018_2_11 (mix_q_src_c018_2_11 mix_q_c018_2 win_2_11 0) relay vt1=-1m vt2=1m ropen=ropen_mix rclosed=rclosed_mix
EMIXI_c018_2_12 (mix_i_src_c018_2_12 0 bpf_c018_2 0) vcvs gain=1.950903220161e-01
SMIXI_c018_2_12 (mix_i_src_c018_2_12 mix_i_c018_2 win_2_12 0) relay vt1=-1m vt2=1m ropen=ropen_mix rclosed=rclosed_mix
EMIXQ_c018_2_12 (mix_q_src_c018_2_12 0 bpf_c018_2 0) vcvs gain=-9.807852804032e-01
SMIXQ_c018_2_12 (mix_q_src_c018_2_12 mix_q_c018_2 win_2_12 0) relay vt1=-1m vt2=1m ropen=ropen_mix rclosed=rclosed_mix
EMIXI_c018_2_13 (mix_i_src_c018_2_13 0 bpf_c018_2 0) vcvs gain=5.555702330196e-01
SMIXI_c018_2_13 (mix_i_src_c018_2_13 mix_i_c018_2 win_2_13 0) relay vt1=-1m vt2=1m ropen=ropen_mix rclosed=rclosed_mix
EMIXQ_c018_2_13 (mix_q_src_c018_2_13 0 bpf_c018_2 0) vcvs gain=-8.314696123025e-01
SMIXQ_c018_2_13 (mix_q_src_c018_2_13 mix_q_c018_2 win_2_13 0) relay vt1=-1m vt2=1m ropen=ropen_mix rclosed=rclosed_mix
EMIXI_c018_2_14 (mix_i_src_c018_2_14 0 bpf_c018_2 0) vcvs gain=8.314696123025e-01
SMIXI_c018_2_14 (mix_i_src_c018_2_14 mix_i_c018_2 win_2_14 0) relay vt1=-1m vt2=1m ropen=ropen_mix rclosed=rclosed_mix
EMIXQ_c018_2_14 (mix_q_src_c018_2_14 0 bpf_c018_2 0) vcvs gain=-5.555702330196e-01
SMIXQ_c018_2_14 (mix_q_src_c018_2_14 mix_q_c018_2 win_2_14 0) relay vt1=-1m vt2=1m ropen=ropen_mix rclosed=rclosed_mix
EMIXI_c018_2_15 (mix_i_src_c018_2_15 0 bpf_c018_2 0) vcvs gain=9.807852804032e-01
SMIXI_c018_2_15 (mix_i_src_c018_2_15 mix_i_c018_2 win_2_15 0) relay vt1=-1m vt2=1m ropen=ropen_mix rclosed=rclosed_mix
EMIXQ_c018_2_15 (mix_q_src_c018_2_15 0 bpf_c018_2 0) vcvs gain=-1.950903220161e-01
SMIXQ_c018_2_15 (mix_q_src_c018_2_15 mix_q_c018_2 win_2_15 0) relay vt1=-1m vt2=1m ropen=ropen_mix rclosed=rclosed_mix
RMIXI_c018_2 (mix_i_c018_2 0) resistor r=1G
RMIXQ_c018_2 (mix_q_c018_2 0) resistor r=1G
RINTI_c018_2 (mix_i_c018_2 Icar_c018_2) resistor r=1k
CINTI_c018_2 (Icar_c018_2 0) capacitor c=80p
RINTQ_c018_2 (mix_q_c018_2 Qcar_c018_2) resistor r=1k
CINTQ_c018_2 (Qcar_c018_2 0) capacitor c=80p
save bpf_c018_2 Icar_c018_2 Qcar_c018_2

// bl018, carrier_3: 1000000000 Hz coherent I/Q phase-window verification-demod path
CBPF_c018_3 (bl018 n_cbpf_c018_3) capacitor c=2.533029591058e-14
LBPF_c018_3 (n_cbpf_c018_3 bpf_c018_3) inductor l=1.000000000000e-06
RBPF_c018_3 (bpf_c018_3 0) resistor r=3.141592653590e+02
EMIXI_c018_3_00 (mix_i_src_c018_3_00 0 bpf_c018_3 0) vcvs gain=9.807852804032e-01
SMIXI_c018_3_00 (mix_i_src_c018_3_00 mix_i_c018_3 win_3_00 0) relay vt1=-1m vt2=1m ropen=ropen_mix rclosed=rclosed_mix
EMIXQ_c018_3_00 (mix_q_src_c018_3_00 0 bpf_c018_3 0) vcvs gain=1.950903220161e-01
SMIXQ_c018_3_00 (mix_q_src_c018_3_00 mix_q_c018_3 win_3_00 0) relay vt1=-1m vt2=1m ropen=ropen_mix rclosed=rclosed_mix
EMIXI_c018_3_01 (mix_i_src_c018_3_01 0 bpf_c018_3 0) vcvs gain=8.314696123025e-01
SMIXI_c018_3_01 (mix_i_src_c018_3_01 mix_i_c018_3 win_3_01 0) relay vt1=-1m vt2=1m ropen=ropen_mix rclosed=rclosed_mix
EMIXQ_c018_3_01 (mix_q_src_c018_3_01 0 bpf_c018_3 0) vcvs gain=5.555702330196e-01
SMIXQ_c018_3_01 (mix_q_src_c018_3_01 mix_q_c018_3 win_3_01 0) relay vt1=-1m vt2=1m ropen=ropen_mix rclosed=rclosed_mix
EMIXI_c018_3_02 (mix_i_src_c018_3_02 0 bpf_c018_3 0) vcvs gain=5.555702330196e-01
SMIXI_c018_3_02 (mix_i_src_c018_3_02 mix_i_c018_3 win_3_02 0) relay vt1=-1m vt2=1m ropen=ropen_mix rclosed=rclosed_mix
EMIXQ_c018_3_02 (mix_q_src_c018_3_02 0 bpf_c018_3 0) vcvs gain=8.314696123025e-01
SMIXQ_c018_3_02 (mix_q_src_c018_3_02 mix_q_c018_3 win_3_02 0) relay vt1=-1m vt2=1m ropen=ropen_mix rclosed=rclosed_mix
EMIXI_c018_3_03 (mix_i_src_c018_3_03 0 bpf_c018_3 0) vcvs gain=1.950903220161e-01
SMIXI_c018_3_03 (mix_i_src_c018_3_03 mix_i_c018_3 win_3_03 0) relay vt1=-1m vt2=1m ropen=ropen_mix rclosed=rclosed_mix
EMIXQ_c018_3_03 (mix_q_src_c018_3_03 0 bpf_c018_3 0) vcvs gain=9.807852804032e-01
SMIXQ_c018_3_03 (mix_q_src_c018_3_03 mix_q_c018_3 win_3_03 0) relay vt1=-1m vt2=1m ropen=ropen_mix rclosed=rclosed_mix
EMIXI_c018_3_04 (mix_i_src_c018_3_04 0 bpf_c018_3 0) vcvs gain=-1.950903220161e-01
SMIXI_c018_3_04 (mix_i_src_c018_3_04 mix_i_c018_3 win_3_04 0) relay vt1=-1m vt2=1m ropen=ropen_mix rclosed=rclosed_mix
EMIXQ_c018_3_04 (mix_q_src_c018_3_04 0 bpf_c018_3 0) vcvs gain=9.807852804032e-01
SMIXQ_c018_3_04 (mix_q_src_c018_3_04 mix_q_c018_3 win_3_04 0) relay vt1=-1m vt2=1m ropen=ropen_mix rclosed=rclosed_mix
EMIXI_c018_3_05 (mix_i_src_c018_3_05 0 bpf_c018_3 0) vcvs gain=-5.555702330196e-01
SMIXI_c018_3_05 (mix_i_src_c018_3_05 mix_i_c018_3 win_3_05 0) relay vt1=-1m vt2=1m ropen=ropen_mix rclosed=rclosed_mix
EMIXQ_c018_3_05 (mix_q_src_c018_3_05 0 bpf_c018_3 0) vcvs gain=8.314696123025e-01
SMIXQ_c018_3_05 (mix_q_src_c018_3_05 mix_q_c018_3 win_3_05 0) relay vt1=-1m vt2=1m ropen=ropen_mix rclosed=rclosed_mix
EMIXI_c018_3_06 (mix_i_src_c018_3_06 0 bpf_c018_3 0) vcvs gain=-8.314696123025e-01
SMIXI_c018_3_06 (mix_i_src_c018_3_06 mix_i_c018_3 win_3_06 0) relay vt1=-1m vt2=1m ropen=ropen_mix rclosed=rclosed_mix
EMIXQ_c018_3_06 (mix_q_src_c018_3_06 0 bpf_c018_3 0) vcvs gain=5.555702330196e-01
SMIXQ_c018_3_06 (mix_q_src_c018_3_06 mix_q_c018_3 win_3_06 0) relay vt1=-1m vt2=1m ropen=ropen_mix rclosed=rclosed_mix
EMIXI_c018_3_07 (mix_i_src_c018_3_07 0 bpf_c018_3 0) vcvs gain=-9.807852804032e-01
SMIXI_c018_3_07 (mix_i_src_c018_3_07 mix_i_c018_3 win_3_07 0) relay vt1=-1m vt2=1m ropen=ropen_mix rclosed=rclosed_mix
EMIXQ_c018_3_07 (mix_q_src_c018_3_07 0 bpf_c018_3 0) vcvs gain=1.950903220161e-01
SMIXQ_c018_3_07 (mix_q_src_c018_3_07 mix_q_c018_3 win_3_07 0) relay vt1=-1m vt2=1m ropen=ropen_mix rclosed=rclosed_mix
EMIXI_c018_3_08 (mix_i_src_c018_3_08 0 bpf_c018_3 0) vcvs gain=-9.807852804032e-01
SMIXI_c018_3_08 (mix_i_src_c018_3_08 mix_i_c018_3 win_3_08 0) relay vt1=-1m vt2=1m ropen=ropen_mix rclosed=rclosed_mix
EMIXQ_c018_3_08 (mix_q_src_c018_3_08 0 bpf_c018_3 0) vcvs gain=-1.950903220161e-01
SMIXQ_c018_3_08 (mix_q_src_c018_3_08 mix_q_c018_3 win_3_08 0) relay vt1=-1m vt2=1m ropen=ropen_mix rclosed=rclosed_mix
EMIXI_c018_3_09 (mix_i_src_c018_3_09 0 bpf_c018_3 0) vcvs gain=-8.314696123025e-01
SMIXI_c018_3_09 (mix_i_src_c018_3_09 mix_i_c018_3 win_3_09 0) relay vt1=-1m vt2=1m ropen=ropen_mix rclosed=rclosed_mix
EMIXQ_c018_3_09 (mix_q_src_c018_3_09 0 bpf_c018_3 0) vcvs gain=-5.555702330196e-01
SMIXQ_c018_3_09 (mix_q_src_c018_3_09 mix_q_c018_3 win_3_09 0) relay vt1=-1m vt2=1m ropen=ropen_mix rclosed=rclosed_mix
EMIXI_c018_3_10 (mix_i_src_c018_3_10 0 bpf_c018_3 0) vcvs gain=-5.555702330196e-01
SMIXI_c018_3_10 (mix_i_src_c018_3_10 mix_i_c018_3 win_3_10 0) relay vt1=-1m vt2=1m ropen=ropen_mix rclosed=rclosed_mix
EMIXQ_c018_3_10 (mix_q_src_c018_3_10 0 bpf_c018_3 0) vcvs gain=-8.314696123025e-01
SMIXQ_c018_3_10 (mix_q_src_c018_3_10 mix_q_c018_3 win_3_10 0) relay vt1=-1m vt2=1m ropen=ropen_mix rclosed=rclosed_mix
EMIXI_c018_3_11 (mix_i_src_c018_3_11 0 bpf_c018_3 0) vcvs gain=-1.950903220161e-01
SMIXI_c018_3_11 (mix_i_src_c018_3_11 mix_i_c018_3 win_3_11 0) relay vt1=-1m vt2=1m ropen=ropen_mix rclosed=rclosed_mix
EMIXQ_c018_3_11 (mix_q_src_c018_3_11 0 bpf_c018_3 0) vcvs gain=-9.807852804032e-01
SMIXQ_c018_3_11 (mix_q_src_c018_3_11 mix_q_c018_3 win_3_11 0) relay vt1=-1m vt2=1m ropen=ropen_mix rclosed=rclosed_mix
EMIXI_c018_3_12 (mix_i_src_c018_3_12 0 bpf_c018_3 0) vcvs gain=1.950903220161e-01
SMIXI_c018_3_12 (mix_i_src_c018_3_12 mix_i_c018_3 win_3_12 0) relay vt1=-1m vt2=1m ropen=ropen_mix rclosed=rclosed_mix
EMIXQ_c018_3_12 (mix_q_src_c018_3_12 0 bpf_c018_3 0) vcvs gain=-9.807852804032e-01
SMIXQ_c018_3_12 (mix_q_src_c018_3_12 mix_q_c018_3 win_3_12 0) relay vt1=-1m vt2=1m ropen=ropen_mix rclosed=rclosed_mix
EMIXI_c018_3_13 (mix_i_src_c018_3_13 0 bpf_c018_3 0) vcvs gain=5.555702330196e-01
SMIXI_c018_3_13 (mix_i_src_c018_3_13 mix_i_c018_3 win_3_13 0) relay vt1=-1m vt2=1m ropen=ropen_mix rclosed=rclosed_mix
EMIXQ_c018_3_13 (mix_q_src_c018_3_13 0 bpf_c018_3 0) vcvs gain=-8.314696123025e-01
SMIXQ_c018_3_13 (mix_q_src_c018_3_13 mix_q_c018_3 win_3_13 0) relay vt1=-1m vt2=1m ropen=ropen_mix rclosed=rclosed_mix
EMIXI_c018_3_14 (mix_i_src_c018_3_14 0 bpf_c018_3 0) vcvs gain=8.314696123025e-01
SMIXI_c018_3_14 (mix_i_src_c018_3_14 mix_i_c018_3 win_3_14 0) relay vt1=-1m vt2=1m ropen=ropen_mix rclosed=rclosed_mix
EMIXQ_c018_3_14 (mix_q_src_c018_3_14 0 bpf_c018_3 0) vcvs gain=-5.555702330196e-01
SMIXQ_c018_3_14 (mix_q_src_c018_3_14 mix_q_c018_3 win_3_14 0) relay vt1=-1m vt2=1m ropen=ropen_mix rclosed=rclosed_mix
EMIXI_c018_3_15 (mix_i_src_c018_3_15 0 bpf_c018_3 0) vcvs gain=9.807852804032e-01
SMIXI_c018_3_15 (mix_i_src_c018_3_15 mix_i_c018_3 win_3_15 0) relay vt1=-1m vt2=1m ropen=ropen_mix rclosed=rclosed_mix
EMIXQ_c018_3_15 (mix_q_src_c018_3_15 0 bpf_c018_3 0) vcvs gain=-1.950903220161e-01
SMIXQ_c018_3_15 (mix_q_src_c018_3_15 mix_q_c018_3 win_3_15 0) relay vt1=-1m vt2=1m ropen=ropen_mix rclosed=rclosed_mix
RMIXI_c018_3 (mix_i_c018_3 0) resistor r=1G
RMIXQ_c018_3 (mix_q_c018_3 0) resistor r=1G
RINTI_c018_3 (mix_i_c018_3 Icar_c018_3) resistor r=1k
CINTI_c018_3 (Icar_c018_3 0) capacitor c=80p
RINTQ_c018_3 (mix_q_c018_3 Qcar_c018_3) resistor r=1k
CINTQ_c018_3 (Qcar_c018_3 0) capacitor c=80p
save bpf_c018_3 Icar_c018_3 Qcar_c018_3

// bl019, carrier_0: 250000000 Hz coherent I/Q phase-window verification-demod path
CBPF_c019_0 (bl019 n_cbpf_c019_0) capacitor c=4.052847345694e-13
LBPF_c019_0 (n_cbpf_c019_0 bpf_c019_0) inductor l=1.000000000000e-06
RBPF_c019_0 (bpf_c019_0 0) resistor r=7.853981633974e+01
EMIXI_c019_0_00 (mix_i_src_c019_0_00 0 bpf_c019_0 0) vcvs gain=9.807852804032e-01
SMIXI_c019_0_00 (mix_i_src_c019_0_00 mix_i_c019_0 win_0_00 0) relay vt1=-1m vt2=1m ropen=ropen_mix rclosed=rclosed_mix
EMIXQ_c019_0_00 (mix_q_src_c019_0_00 0 bpf_c019_0 0) vcvs gain=1.950903220161e-01
SMIXQ_c019_0_00 (mix_q_src_c019_0_00 mix_q_c019_0 win_0_00 0) relay vt1=-1m vt2=1m ropen=ropen_mix rclosed=rclosed_mix
EMIXI_c019_0_01 (mix_i_src_c019_0_01 0 bpf_c019_0 0) vcvs gain=8.314696123025e-01
SMIXI_c019_0_01 (mix_i_src_c019_0_01 mix_i_c019_0 win_0_01 0) relay vt1=-1m vt2=1m ropen=ropen_mix rclosed=rclosed_mix
EMIXQ_c019_0_01 (mix_q_src_c019_0_01 0 bpf_c019_0 0) vcvs gain=5.555702330196e-01
SMIXQ_c019_0_01 (mix_q_src_c019_0_01 mix_q_c019_0 win_0_01 0) relay vt1=-1m vt2=1m ropen=ropen_mix rclosed=rclosed_mix
EMIXI_c019_0_02 (mix_i_src_c019_0_02 0 bpf_c019_0 0) vcvs gain=5.555702330196e-01
SMIXI_c019_0_02 (mix_i_src_c019_0_02 mix_i_c019_0 win_0_02 0) relay vt1=-1m vt2=1m ropen=ropen_mix rclosed=rclosed_mix
EMIXQ_c019_0_02 (mix_q_src_c019_0_02 0 bpf_c019_0 0) vcvs gain=8.314696123025e-01
SMIXQ_c019_0_02 (mix_q_src_c019_0_02 mix_q_c019_0 win_0_02 0) relay vt1=-1m vt2=1m ropen=ropen_mix rclosed=rclosed_mix
EMIXI_c019_0_03 (mix_i_src_c019_0_03 0 bpf_c019_0 0) vcvs gain=1.950903220161e-01
SMIXI_c019_0_03 (mix_i_src_c019_0_03 mix_i_c019_0 win_0_03 0) relay vt1=-1m vt2=1m ropen=ropen_mix rclosed=rclosed_mix
EMIXQ_c019_0_03 (mix_q_src_c019_0_03 0 bpf_c019_0 0) vcvs gain=9.807852804032e-01
SMIXQ_c019_0_03 (mix_q_src_c019_0_03 mix_q_c019_0 win_0_03 0) relay vt1=-1m vt2=1m ropen=ropen_mix rclosed=rclosed_mix
EMIXI_c019_0_04 (mix_i_src_c019_0_04 0 bpf_c019_0 0) vcvs gain=-1.950903220161e-01
SMIXI_c019_0_04 (mix_i_src_c019_0_04 mix_i_c019_0 win_0_04 0) relay vt1=-1m vt2=1m ropen=ropen_mix rclosed=rclosed_mix
EMIXQ_c019_0_04 (mix_q_src_c019_0_04 0 bpf_c019_0 0) vcvs gain=9.807852804032e-01
SMIXQ_c019_0_04 (mix_q_src_c019_0_04 mix_q_c019_0 win_0_04 0) relay vt1=-1m vt2=1m ropen=ropen_mix rclosed=rclosed_mix
EMIXI_c019_0_05 (mix_i_src_c019_0_05 0 bpf_c019_0 0) vcvs gain=-5.555702330196e-01
SMIXI_c019_0_05 (mix_i_src_c019_0_05 mix_i_c019_0 win_0_05 0) relay vt1=-1m vt2=1m ropen=ropen_mix rclosed=rclosed_mix
EMIXQ_c019_0_05 (mix_q_src_c019_0_05 0 bpf_c019_0 0) vcvs gain=8.314696123025e-01
SMIXQ_c019_0_05 (mix_q_src_c019_0_05 mix_q_c019_0 win_0_05 0) relay vt1=-1m vt2=1m ropen=ropen_mix rclosed=rclosed_mix
EMIXI_c019_0_06 (mix_i_src_c019_0_06 0 bpf_c019_0 0) vcvs gain=-8.314696123025e-01
SMIXI_c019_0_06 (mix_i_src_c019_0_06 mix_i_c019_0 win_0_06 0) relay vt1=-1m vt2=1m ropen=ropen_mix rclosed=rclosed_mix
EMIXQ_c019_0_06 (mix_q_src_c019_0_06 0 bpf_c019_0 0) vcvs gain=5.555702330196e-01
SMIXQ_c019_0_06 (mix_q_src_c019_0_06 mix_q_c019_0 win_0_06 0) relay vt1=-1m vt2=1m ropen=ropen_mix rclosed=rclosed_mix
EMIXI_c019_0_07 (mix_i_src_c019_0_07 0 bpf_c019_0 0) vcvs gain=-9.807852804032e-01
SMIXI_c019_0_07 (mix_i_src_c019_0_07 mix_i_c019_0 win_0_07 0) relay vt1=-1m vt2=1m ropen=ropen_mix rclosed=rclosed_mix
EMIXQ_c019_0_07 (mix_q_src_c019_0_07 0 bpf_c019_0 0) vcvs gain=1.950903220161e-01
SMIXQ_c019_0_07 (mix_q_src_c019_0_07 mix_q_c019_0 win_0_07 0) relay vt1=-1m vt2=1m ropen=ropen_mix rclosed=rclosed_mix
EMIXI_c019_0_08 (mix_i_src_c019_0_08 0 bpf_c019_0 0) vcvs gain=-9.807852804032e-01
SMIXI_c019_0_08 (mix_i_src_c019_0_08 mix_i_c019_0 win_0_08 0) relay vt1=-1m vt2=1m ropen=ropen_mix rclosed=rclosed_mix
EMIXQ_c019_0_08 (mix_q_src_c019_0_08 0 bpf_c019_0 0) vcvs gain=-1.950903220161e-01
SMIXQ_c019_0_08 (mix_q_src_c019_0_08 mix_q_c019_0 win_0_08 0) relay vt1=-1m vt2=1m ropen=ropen_mix rclosed=rclosed_mix
EMIXI_c019_0_09 (mix_i_src_c019_0_09 0 bpf_c019_0 0) vcvs gain=-8.314696123025e-01
SMIXI_c019_0_09 (mix_i_src_c019_0_09 mix_i_c019_0 win_0_09 0) relay vt1=-1m vt2=1m ropen=ropen_mix rclosed=rclosed_mix
EMIXQ_c019_0_09 (mix_q_src_c019_0_09 0 bpf_c019_0 0) vcvs gain=-5.555702330196e-01
SMIXQ_c019_0_09 (mix_q_src_c019_0_09 mix_q_c019_0 win_0_09 0) relay vt1=-1m vt2=1m ropen=ropen_mix rclosed=rclosed_mix
EMIXI_c019_0_10 (mix_i_src_c019_0_10 0 bpf_c019_0 0) vcvs gain=-5.555702330196e-01
SMIXI_c019_0_10 (mix_i_src_c019_0_10 mix_i_c019_0 win_0_10 0) relay vt1=-1m vt2=1m ropen=ropen_mix rclosed=rclosed_mix
EMIXQ_c019_0_10 (mix_q_src_c019_0_10 0 bpf_c019_0 0) vcvs gain=-8.314696123025e-01
SMIXQ_c019_0_10 (mix_q_src_c019_0_10 mix_q_c019_0 win_0_10 0) relay vt1=-1m vt2=1m ropen=ropen_mix rclosed=rclosed_mix
EMIXI_c019_0_11 (mix_i_src_c019_0_11 0 bpf_c019_0 0) vcvs gain=-1.950903220161e-01
SMIXI_c019_0_11 (mix_i_src_c019_0_11 mix_i_c019_0 win_0_11 0) relay vt1=-1m vt2=1m ropen=ropen_mix rclosed=rclosed_mix
EMIXQ_c019_0_11 (mix_q_src_c019_0_11 0 bpf_c019_0 0) vcvs gain=-9.807852804032e-01
SMIXQ_c019_0_11 (mix_q_src_c019_0_11 mix_q_c019_0 win_0_11 0) relay vt1=-1m vt2=1m ropen=ropen_mix rclosed=rclosed_mix
EMIXI_c019_0_12 (mix_i_src_c019_0_12 0 bpf_c019_0 0) vcvs gain=1.950903220161e-01
SMIXI_c019_0_12 (mix_i_src_c019_0_12 mix_i_c019_0 win_0_12 0) relay vt1=-1m vt2=1m ropen=ropen_mix rclosed=rclosed_mix
EMIXQ_c019_0_12 (mix_q_src_c019_0_12 0 bpf_c019_0 0) vcvs gain=-9.807852804032e-01
SMIXQ_c019_0_12 (mix_q_src_c019_0_12 mix_q_c019_0 win_0_12 0) relay vt1=-1m vt2=1m ropen=ropen_mix rclosed=rclosed_mix
EMIXI_c019_0_13 (mix_i_src_c019_0_13 0 bpf_c019_0 0) vcvs gain=5.555702330196e-01
SMIXI_c019_0_13 (mix_i_src_c019_0_13 mix_i_c019_0 win_0_13 0) relay vt1=-1m vt2=1m ropen=ropen_mix rclosed=rclosed_mix
EMIXQ_c019_0_13 (mix_q_src_c019_0_13 0 bpf_c019_0 0) vcvs gain=-8.314696123025e-01
SMIXQ_c019_0_13 (mix_q_src_c019_0_13 mix_q_c019_0 win_0_13 0) relay vt1=-1m vt2=1m ropen=ropen_mix rclosed=rclosed_mix
EMIXI_c019_0_14 (mix_i_src_c019_0_14 0 bpf_c019_0 0) vcvs gain=8.314696123025e-01
SMIXI_c019_0_14 (mix_i_src_c019_0_14 mix_i_c019_0 win_0_14 0) relay vt1=-1m vt2=1m ropen=ropen_mix rclosed=rclosed_mix
EMIXQ_c019_0_14 (mix_q_src_c019_0_14 0 bpf_c019_0 0) vcvs gain=-5.555702330196e-01
SMIXQ_c019_0_14 (mix_q_src_c019_0_14 mix_q_c019_0 win_0_14 0) relay vt1=-1m vt2=1m ropen=ropen_mix rclosed=rclosed_mix
EMIXI_c019_0_15 (mix_i_src_c019_0_15 0 bpf_c019_0 0) vcvs gain=9.807852804032e-01
SMIXI_c019_0_15 (mix_i_src_c019_0_15 mix_i_c019_0 win_0_15 0) relay vt1=-1m vt2=1m ropen=ropen_mix rclosed=rclosed_mix
EMIXQ_c019_0_15 (mix_q_src_c019_0_15 0 bpf_c019_0 0) vcvs gain=-1.950903220161e-01
SMIXQ_c019_0_15 (mix_q_src_c019_0_15 mix_q_c019_0 win_0_15 0) relay vt1=-1m vt2=1m ropen=ropen_mix rclosed=rclosed_mix
RMIXI_c019_0 (mix_i_c019_0 0) resistor r=1G
RMIXQ_c019_0 (mix_q_c019_0 0) resistor r=1G
RINTI_c019_0 (mix_i_c019_0 Icar_c019_0) resistor r=1k
CINTI_c019_0 (Icar_c019_0 0) capacitor c=80p
RINTQ_c019_0 (mix_q_c019_0 Qcar_c019_0) resistor r=1k
CINTQ_c019_0 (Qcar_c019_0 0) capacitor c=80p
save bpf_c019_0 Icar_c019_0 Qcar_c019_0

// bl019, carrier_1: 500000000 Hz coherent I/Q phase-window verification-demod path
CBPF_c019_1 (bl019 n_cbpf_c019_1) capacitor c=1.013211836423e-13
LBPF_c019_1 (n_cbpf_c019_1 bpf_c019_1) inductor l=1.000000000000e-06
RBPF_c019_1 (bpf_c019_1 0) resistor r=1.570796326795e+02
EMIXI_c019_1_00 (mix_i_src_c019_1_00 0 bpf_c019_1 0) vcvs gain=9.807852804032e-01
SMIXI_c019_1_00 (mix_i_src_c019_1_00 mix_i_c019_1 win_1_00 0) relay vt1=-1m vt2=1m ropen=ropen_mix rclosed=rclosed_mix
EMIXQ_c019_1_00 (mix_q_src_c019_1_00 0 bpf_c019_1 0) vcvs gain=1.950903220161e-01
SMIXQ_c019_1_00 (mix_q_src_c019_1_00 mix_q_c019_1 win_1_00 0) relay vt1=-1m vt2=1m ropen=ropen_mix rclosed=rclosed_mix
EMIXI_c019_1_01 (mix_i_src_c019_1_01 0 bpf_c019_1 0) vcvs gain=8.314696123025e-01
SMIXI_c019_1_01 (mix_i_src_c019_1_01 mix_i_c019_1 win_1_01 0) relay vt1=-1m vt2=1m ropen=ropen_mix rclosed=rclosed_mix
EMIXQ_c019_1_01 (mix_q_src_c019_1_01 0 bpf_c019_1 0) vcvs gain=5.555702330196e-01
SMIXQ_c019_1_01 (mix_q_src_c019_1_01 mix_q_c019_1 win_1_01 0) relay vt1=-1m vt2=1m ropen=ropen_mix rclosed=rclosed_mix
EMIXI_c019_1_02 (mix_i_src_c019_1_02 0 bpf_c019_1 0) vcvs gain=5.555702330196e-01
SMIXI_c019_1_02 (mix_i_src_c019_1_02 mix_i_c019_1 win_1_02 0) relay vt1=-1m vt2=1m ropen=ropen_mix rclosed=rclosed_mix
EMIXQ_c019_1_02 (mix_q_src_c019_1_02 0 bpf_c019_1 0) vcvs gain=8.314696123025e-01
SMIXQ_c019_1_02 (mix_q_src_c019_1_02 mix_q_c019_1 win_1_02 0) relay vt1=-1m vt2=1m ropen=ropen_mix rclosed=rclosed_mix
EMIXI_c019_1_03 (mix_i_src_c019_1_03 0 bpf_c019_1 0) vcvs gain=1.950903220161e-01
SMIXI_c019_1_03 (mix_i_src_c019_1_03 mix_i_c019_1 win_1_03 0) relay vt1=-1m vt2=1m ropen=ropen_mix rclosed=rclosed_mix
EMIXQ_c019_1_03 (mix_q_src_c019_1_03 0 bpf_c019_1 0) vcvs gain=9.807852804032e-01
SMIXQ_c019_1_03 (mix_q_src_c019_1_03 mix_q_c019_1 win_1_03 0) relay vt1=-1m vt2=1m ropen=ropen_mix rclosed=rclosed_mix
EMIXI_c019_1_04 (mix_i_src_c019_1_04 0 bpf_c019_1 0) vcvs gain=-1.950903220161e-01
SMIXI_c019_1_04 (mix_i_src_c019_1_04 mix_i_c019_1 win_1_04 0) relay vt1=-1m vt2=1m ropen=ropen_mix rclosed=rclosed_mix
EMIXQ_c019_1_04 (mix_q_src_c019_1_04 0 bpf_c019_1 0) vcvs gain=9.807852804032e-01
SMIXQ_c019_1_04 (mix_q_src_c019_1_04 mix_q_c019_1 win_1_04 0) relay vt1=-1m vt2=1m ropen=ropen_mix rclosed=rclosed_mix
EMIXI_c019_1_05 (mix_i_src_c019_1_05 0 bpf_c019_1 0) vcvs gain=-5.555702330196e-01
SMIXI_c019_1_05 (mix_i_src_c019_1_05 mix_i_c019_1 win_1_05 0) relay vt1=-1m vt2=1m ropen=ropen_mix rclosed=rclosed_mix
EMIXQ_c019_1_05 (mix_q_src_c019_1_05 0 bpf_c019_1 0) vcvs gain=8.314696123025e-01
SMIXQ_c019_1_05 (mix_q_src_c019_1_05 mix_q_c019_1 win_1_05 0) relay vt1=-1m vt2=1m ropen=ropen_mix rclosed=rclosed_mix
EMIXI_c019_1_06 (mix_i_src_c019_1_06 0 bpf_c019_1 0) vcvs gain=-8.314696123025e-01
SMIXI_c019_1_06 (mix_i_src_c019_1_06 mix_i_c019_1 win_1_06 0) relay vt1=-1m vt2=1m ropen=ropen_mix rclosed=rclosed_mix
EMIXQ_c019_1_06 (mix_q_src_c019_1_06 0 bpf_c019_1 0) vcvs gain=5.555702330196e-01
SMIXQ_c019_1_06 (mix_q_src_c019_1_06 mix_q_c019_1 win_1_06 0) relay vt1=-1m vt2=1m ropen=ropen_mix rclosed=rclosed_mix
EMIXI_c019_1_07 (mix_i_src_c019_1_07 0 bpf_c019_1 0) vcvs gain=-9.807852804032e-01
SMIXI_c019_1_07 (mix_i_src_c019_1_07 mix_i_c019_1 win_1_07 0) relay vt1=-1m vt2=1m ropen=ropen_mix rclosed=rclosed_mix
EMIXQ_c019_1_07 (mix_q_src_c019_1_07 0 bpf_c019_1 0) vcvs gain=1.950903220161e-01
SMIXQ_c019_1_07 (mix_q_src_c019_1_07 mix_q_c019_1 win_1_07 0) relay vt1=-1m vt2=1m ropen=ropen_mix rclosed=rclosed_mix
EMIXI_c019_1_08 (mix_i_src_c019_1_08 0 bpf_c019_1 0) vcvs gain=-9.807852804032e-01
SMIXI_c019_1_08 (mix_i_src_c019_1_08 mix_i_c019_1 win_1_08 0) relay vt1=-1m vt2=1m ropen=ropen_mix rclosed=rclosed_mix
EMIXQ_c019_1_08 (mix_q_src_c019_1_08 0 bpf_c019_1 0) vcvs gain=-1.950903220161e-01
SMIXQ_c019_1_08 (mix_q_src_c019_1_08 mix_q_c019_1 win_1_08 0) relay vt1=-1m vt2=1m ropen=ropen_mix rclosed=rclosed_mix
EMIXI_c019_1_09 (mix_i_src_c019_1_09 0 bpf_c019_1 0) vcvs gain=-8.314696123025e-01
SMIXI_c019_1_09 (mix_i_src_c019_1_09 mix_i_c019_1 win_1_09 0) relay vt1=-1m vt2=1m ropen=ropen_mix rclosed=rclosed_mix
EMIXQ_c019_1_09 (mix_q_src_c019_1_09 0 bpf_c019_1 0) vcvs gain=-5.555702330196e-01
SMIXQ_c019_1_09 (mix_q_src_c019_1_09 mix_q_c019_1 win_1_09 0) relay vt1=-1m vt2=1m ropen=ropen_mix rclosed=rclosed_mix
EMIXI_c019_1_10 (mix_i_src_c019_1_10 0 bpf_c019_1 0) vcvs gain=-5.555702330196e-01
SMIXI_c019_1_10 (mix_i_src_c019_1_10 mix_i_c019_1 win_1_10 0) relay vt1=-1m vt2=1m ropen=ropen_mix rclosed=rclosed_mix
EMIXQ_c019_1_10 (mix_q_src_c019_1_10 0 bpf_c019_1 0) vcvs gain=-8.314696123025e-01
SMIXQ_c019_1_10 (mix_q_src_c019_1_10 mix_q_c019_1 win_1_10 0) relay vt1=-1m vt2=1m ropen=ropen_mix rclosed=rclosed_mix
EMIXI_c019_1_11 (mix_i_src_c019_1_11 0 bpf_c019_1 0) vcvs gain=-1.950903220161e-01
SMIXI_c019_1_11 (mix_i_src_c019_1_11 mix_i_c019_1 win_1_11 0) relay vt1=-1m vt2=1m ropen=ropen_mix rclosed=rclosed_mix
EMIXQ_c019_1_11 (mix_q_src_c019_1_11 0 bpf_c019_1 0) vcvs gain=-9.807852804032e-01
SMIXQ_c019_1_11 (mix_q_src_c019_1_11 mix_q_c019_1 win_1_11 0) relay vt1=-1m vt2=1m ropen=ropen_mix rclosed=rclosed_mix
EMIXI_c019_1_12 (mix_i_src_c019_1_12 0 bpf_c019_1 0) vcvs gain=1.950903220161e-01
SMIXI_c019_1_12 (mix_i_src_c019_1_12 mix_i_c019_1 win_1_12 0) relay vt1=-1m vt2=1m ropen=ropen_mix rclosed=rclosed_mix
EMIXQ_c019_1_12 (mix_q_src_c019_1_12 0 bpf_c019_1 0) vcvs gain=-9.807852804032e-01
SMIXQ_c019_1_12 (mix_q_src_c019_1_12 mix_q_c019_1 win_1_12 0) relay vt1=-1m vt2=1m ropen=ropen_mix rclosed=rclosed_mix
EMIXI_c019_1_13 (mix_i_src_c019_1_13 0 bpf_c019_1 0) vcvs gain=5.555702330196e-01
SMIXI_c019_1_13 (mix_i_src_c019_1_13 mix_i_c019_1 win_1_13 0) relay vt1=-1m vt2=1m ropen=ropen_mix rclosed=rclosed_mix
EMIXQ_c019_1_13 (mix_q_src_c019_1_13 0 bpf_c019_1 0) vcvs gain=-8.314696123025e-01
SMIXQ_c019_1_13 (mix_q_src_c019_1_13 mix_q_c019_1 win_1_13 0) relay vt1=-1m vt2=1m ropen=ropen_mix rclosed=rclosed_mix
EMIXI_c019_1_14 (mix_i_src_c019_1_14 0 bpf_c019_1 0) vcvs gain=8.314696123025e-01
SMIXI_c019_1_14 (mix_i_src_c019_1_14 mix_i_c019_1 win_1_14 0) relay vt1=-1m vt2=1m ropen=ropen_mix rclosed=rclosed_mix
EMIXQ_c019_1_14 (mix_q_src_c019_1_14 0 bpf_c019_1 0) vcvs gain=-5.555702330196e-01
SMIXQ_c019_1_14 (mix_q_src_c019_1_14 mix_q_c019_1 win_1_14 0) relay vt1=-1m vt2=1m ropen=ropen_mix rclosed=rclosed_mix
EMIXI_c019_1_15 (mix_i_src_c019_1_15 0 bpf_c019_1 0) vcvs gain=9.807852804032e-01
SMIXI_c019_1_15 (mix_i_src_c019_1_15 mix_i_c019_1 win_1_15 0) relay vt1=-1m vt2=1m ropen=ropen_mix rclosed=rclosed_mix
EMIXQ_c019_1_15 (mix_q_src_c019_1_15 0 bpf_c019_1 0) vcvs gain=-1.950903220161e-01
SMIXQ_c019_1_15 (mix_q_src_c019_1_15 mix_q_c019_1 win_1_15 0) relay vt1=-1m vt2=1m ropen=ropen_mix rclosed=rclosed_mix
RMIXI_c019_1 (mix_i_c019_1 0) resistor r=1G
RMIXQ_c019_1 (mix_q_c019_1 0) resistor r=1G
RINTI_c019_1 (mix_i_c019_1 Icar_c019_1) resistor r=1k
CINTI_c019_1 (Icar_c019_1 0) capacitor c=80p
RINTQ_c019_1 (mix_q_c019_1 Qcar_c019_1) resistor r=1k
CINTQ_c019_1 (Qcar_c019_1 0) capacitor c=80p
save bpf_c019_1 Icar_c019_1 Qcar_c019_1

// bl019, carrier_2: 750000000 Hz coherent I/Q phase-window verification-demod path
CBPF_c019_2 (bl019 n_cbpf_c019_2) capacitor c=4.503163717437e-14
LBPF_c019_2 (n_cbpf_c019_2 bpf_c019_2) inductor l=1.000000000000e-06
RBPF_c019_2 (bpf_c019_2 0) resistor r=2.356194490192e+02
EMIXI_c019_2_00 (mix_i_src_c019_2_00 0 bpf_c019_2 0) vcvs gain=9.807852804032e-01
SMIXI_c019_2_00 (mix_i_src_c019_2_00 mix_i_c019_2 win_2_00 0) relay vt1=-1m vt2=1m ropen=ropen_mix rclosed=rclosed_mix
EMIXQ_c019_2_00 (mix_q_src_c019_2_00 0 bpf_c019_2 0) vcvs gain=1.950903220161e-01
SMIXQ_c019_2_00 (mix_q_src_c019_2_00 mix_q_c019_2 win_2_00 0) relay vt1=-1m vt2=1m ropen=ropen_mix rclosed=rclosed_mix
EMIXI_c019_2_01 (mix_i_src_c019_2_01 0 bpf_c019_2 0) vcvs gain=8.314696123025e-01
SMIXI_c019_2_01 (mix_i_src_c019_2_01 mix_i_c019_2 win_2_01 0) relay vt1=-1m vt2=1m ropen=ropen_mix rclosed=rclosed_mix
EMIXQ_c019_2_01 (mix_q_src_c019_2_01 0 bpf_c019_2 0) vcvs gain=5.555702330196e-01
SMIXQ_c019_2_01 (mix_q_src_c019_2_01 mix_q_c019_2 win_2_01 0) relay vt1=-1m vt2=1m ropen=ropen_mix rclosed=rclosed_mix
EMIXI_c019_2_02 (mix_i_src_c019_2_02 0 bpf_c019_2 0) vcvs gain=5.555702330196e-01
SMIXI_c019_2_02 (mix_i_src_c019_2_02 mix_i_c019_2 win_2_02 0) relay vt1=-1m vt2=1m ropen=ropen_mix rclosed=rclosed_mix
EMIXQ_c019_2_02 (mix_q_src_c019_2_02 0 bpf_c019_2 0) vcvs gain=8.314696123025e-01
SMIXQ_c019_2_02 (mix_q_src_c019_2_02 mix_q_c019_2 win_2_02 0) relay vt1=-1m vt2=1m ropen=ropen_mix rclosed=rclosed_mix
EMIXI_c019_2_03 (mix_i_src_c019_2_03 0 bpf_c019_2 0) vcvs gain=1.950903220161e-01
SMIXI_c019_2_03 (mix_i_src_c019_2_03 mix_i_c019_2 win_2_03 0) relay vt1=-1m vt2=1m ropen=ropen_mix rclosed=rclosed_mix
EMIXQ_c019_2_03 (mix_q_src_c019_2_03 0 bpf_c019_2 0) vcvs gain=9.807852804032e-01
SMIXQ_c019_2_03 (mix_q_src_c019_2_03 mix_q_c019_2 win_2_03 0) relay vt1=-1m vt2=1m ropen=ropen_mix rclosed=rclosed_mix
EMIXI_c019_2_04 (mix_i_src_c019_2_04 0 bpf_c019_2 0) vcvs gain=-1.950903220161e-01
SMIXI_c019_2_04 (mix_i_src_c019_2_04 mix_i_c019_2 win_2_04 0) relay vt1=-1m vt2=1m ropen=ropen_mix rclosed=rclosed_mix
EMIXQ_c019_2_04 (mix_q_src_c019_2_04 0 bpf_c019_2 0) vcvs gain=9.807852804032e-01
SMIXQ_c019_2_04 (mix_q_src_c019_2_04 mix_q_c019_2 win_2_04 0) relay vt1=-1m vt2=1m ropen=ropen_mix rclosed=rclosed_mix
EMIXI_c019_2_05 (mix_i_src_c019_2_05 0 bpf_c019_2 0) vcvs gain=-5.555702330196e-01
SMIXI_c019_2_05 (mix_i_src_c019_2_05 mix_i_c019_2 win_2_05 0) relay vt1=-1m vt2=1m ropen=ropen_mix rclosed=rclosed_mix
EMIXQ_c019_2_05 (mix_q_src_c019_2_05 0 bpf_c019_2 0) vcvs gain=8.314696123025e-01
SMIXQ_c019_2_05 (mix_q_src_c019_2_05 mix_q_c019_2 win_2_05 0) relay vt1=-1m vt2=1m ropen=ropen_mix rclosed=rclosed_mix
EMIXI_c019_2_06 (mix_i_src_c019_2_06 0 bpf_c019_2 0) vcvs gain=-8.314696123025e-01
SMIXI_c019_2_06 (mix_i_src_c019_2_06 mix_i_c019_2 win_2_06 0) relay vt1=-1m vt2=1m ropen=ropen_mix rclosed=rclosed_mix
EMIXQ_c019_2_06 (mix_q_src_c019_2_06 0 bpf_c019_2 0) vcvs gain=5.555702330196e-01
SMIXQ_c019_2_06 (mix_q_src_c019_2_06 mix_q_c019_2 win_2_06 0) relay vt1=-1m vt2=1m ropen=ropen_mix rclosed=rclosed_mix
EMIXI_c019_2_07 (mix_i_src_c019_2_07 0 bpf_c019_2 0) vcvs gain=-9.807852804032e-01
SMIXI_c019_2_07 (mix_i_src_c019_2_07 mix_i_c019_2 win_2_07 0) relay vt1=-1m vt2=1m ropen=ropen_mix rclosed=rclosed_mix
EMIXQ_c019_2_07 (mix_q_src_c019_2_07 0 bpf_c019_2 0) vcvs gain=1.950903220161e-01
SMIXQ_c019_2_07 (mix_q_src_c019_2_07 mix_q_c019_2 win_2_07 0) relay vt1=-1m vt2=1m ropen=ropen_mix rclosed=rclosed_mix
EMIXI_c019_2_08 (mix_i_src_c019_2_08 0 bpf_c019_2 0) vcvs gain=-9.807852804032e-01
SMIXI_c019_2_08 (mix_i_src_c019_2_08 mix_i_c019_2 win_2_08 0) relay vt1=-1m vt2=1m ropen=ropen_mix rclosed=rclosed_mix
EMIXQ_c019_2_08 (mix_q_src_c019_2_08 0 bpf_c019_2 0) vcvs gain=-1.950903220161e-01
SMIXQ_c019_2_08 (mix_q_src_c019_2_08 mix_q_c019_2 win_2_08 0) relay vt1=-1m vt2=1m ropen=ropen_mix rclosed=rclosed_mix
EMIXI_c019_2_09 (mix_i_src_c019_2_09 0 bpf_c019_2 0) vcvs gain=-8.314696123025e-01
SMIXI_c019_2_09 (mix_i_src_c019_2_09 mix_i_c019_2 win_2_09 0) relay vt1=-1m vt2=1m ropen=ropen_mix rclosed=rclosed_mix
EMIXQ_c019_2_09 (mix_q_src_c019_2_09 0 bpf_c019_2 0) vcvs gain=-5.555702330196e-01
SMIXQ_c019_2_09 (mix_q_src_c019_2_09 mix_q_c019_2 win_2_09 0) relay vt1=-1m vt2=1m ropen=ropen_mix rclosed=rclosed_mix
EMIXI_c019_2_10 (mix_i_src_c019_2_10 0 bpf_c019_2 0) vcvs gain=-5.555702330196e-01
SMIXI_c019_2_10 (mix_i_src_c019_2_10 mix_i_c019_2 win_2_10 0) relay vt1=-1m vt2=1m ropen=ropen_mix rclosed=rclosed_mix
EMIXQ_c019_2_10 (mix_q_src_c019_2_10 0 bpf_c019_2 0) vcvs gain=-8.314696123025e-01
SMIXQ_c019_2_10 (mix_q_src_c019_2_10 mix_q_c019_2 win_2_10 0) relay vt1=-1m vt2=1m ropen=ropen_mix rclosed=rclosed_mix
EMIXI_c019_2_11 (mix_i_src_c019_2_11 0 bpf_c019_2 0) vcvs gain=-1.950903220161e-01
SMIXI_c019_2_11 (mix_i_src_c019_2_11 mix_i_c019_2 win_2_11 0) relay vt1=-1m vt2=1m ropen=ropen_mix rclosed=rclosed_mix
EMIXQ_c019_2_11 (mix_q_src_c019_2_11 0 bpf_c019_2 0) vcvs gain=-9.807852804032e-01
SMIXQ_c019_2_11 (mix_q_src_c019_2_11 mix_q_c019_2 win_2_11 0) relay vt1=-1m vt2=1m ropen=ropen_mix rclosed=rclosed_mix
EMIXI_c019_2_12 (mix_i_src_c019_2_12 0 bpf_c019_2 0) vcvs gain=1.950903220161e-01
SMIXI_c019_2_12 (mix_i_src_c019_2_12 mix_i_c019_2 win_2_12 0) relay vt1=-1m vt2=1m ropen=ropen_mix rclosed=rclosed_mix
EMIXQ_c019_2_12 (mix_q_src_c019_2_12 0 bpf_c019_2 0) vcvs gain=-9.807852804032e-01
SMIXQ_c019_2_12 (mix_q_src_c019_2_12 mix_q_c019_2 win_2_12 0) relay vt1=-1m vt2=1m ropen=ropen_mix rclosed=rclosed_mix
EMIXI_c019_2_13 (mix_i_src_c019_2_13 0 bpf_c019_2 0) vcvs gain=5.555702330196e-01
SMIXI_c019_2_13 (mix_i_src_c019_2_13 mix_i_c019_2 win_2_13 0) relay vt1=-1m vt2=1m ropen=ropen_mix rclosed=rclosed_mix
EMIXQ_c019_2_13 (mix_q_src_c019_2_13 0 bpf_c019_2 0) vcvs gain=-8.314696123025e-01
SMIXQ_c019_2_13 (mix_q_src_c019_2_13 mix_q_c019_2 win_2_13 0) relay vt1=-1m vt2=1m ropen=ropen_mix rclosed=rclosed_mix
EMIXI_c019_2_14 (mix_i_src_c019_2_14 0 bpf_c019_2 0) vcvs gain=8.314696123025e-01
SMIXI_c019_2_14 (mix_i_src_c019_2_14 mix_i_c019_2 win_2_14 0) relay vt1=-1m vt2=1m ropen=ropen_mix rclosed=rclosed_mix
EMIXQ_c019_2_14 (mix_q_src_c019_2_14 0 bpf_c019_2 0) vcvs gain=-5.555702330196e-01
SMIXQ_c019_2_14 (mix_q_src_c019_2_14 mix_q_c019_2 win_2_14 0) relay vt1=-1m vt2=1m ropen=ropen_mix rclosed=rclosed_mix
EMIXI_c019_2_15 (mix_i_src_c019_2_15 0 bpf_c019_2 0) vcvs gain=9.807852804032e-01
SMIXI_c019_2_15 (mix_i_src_c019_2_15 mix_i_c019_2 win_2_15 0) relay vt1=-1m vt2=1m ropen=ropen_mix rclosed=rclosed_mix
EMIXQ_c019_2_15 (mix_q_src_c019_2_15 0 bpf_c019_2 0) vcvs gain=-1.950903220161e-01
SMIXQ_c019_2_15 (mix_q_src_c019_2_15 mix_q_c019_2 win_2_15 0) relay vt1=-1m vt2=1m ropen=ropen_mix rclosed=rclosed_mix
RMIXI_c019_2 (mix_i_c019_2 0) resistor r=1G
RMIXQ_c019_2 (mix_q_c019_2 0) resistor r=1G
RINTI_c019_2 (mix_i_c019_2 Icar_c019_2) resistor r=1k
CINTI_c019_2 (Icar_c019_2 0) capacitor c=80p
RINTQ_c019_2 (mix_q_c019_2 Qcar_c019_2) resistor r=1k
CINTQ_c019_2 (Qcar_c019_2 0) capacitor c=80p
save bpf_c019_2 Icar_c019_2 Qcar_c019_2

// bl019, carrier_3: 1000000000 Hz coherent I/Q phase-window verification-demod path
CBPF_c019_3 (bl019 n_cbpf_c019_3) capacitor c=2.533029591058e-14
LBPF_c019_3 (n_cbpf_c019_3 bpf_c019_3) inductor l=1.000000000000e-06
RBPF_c019_3 (bpf_c019_3 0) resistor r=3.141592653590e+02
EMIXI_c019_3_00 (mix_i_src_c019_3_00 0 bpf_c019_3 0) vcvs gain=9.807852804032e-01
SMIXI_c019_3_00 (mix_i_src_c019_3_00 mix_i_c019_3 win_3_00 0) relay vt1=-1m vt2=1m ropen=ropen_mix rclosed=rclosed_mix
EMIXQ_c019_3_00 (mix_q_src_c019_3_00 0 bpf_c019_3 0) vcvs gain=1.950903220161e-01
SMIXQ_c019_3_00 (mix_q_src_c019_3_00 mix_q_c019_3 win_3_00 0) relay vt1=-1m vt2=1m ropen=ropen_mix rclosed=rclosed_mix
EMIXI_c019_3_01 (mix_i_src_c019_3_01 0 bpf_c019_3 0) vcvs gain=8.314696123025e-01
SMIXI_c019_3_01 (mix_i_src_c019_3_01 mix_i_c019_3 win_3_01 0) relay vt1=-1m vt2=1m ropen=ropen_mix rclosed=rclosed_mix
EMIXQ_c019_3_01 (mix_q_src_c019_3_01 0 bpf_c019_3 0) vcvs gain=5.555702330196e-01
SMIXQ_c019_3_01 (mix_q_src_c019_3_01 mix_q_c019_3 win_3_01 0) relay vt1=-1m vt2=1m ropen=ropen_mix rclosed=rclosed_mix
EMIXI_c019_3_02 (mix_i_src_c019_3_02 0 bpf_c019_3 0) vcvs gain=5.555702330196e-01
SMIXI_c019_3_02 (mix_i_src_c019_3_02 mix_i_c019_3 win_3_02 0) relay vt1=-1m vt2=1m ropen=ropen_mix rclosed=rclosed_mix
EMIXQ_c019_3_02 (mix_q_src_c019_3_02 0 bpf_c019_3 0) vcvs gain=8.314696123025e-01
SMIXQ_c019_3_02 (mix_q_src_c019_3_02 mix_q_c019_3 win_3_02 0) relay vt1=-1m vt2=1m ropen=ropen_mix rclosed=rclosed_mix
EMIXI_c019_3_03 (mix_i_src_c019_3_03 0 bpf_c019_3 0) vcvs gain=1.950903220161e-01
SMIXI_c019_3_03 (mix_i_src_c019_3_03 mix_i_c019_3 win_3_03 0) relay vt1=-1m vt2=1m ropen=ropen_mix rclosed=rclosed_mix
EMIXQ_c019_3_03 (mix_q_src_c019_3_03 0 bpf_c019_3 0) vcvs gain=9.807852804032e-01
SMIXQ_c019_3_03 (mix_q_src_c019_3_03 mix_q_c019_3 win_3_03 0) relay vt1=-1m vt2=1m ropen=ropen_mix rclosed=rclosed_mix
EMIXI_c019_3_04 (mix_i_src_c019_3_04 0 bpf_c019_3 0) vcvs gain=-1.950903220161e-01
SMIXI_c019_3_04 (mix_i_src_c019_3_04 mix_i_c019_3 win_3_04 0) relay vt1=-1m vt2=1m ropen=ropen_mix rclosed=rclosed_mix
EMIXQ_c019_3_04 (mix_q_src_c019_3_04 0 bpf_c019_3 0) vcvs gain=9.807852804032e-01
SMIXQ_c019_3_04 (mix_q_src_c019_3_04 mix_q_c019_3 win_3_04 0) relay vt1=-1m vt2=1m ropen=ropen_mix rclosed=rclosed_mix
EMIXI_c019_3_05 (mix_i_src_c019_3_05 0 bpf_c019_3 0) vcvs gain=-5.555702330196e-01
SMIXI_c019_3_05 (mix_i_src_c019_3_05 mix_i_c019_3 win_3_05 0) relay vt1=-1m vt2=1m ropen=ropen_mix rclosed=rclosed_mix
EMIXQ_c019_3_05 (mix_q_src_c019_3_05 0 bpf_c019_3 0) vcvs gain=8.314696123025e-01
SMIXQ_c019_3_05 (mix_q_src_c019_3_05 mix_q_c019_3 win_3_05 0) relay vt1=-1m vt2=1m ropen=ropen_mix rclosed=rclosed_mix
EMIXI_c019_3_06 (mix_i_src_c019_3_06 0 bpf_c019_3 0) vcvs gain=-8.314696123025e-01
SMIXI_c019_3_06 (mix_i_src_c019_3_06 mix_i_c019_3 win_3_06 0) relay vt1=-1m vt2=1m ropen=ropen_mix rclosed=rclosed_mix
EMIXQ_c019_3_06 (mix_q_src_c019_3_06 0 bpf_c019_3 0) vcvs gain=5.555702330196e-01
SMIXQ_c019_3_06 (mix_q_src_c019_3_06 mix_q_c019_3 win_3_06 0) relay vt1=-1m vt2=1m ropen=ropen_mix rclosed=rclosed_mix
EMIXI_c019_3_07 (mix_i_src_c019_3_07 0 bpf_c019_3 0) vcvs gain=-9.807852804032e-01
SMIXI_c019_3_07 (mix_i_src_c019_3_07 mix_i_c019_3 win_3_07 0) relay vt1=-1m vt2=1m ropen=ropen_mix rclosed=rclosed_mix
EMIXQ_c019_3_07 (mix_q_src_c019_3_07 0 bpf_c019_3 0) vcvs gain=1.950903220161e-01
SMIXQ_c019_3_07 (mix_q_src_c019_3_07 mix_q_c019_3 win_3_07 0) relay vt1=-1m vt2=1m ropen=ropen_mix rclosed=rclosed_mix
EMIXI_c019_3_08 (mix_i_src_c019_3_08 0 bpf_c019_3 0) vcvs gain=-9.807852804032e-01
SMIXI_c019_3_08 (mix_i_src_c019_3_08 mix_i_c019_3 win_3_08 0) relay vt1=-1m vt2=1m ropen=ropen_mix rclosed=rclosed_mix
EMIXQ_c019_3_08 (mix_q_src_c019_3_08 0 bpf_c019_3 0) vcvs gain=-1.950903220161e-01
SMIXQ_c019_3_08 (mix_q_src_c019_3_08 mix_q_c019_3 win_3_08 0) relay vt1=-1m vt2=1m ropen=ropen_mix rclosed=rclosed_mix
EMIXI_c019_3_09 (mix_i_src_c019_3_09 0 bpf_c019_3 0) vcvs gain=-8.314696123025e-01
SMIXI_c019_3_09 (mix_i_src_c019_3_09 mix_i_c019_3 win_3_09 0) relay vt1=-1m vt2=1m ropen=ropen_mix rclosed=rclosed_mix
EMIXQ_c019_3_09 (mix_q_src_c019_3_09 0 bpf_c019_3 0) vcvs gain=-5.555702330196e-01
SMIXQ_c019_3_09 (mix_q_src_c019_3_09 mix_q_c019_3 win_3_09 0) relay vt1=-1m vt2=1m ropen=ropen_mix rclosed=rclosed_mix
EMIXI_c019_3_10 (mix_i_src_c019_3_10 0 bpf_c019_3 0) vcvs gain=-5.555702330196e-01
SMIXI_c019_3_10 (mix_i_src_c019_3_10 mix_i_c019_3 win_3_10 0) relay vt1=-1m vt2=1m ropen=ropen_mix rclosed=rclosed_mix
EMIXQ_c019_3_10 (mix_q_src_c019_3_10 0 bpf_c019_3 0) vcvs gain=-8.314696123025e-01
SMIXQ_c019_3_10 (mix_q_src_c019_3_10 mix_q_c019_3 win_3_10 0) relay vt1=-1m vt2=1m ropen=ropen_mix rclosed=rclosed_mix
EMIXI_c019_3_11 (mix_i_src_c019_3_11 0 bpf_c019_3 0) vcvs gain=-1.950903220161e-01
SMIXI_c019_3_11 (mix_i_src_c019_3_11 mix_i_c019_3 win_3_11 0) relay vt1=-1m vt2=1m ropen=ropen_mix rclosed=rclosed_mix
EMIXQ_c019_3_11 (mix_q_src_c019_3_11 0 bpf_c019_3 0) vcvs gain=-9.807852804032e-01
SMIXQ_c019_3_11 (mix_q_src_c019_3_11 mix_q_c019_3 win_3_11 0) relay vt1=-1m vt2=1m ropen=ropen_mix rclosed=rclosed_mix
EMIXI_c019_3_12 (mix_i_src_c019_3_12 0 bpf_c019_3 0) vcvs gain=1.950903220161e-01
SMIXI_c019_3_12 (mix_i_src_c019_3_12 mix_i_c019_3 win_3_12 0) relay vt1=-1m vt2=1m ropen=ropen_mix rclosed=rclosed_mix
EMIXQ_c019_3_12 (mix_q_src_c019_3_12 0 bpf_c019_3 0) vcvs gain=-9.807852804032e-01
SMIXQ_c019_3_12 (mix_q_src_c019_3_12 mix_q_c019_3 win_3_12 0) relay vt1=-1m vt2=1m ropen=ropen_mix rclosed=rclosed_mix
EMIXI_c019_3_13 (mix_i_src_c019_3_13 0 bpf_c019_3 0) vcvs gain=5.555702330196e-01
SMIXI_c019_3_13 (mix_i_src_c019_3_13 mix_i_c019_3 win_3_13 0) relay vt1=-1m vt2=1m ropen=ropen_mix rclosed=rclosed_mix
EMIXQ_c019_3_13 (mix_q_src_c019_3_13 0 bpf_c019_3 0) vcvs gain=-8.314696123025e-01
SMIXQ_c019_3_13 (mix_q_src_c019_3_13 mix_q_c019_3 win_3_13 0) relay vt1=-1m vt2=1m ropen=ropen_mix rclosed=rclosed_mix
EMIXI_c019_3_14 (mix_i_src_c019_3_14 0 bpf_c019_3 0) vcvs gain=8.314696123025e-01
SMIXI_c019_3_14 (mix_i_src_c019_3_14 mix_i_c019_3 win_3_14 0) relay vt1=-1m vt2=1m ropen=ropen_mix rclosed=rclosed_mix
EMIXQ_c019_3_14 (mix_q_src_c019_3_14 0 bpf_c019_3 0) vcvs gain=-5.555702330196e-01
SMIXQ_c019_3_14 (mix_q_src_c019_3_14 mix_q_c019_3 win_3_14 0) relay vt1=-1m vt2=1m ropen=ropen_mix rclosed=rclosed_mix
EMIXI_c019_3_15 (mix_i_src_c019_3_15 0 bpf_c019_3 0) vcvs gain=9.807852804032e-01
SMIXI_c019_3_15 (mix_i_src_c019_3_15 mix_i_c019_3 win_3_15 0) relay vt1=-1m vt2=1m ropen=ropen_mix rclosed=rclosed_mix
EMIXQ_c019_3_15 (mix_q_src_c019_3_15 0 bpf_c019_3 0) vcvs gain=-1.950903220161e-01
SMIXQ_c019_3_15 (mix_q_src_c019_3_15 mix_q_c019_3 win_3_15 0) relay vt1=-1m vt2=1m ropen=ropen_mix rclosed=rclosed_mix
RMIXI_c019_3 (mix_i_c019_3 0) resistor r=1G
RMIXQ_c019_3 (mix_q_c019_3 0) resistor r=1G
RINTI_c019_3 (mix_i_c019_3 Icar_c019_3) resistor r=1k
CINTI_c019_3 (Icar_c019_3 0) capacitor c=80p
RINTQ_c019_3 (mix_q_c019_3 Qcar_c019_3) resistor r=1k
CINTQ_c019_3 (Qcar_c019_3 0) capacitor c=80p
save bpf_c019_3 Icar_c019_3 Qcar_c019_3

// bl020, carrier_0: 250000000 Hz coherent I/Q phase-window verification-demod path
CBPF_c020_0 (bl020 n_cbpf_c020_0) capacitor c=4.052847345694e-13
LBPF_c020_0 (n_cbpf_c020_0 bpf_c020_0) inductor l=1.000000000000e-06
RBPF_c020_0 (bpf_c020_0 0) resistor r=7.853981633974e+01
EMIXI_c020_0_00 (mix_i_src_c020_0_00 0 bpf_c020_0 0) vcvs gain=9.807852804032e-01
SMIXI_c020_0_00 (mix_i_src_c020_0_00 mix_i_c020_0 win_0_00 0) relay vt1=-1m vt2=1m ropen=ropen_mix rclosed=rclosed_mix
EMIXQ_c020_0_00 (mix_q_src_c020_0_00 0 bpf_c020_0 0) vcvs gain=1.950903220161e-01
SMIXQ_c020_0_00 (mix_q_src_c020_0_00 mix_q_c020_0 win_0_00 0) relay vt1=-1m vt2=1m ropen=ropen_mix rclosed=rclosed_mix
EMIXI_c020_0_01 (mix_i_src_c020_0_01 0 bpf_c020_0 0) vcvs gain=8.314696123025e-01
SMIXI_c020_0_01 (mix_i_src_c020_0_01 mix_i_c020_0 win_0_01 0) relay vt1=-1m vt2=1m ropen=ropen_mix rclosed=rclosed_mix
EMIXQ_c020_0_01 (mix_q_src_c020_0_01 0 bpf_c020_0 0) vcvs gain=5.555702330196e-01
SMIXQ_c020_0_01 (mix_q_src_c020_0_01 mix_q_c020_0 win_0_01 0) relay vt1=-1m vt2=1m ropen=ropen_mix rclosed=rclosed_mix
EMIXI_c020_0_02 (mix_i_src_c020_0_02 0 bpf_c020_0 0) vcvs gain=5.555702330196e-01
SMIXI_c020_0_02 (mix_i_src_c020_0_02 mix_i_c020_0 win_0_02 0) relay vt1=-1m vt2=1m ropen=ropen_mix rclosed=rclosed_mix
EMIXQ_c020_0_02 (mix_q_src_c020_0_02 0 bpf_c020_0 0) vcvs gain=8.314696123025e-01
SMIXQ_c020_0_02 (mix_q_src_c020_0_02 mix_q_c020_0 win_0_02 0) relay vt1=-1m vt2=1m ropen=ropen_mix rclosed=rclosed_mix
EMIXI_c020_0_03 (mix_i_src_c020_0_03 0 bpf_c020_0 0) vcvs gain=1.950903220161e-01
SMIXI_c020_0_03 (mix_i_src_c020_0_03 mix_i_c020_0 win_0_03 0) relay vt1=-1m vt2=1m ropen=ropen_mix rclosed=rclosed_mix
EMIXQ_c020_0_03 (mix_q_src_c020_0_03 0 bpf_c020_0 0) vcvs gain=9.807852804032e-01
SMIXQ_c020_0_03 (mix_q_src_c020_0_03 mix_q_c020_0 win_0_03 0) relay vt1=-1m vt2=1m ropen=ropen_mix rclosed=rclosed_mix
EMIXI_c020_0_04 (mix_i_src_c020_0_04 0 bpf_c020_0 0) vcvs gain=-1.950903220161e-01
SMIXI_c020_0_04 (mix_i_src_c020_0_04 mix_i_c020_0 win_0_04 0) relay vt1=-1m vt2=1m ropen=ropen_mix rclosed=rclosed_mix
EMIXQ_c020_0_04 (mix_q_src_c020_0_04 0 bpf_c020_0 0) vcvs gain=9.807852804032e-01
SMIXQ_c020_0_04 (mix_q_src_c020_0_04 mix_q_c020_0 win_0_04 0) relay vt1=-1m vt2=1m ropen=ropen_mix rclosed=rclosed_mix
EMIXI_c020_0_05 (mix_i_src_c020_0_05 0 bpf_c020_0 0) vcvs gain=-5.555702330196e-01
SMIXI_c020_0_05 (mix_i_src_c020_0_05 mix_i_c020_0 win_0_05 0) relay vt1=-1m vt2=1m ropen=ropen_mix rclosed=rclosed_mix
EMIXQ_c020_0_05 (mix_q_src_c020_0_05 0 bpf_c020_0 0) vcvs gain=8.314696123025e-01
SMIXQ_c020_0_05 (mix_q_src_c020_0_05 mix_q_c020_0 win_0_05 0) relay vt1=-1m vt2=1m ropen=ropen_mix rclosed=rclosed_mix
EMIXI_c020_0_06 (mix_i_src_c020_0_06 0 bpf_c020_0 0) vcvs gain=-8.314696123025e-01
SMIXI_c020_0_06 (mix_i_src_c020_0_06 mix_i_c020_0 win_0_06 0) relay vt1=-1m vt2=1m ropen=ropen_mix rclosed=rclosed_mix
EMIXQ_c020_0_06 (mix_q_src_c020_0_06 0 bpf_c020_0 0) vcvs gain=5.555702330196e-01
SMIXQ_c020_0_06 (mix_q_src_c020_0_06 mix_q_c020_0 win_0_06 0) relay vt1=-1m vt2=1m ropen=ropen_mix rclosed=rclosed_mix
EMIXI_c020_0_07 (mix_i_src_c020_0_07 0 bpf_c020_0 0) vcvs gain=-9.807852804032e-01
SMIXI_c020_0_07 (mix_i_src_c020_0_07 mix_i_c020_0 win_0_07 0) relay vt1=-1m vt2=1m ropen=ropen_mix rclosed=rclosed_mix
EMIXQ_c020_0_07 (mix_q_src_c020_0_07 0 bpf_c020_0 0) vcvs gain=1.950903220161e-01
SMIXQ_c020_0_07 (mix_q_src_c020_0_07 mix_q_c020_0 win_0_07 0) relay vt1=-1m vt2=1m ropen=ropen_mix rclosed=rclosed_mix
EMIXI_c020_0_08 (mix_i_src_c020_0_08 0 bpf_c020_0 0) vcvs gain=-9.807852804032e-01
SMIXI_c020_0_08 (mix_i_src_c020_0_08 mix_i_c020_0 win_0_08 0) relay vt1=-1m vt2=1m ropen=ropen_mix rclosed=rclosed_mix
EMIXQ_c020_0_08 (mix_q_src_c020_0_08 0 bpf_c020_0 0) vcvs gain=-1.950903220161e-01
SMIXQ_c020_0_08 (mix_q_src_c020_0_08 mix_q_c020_0 win_0_08 0) relay vt1=-1m vt2=1m ropen=ropen_mix rclosed=rclosed_mix
EMIXI_c020_0_09 (mix_i_src_c020_0_09 0 bpf_c020_0 0) vcvs gain=-8.314696123025e-01
SMIXI_c020_0_09 (mix_i_src_c020_0_09 mix_i_c020_0 win_0_09 0) relay vt1=-1m vt2=1m ropen=ropen_mix rclosed=rclosed_mix
EMIXQ_c020_0_09 (mix_q_src_c020_0_09 0 bpf_c020_0 0) vcvs gain=-5.555702330196e-01
SMIXQ_c020_0_09 (mix_q_src_c020_0_09 mix_q_c020_0 win_0_09 0) relay vt1=-1m vt2=1m ropen=ropen_mix rclosed=rclosed_mix
EMIXI_c020_0_10 (mix_i_src_c020_0_10 0 bpf_c020_0 0) vcvs gain=-5.555702330196e-01
SMIXI_c020_0_10 (mix_i_src_c020_0_10 mix_i_c020_0 win_0_10 0) relay vt1=-1m vt2=1m ropen=ropen_mix rclosed=rclosed_mix
EMIXQ_c020_0_10 (mix_q_src_c020_0_10 0 bpf_c020_0 0) vcvs gain=-8.314696123025e-01
SMIXQ_c020_0_10 (mix_q_src_c020_0_10 mix_q_c020_0 win_0_10 0) relay vt1=-1m vt2=1m ropen=ropen_mix rclosed=rclosed_mix
EMIXI_c020_0_11 (mix_i_src_c020_0_11 0 bpf_c020_0 0) vcvs gain=-1.950903220161e-01
SMIXI_c020_0_11 (mix_i_src_c020_0_11 mix_i_c020_0 win_0_11 0) relay vt1=-1m vt2=1m ropen=ropen_mix rclosed=rclosed_mix
EMIXQ_c020_0_11 (mix_q_src_c020_0_11 0 bpf_c020_0 0) vcvs gain=-9.807852804032e-01
SMIXQ_c020_0_11 (mix_q_src_c020_0_11 mix_q_c020_0 win_0_11 0) relay vt1=-1m vt2=1m ropen=ropen_mix rclosed=rclosed_mix
EMIXI_c020_0_12 (mix_i_src_c020_0_12 0 bpf_c020_0 0) vcvs gain=1.950903220161e-01
SMIXI_c020_0_12 (mix_i_src_c020_0_12 mix_i_c020_0 win_0_12 0) relay vt1=-1m vt2=1m ropen=ropen_mix rclosed=rclosed_mix
EMIXQ_c020_0_12 (mix_q_src_c020_0_12 0 bpf_c020_0 0) vcvs gain=-9.807852804032e-01
SMIXQ_c020_0_12 (mix_q_src_c020_0_12 mix_q_c020_0 win_0_12 0) relay vt1=-1m vt2=1m ropen=ropen_mix rclosed=rclosed_mix
EMIXI_c020_0_13 (mix_i_src_c020_0_13 0 bpf_c020_0 0) vcvs gain=5.555702330196e-01
SMIXI_c020_0_13 (mix_i_src_c020_0_13 mix_i_c020_0 win_0_13 0) relay vt1=-1m vt2=1m ropen=ropen_mix rclosed=rclosed_mix
EMIXQ_c020_0_13 (mix_q_src_c020_0_13 0 bpf_c020_0 0) vcvs gain=-8.314696123025e-01
SMIXQ_c020_0_13 (mix_q_src_c020_0_13 mix_q_c020_0 win_0_13 0) relay vt1=-1m vt2=1m ropen=ropen_mix rclosed=rclosed_mix
EMIXI_c020_0_14 (mix_i_src_c020_0_14 0 bpf_c020_0 0) vcvs gain=8.314696123025e-01
SMIXI_c020_0_14 (mix_i_src_c020_0_14 mix_i_c020_0 win_0_14 0) relay vt1=-1m vt2=1m ropen=ropen_mix rclosed=rclosed_mix
EMIXQ_c020_0_14 (mix_q_src_c020_0_14 0 bpf_c020_0 0) vcvs gain=-5.555702330196e-01
SMIXQ_c020_0_14 (mix_q_src_c020_0_14 mix_q_c020_0 win_0_14 0) relay vt1=-1m vt2=1m ropen=ropen_mix rclosed=rclosed_mix
EMIXI_c020_0_15 (mix_i_src_c020_0_15 0 bpf_c020_0 0) vcvs gain=9.807852804032e-01
SMIXI_c020_0_15 (mix_i_src_c020_0_15 mix_i_c020_0 win_0_15 0) relay vt1=-1m vt2=1m ropen=ropen_mix rclosed=rclosed_mix
EMIXQ_c020_0_15 (mix_q_src_c020_0_15 0 bpf_c020_0 0) vcvs gain=-1.950903220161e-01
SMIXQ_c020_0_15 (mix_q_src_c020_0_15 mix_q_c020_0 win_0_15 0) relay vt1=-1m vt2=1m ropen=ropen_mix rclosed=rclosed_mix
RMIXI_c020_0 (mix_i_c020_0 0) resistor r=1G
RMIXQ_c020_0 (mix_q_c020_0 0) resistor r=1G
RINTI_c020_0 (mix_i_c020_0 Icar_c020_0) resistor r=1k
CINTI_c020_0 (Icar_c020_0 0) capacitor c=80p
RINTQ_c020_0 (mix_q_c020_0 Qcar_c020_0) resistor r=1k
CINTQ_c020_0 (Qcar_c020_0 0) capacitor c=80p
save bpf_c020_0 Icar_c020_0 Qcar_c020_0

// bl020, carrier_1: 500000000 Hz coherent I/Q phase-window verification-demod path
CBPF_c020_1 (bl020 n_cbpf_c020_1) capacitor c=1.013211836423e-13
LBPF_c020_1 (n_cbpf_c020_1 bpf_c020_1) inductor l=1.000000000000e-06
RBPF_c020_1 (bpf_c020_1 0) resistor r=1.570796326795e+02
EMIXI_c020_1_00 (mix_i_src_c020_1_00 0 bpf_c020_1 0) vcvs gain=9.807852804032e-01
SMIXI_c020_1_00 (mix_i_src_c020_1_00 mix_i_c020_1 win_1_00 0) relay vt1=-1m vt2=1m ropen=ropen_mix rclosed=rclosed_mix
EMIXQ_c020_1_00 (mix_q_src_c020_1_00 0 bpf_c020_1 0) vcvs gain=1.950903220161e-01
SMIXQ_c020_1_00 (mix_q_src_c020_1_00 mix_q_c020_1 win_1_00 0) relay vt1=-1m vt2=1m ropen=ropen_mix rclosed=rclosed_mix
EMIXI_c020_1_01 (mix_i_src_c020_1_01 0 bpf_c020_1 0) vcvs gain=8.314696123025e-01
SMIXI_c020_1_01 (mix_i_src_c020_1_01 mix_i_c020_1 win_1_01 0) relay vt1=-1m vt2=1m ropen=ropen_mix rclosed=rclosed_mix
EMIXQ_c020_1_01 (mix_q_src_c020_1_01 0 bpf_c020_1 0) vcvs gain=5.555702330196e-01
SMIXQ_c020_1_01 (mix_q_src_c020_1_01 mix_q_c020_1 win_1_01 0) relay vt1=-1m vt2=1m ropen=ropen_mix rclosed=rclosed_mix
EMIXI_c020_1_02 (mix_i_src_c020_1_02 0 bpf_c020_1 0) vcvs gain=5.555702330196e-01
SMIXI_c020_1_02 (mix_i_src_c020_1_02 mix_i_c020_1 win_1_02 0) relay vt1=-1m vt2=1m ropen=ropen_mix rclosed=rclosed_mix
EMIXQ_c020_1_02 (mix_q_src_c020_1_02 0 bpf_c020_1 0) vcvs gain=8.314696123025e-01
SMIXQ_c020_1_02 (mix_q_src_c020_1_02 mix_q_c020_1 win_1_02 0) relay vt1=-1m vt2=1m ropen=ropen_mix rclosed=rclosed_mix
EMIXI_c020_1_03 (mix_i_src_c020_1_03 0 bpf_c020_1 0) vcvs gain=1.950903220161e-01
SMIXI_c020_1_03 (mix_i_src_c020_1_03 mix_i_c020_1 win_1_03 0) relay vt1=-1m vt2=1m ropen=ropen_mix rclosed=rclosed_mix
EMIXQ_c020_1_03 (mix_q_src_c020_1_03 0 bpf_c020_1 0) vcvs gain=9.807852804032e-01
SMIXQ_c020_1_03 (mix_q_src_c020_1_03 mix_q_c020_1 win_1_03 0) relay vt1=-1m vt2=1m ropen=ropen_mix rclosed=rclosed_mix
EMIXI_c020_1_04 (mix_i_src_c020_1_04 0 bpf_c020_1 0) vcvs gain=-1.950903220161e-01
SMIXI_c020_1_04 (mix_i_src_c020_1_04 mix_i_c020_1 win_1_04 0) relay vt1=-1m vt2=1m ropen=ropen_mix rclosed=rclosed_mix
EMIXQ_c020_1_04 (mix_q_src_c020_1_04 0 bpf_c020_1 0) vcvs gain=9.807852804032e-01
SMIXQ_c020_1_04 (mix_q_src_c020_1_04 mix_q_c020_1 win_1_04 0) relay vt1=-1m vt2=1m ropen=ropen_mix rclosed=rclosed_mix
EMIXI_c020_1_05 (mix_i_src_c020_1_05 0 bpf_c020_1 0) vcvs gain=-5.555702330196e-01
SMIXI_c020_1_05 (mix_i_src_c020_1_05 mix_i_c020_1 win_1_05 0) relay vt1=-1m vt2=1m ropen=ropen_mix rclosed=rclosed_mix
EMIXQ_c020_1_05 (mix_q_src_c020_1_05 0 bpf_c020_1 0) vcvs gain=8.314696123025e-01
SMIXQ_c020_1_05 (mix_q_src_c020_1_05 mix_q_c020_1 win_1_05 0) relay vt1=-1m vt2=1m ropen=ropen_mix rclosed=rclosed_mix
EMIXI_c020_1_06 (mix_i_src_c020_1_06 0 bpf_c020_1 0) vcvs gain=-8.314696123025e-01
SMIXI_c020_1_06 (mix_i_src_c020_1_06 mix_i_c020_1 win_1_06 0) relay vt1=-1m vt2=1m ropen=ropen_mix rclosed=rclosed_mix
EMIXQ_c020_1_06 (mix_q_src_c020_1_06 0 bpf_c020_1 0) vcvs gain=5.555702330196e-01
SMIXQ_c020_1_06 (mix_q_src_c020_1_06 mix_q_c020_1 win_1_06 0) relay vt1=-1m vt2=1m ropen=ropen_mix rclosed=rclosed_mix
EMIXI_c020_1_07 (mix_i_src_c020_1_07 0 bpf_c020_1 0) vcvs gain=-9.807852804032e-01
SMIXI_c020_1_07 (mix_i_src_c020_1_07 mix_i_c020_1 win_1_07 0) relay vt1=-1m vt2=1m ropen=ropen_mix rclosed=rclosed_mix
EMIXQ_c020_1_07 (mix_q_src_c020_1_07 0 bpf_c020_1 0) vcvs gain=1.950903220161e-01
SMIXQ_c020_1_07 (mix_q_src_c020_1_07 mix_q_c020_1 win_1_07 0) relay vt1=-1m vt2=1m ropen=ropen_mix rclosed=rclosed_mix
EMIXI_c020_1_08 (mix_i_src_c020_1_08 0 bpf_c020_1 0) vcvs gain=-9.807852804032e-01
SMIXI_c020_1_08 (mix_i_src_c020_1_08 mix_i_c020_1 win_1_08 0) relay vt1=-1m vt2=1m ropen=ropen_mix rclosed=rclosed_mix
EMIXQ_c020_1_08 (mix_q_src_c020_1_08 0 bpf_c020_1 0) vcvs gain=-1.950903220161e-01
SMIXQ_c020_1_08 (mix_q_src_c020_1_08 mix_q_c020_1 win_1_08 0) relay vt1=-1m vt2=1m ropen=ropen_mix rclosed=rclosed_mix
EMIXI_c020_1_09 (mix_i_src_c020_1_09 0 bpf_c020_1 0) vcvs gain=-8.314696123025e-01
SMIXI_c020_1_09 (mix_i_src_c020_1_09 mix_i_c020_1 win_1_09 0) relay vt1=-1m vt2=1m ropen=ropen_mix rclosed=rclosed_mix
EMIXQ_c020_1_09 (mix_q_src_c020_1_09 0 bpf_c020_1 0) vcvs gain=-5.555702330196e-01
SMIXQ_c020_1_09 (mix_q_src_c020_1_09 mix_q_c020_1 win_1_09 0) relay vt1=-1m vt2=1m ropen=ropen_mix rclosed=rclosed_mix
EMIXI_c020_1_10 (mix_i_src_c020_1_10 0 bpf_c020_1 0) vcvs gain=-5.555702330196e-01
SMIXI_c020_1_10 (mix_i_src_c020_1_10 mix_i_c020_1 win_1_10 0) relay vt1=-1m vt2=1m ropen=ropen_mix rclosed=rclosed_mix
EMIXQ_c020_1_10 (mix_q_src_c020_1_10 0 bpf_c020_1 0) vcvs gain=-8.314696123025e-01
SMIXQ_c020_1_10 (mix_q_src_c020_1_10 mix_q_c020_1 win_1_10 0) relay vt1=-1m vt2=1m ropen=ropen_mix rclosed=rclosed_mix
EMIXI_c020_1_11 (mix_i_src_c020_1_11 0 bpf_c020_1 0) vcvs gain=-1.950903220161e-01
SMIXI_c020_1_11 (mix_i_src_c020_1_11 mix_i_c020_1 win_1_11 0) relay vt1=-1m vt2=1m ropen=ropen_mix rclosed=rclosed_mix
EMIXQ_c020_1_11 (mix_q_src_c020_1_11 0 bpf_c020_1 0) vcvs gain=-9.807852804032e-01
SMIXQ_c020_1_11 (mix_q_src_c020_1_11 mix_q_c020_1 win_1_11 0) relay vt1=-1m vt2=1m ropen=ropen_mix rclosed=rclosed_mix
EMIXI_c020_1_12 (mix_i_src_c020_1_12 0 bpf_c020_1 0) vcvs gain=1.950903220161e-01
SMIXI_c020_1_12 (mix_i_src_c020_1_12 mix_i_c020_1 win_1_12 0) relay vt1=-1m vt2=1m ropen=ropen_mix rclosed=rclosed_mix
EMIXQ_c020_1_12 (mix_q_src_c020_1_12 0 bpf_c020_1 0) vcvs gain=-9.807852804032e-01
SMIXQ_c020_1_12 (mix_q_src_c020_1_12 mix_q_c020_1 win_1_12 0) relay vt1=-1m vt2=1m ropen=ropen_mix rclosed=rclosed_mix
EMIXI_c020_1_13 (mix_i_src_c020_1_13 0 bpf_c020_1 0) vcvs gain=5.555702330196e-01
SMIXI_c020_1_13 (mix_i_src_c020_1_13 mix_i_c020_1 win_1_13 0) relay vt1=-1m vt2=1m ropen=ropen_mix rclosed=rclosed_mix
EMIXQ_c020_1_13 (mix_q_src_c020_1_13 0 bpf_c020_1 0) vcvs gain=-8.314696123025e-01
SMIXQ_c020_1_13 (mix_q_src_c020_1_13 mix_q_c020_1 win_1_13 0) relay vt1=-1m vt2=1m ropen=ropen_mix rclosed=rclosed_mix
EMIXI_c020_1_14 (mix_i_src_c020_1_14 0 bpf_c020_1 0) vcvs gain=8.314696123025e-01
SMIXI_c020_1_14 (mix_i_src_c020_1_14 mix_i_c020_1 win_1_14 0) relay vt1=-1m vt2=1m ropen=ropen_mix rclosed=rclosed_mix
EMIXQ_c020_1_14 (mix_q_src_c020_1_14 0 bpf_c020_1 0) vcvs gain=-5.555702330196e-01
SMIXQ_c020_1_14 (mix_q_src_c020_1_14 mix_q_c020_1 win_1_14 0) relay vt1=-1m vt2=1m ropen=ropen_mix rclosed=rclosed_mix
EMIXI_c020_1_15 (mix_i_src_c020_1_15 0 bpf_c020_1 0) vcvs gain=9.807852804032e-01
SMIXI_c020_1_15 (mix_i_src_c020_1_15 mix_i_c020_1 win_1_15 0) relay vt1=-1m vt2=1m ropen=ropen_mix rclosed=rclosed_mix
EMIXQ_c020_1_15 (mix_q_src_c020_1_15 0 bpf_c020_1 0) vcvs gain=-1.950903220161e-01
SMIXQ_c020_1_15 (mix_q_src_c020_1_15 mix_q_c020_1 win_1_15 0) relay vt1=-1m vt2=1m ropen=ropen_mix rclosed=rclosed_mix
RMIXI_c020_1 (mix_i_c020_1 0) resistor r=1G
RMIXQ_c020_1 (mix_q_c020_1 0) resistor r=1G
RINTI_c020_1 (mix_i_c020_1 Icar_c020_1) resistor r=1k
CINTI_c020_1 (Icar_c020_1 0) capacitor c=80p
RINTQ_c020_1 (mix_q_c020_1 Qcar_c020_1) resistor r=1k
CINTQ_c020_1 (Qcar_c020_1 0) capacitor c=80p
save bpf_c020_1 Icar_c020_1 Qcar_c020_1

// bl020, carrier_2: 750000000 Hz coherent I/Q phase-window verification-demod path
CBPF_c020_2 (bl020 n_cbpf_c020_2) capacitor c=4.503163717437e-14
LBPF_c020_2 (n_cbpf_c020_2 bpf_c020_2) inductor l=1.000000000000e-06
RBPF_c020_2 (bpf_c020_2 0) resistor r=2.356194490192e+02
EMIXI_c020_2_00 (mix_i_src_c020_2_00 0 bpf_c020_2 0) vcvs gain=9.807852804032e-01
SMIXI_c020_2_00 (mix_i_src_c020_2_00 mix_i_c020_2 win_2_00 0) relay vt1=-1m vt2=1m ropen=ropen_mix rclosed=rclosed_mix
EMIXQ_c020_2_00 (mix_q_src_c020_2_00 0 bpf_c020_2 0) vcvs gain=1.950903220161e-01
SMIXQ_c020_2_00 (mix_q_src_c020_2_00 mix_q_c020_2 win_2_00 0) relay vt1=-1m vt2=1m ropen=ropen_mix rclosed=rclosed_mix
EMIXI_c020_2_01 (mix_i_src_c020_2_01 0 bpf_c020_2 0) vcvs gain=8.314696123025e-01
SMIXI_c020_2_01 (mix_i_src_c020_2_01 mix_i_c020_2 win_2_01 0) relay vt1=-1m vt2=1m ropen=ropen_mix rclosed=rclosed_mix
EMIXQ_c020_2_01 (mix_q_src_c020_2_01 0 bpf_c020_2 0) vcvs gain=5.555702330196e-01
SMIXQ_c020_2_01 (mix_q_src_c020_2_01 mix_q_c020_2 win_2_01 0) relay vt1=-1m vt2=1m ropen=ropen_mix rclosed=rclosed_mix
EMIXI_c020_2_02 (mix_i_src_c020_2_02 0 bpf_c020_2 0) vcvs gain=5.555702330196e-01
SMIXI_c020_2_02 (mix_i_src_c020_2_02 mix_i_c020_2 win_2_02 0) relay vt1=-1m vt2=1m ropen=ropen_mix rclosed=rclosed_mix
EMIXQ_c020_2_02 (mix_q_src_c020_2_02 0 bpf_c020_2 0) vcvs gain=8.314696123025e-01
SMIXQ_c020_2_02 (mix_q_src_c020_2_02 mix_q_c020_2 win_2_02 0) relay vt1=-1m vt2=1m ropen=ropen_mix rclosed=rclosed_mix
EMIXI_c020_2_03 (mix_i_src_c020_2_03 0 bpf_c020_2 0) vcvs gain=1.950903220161e-01
SMIXI_c020_2_03 (mix_i_src_c020_2_03 mix_i_c020_2 win_2_03 0) relay vt1=-1m vt2=1m ropen=ropen_mix rclosed=rclosed_mix
EMIXQ_c020_2_03 (mix_q_src_c020_2_03 0 bpf_c020_2 0) vcvs gain=9.807852804032e-01
SMIXQ_c020_2_03 (mix_q_src_c020_2_03 mix_q_c020_2 win_2_03 0) relay vt1=-1m vt2=1m ropen=ropen_mix rclosed=rclosed_mix
EMIXI_c020_2_04 (mix_i_src_c020_2_04 0 bpf_c020_2 0) vcvs gain=-1.950903220161e-01
SMIXI_c020_2_04 (mix_i_src_c020_2_04 mix_i_c020_2 win_2_04 0) relay vt1=-1m vt2=1m ropen=ropen_mix rclosed=rclosed_mix
EMIXQ_c020_2_04 (mix_q_src_c020_2_04 0 bpf_c020_2 0) vcvs gain=9.807852804032e-01
SMIXQ_c020_2_04 (mix_q_src_c020_2_04 mix_q_c020_2 win_2_04 0) relay vt1=-1m vt2=1m ropen=ropen_mix rclosed=rclosed_mix
EMIXI_c020_2_05 (mix_i_src_c020_2_05 0 bpf_c020_2 0) vcvs gain=-5.555702330196e-01
SMIXI_c020_2_05 (mix_i_src_c020_2_05 mix_i_c020_2 win_2_05 0) relay vt1=-1m vt2=1m ropen=ropen_mix rclosed=rclosed_mix
EMIXQ_c020_2_05 (mix_q_src_c020_2_05 0 bpf_c020_2 0) vcvs gain=8.314696123025e-01
SMIXQ_c020_2_05 (mix_q_src_c020_2_05 mix_q_c020_2 win_2_05 0) relay vt1=-1m vt2=1m ropen=ropen_mix rclosed=rclosed_mix
EMIXI_c020_2_06 (mix_i_src_c020_2_06 0 bpf_c020_2 0) vcvs gain=-8.314696123025e-01
SMIXI_c020_2_06 (mix_i_src_c020_2_06 mix_i_c020_2 win_2_06 0) relay vt1=-1m vt2=1m ropen=ropen_mix rclosed=rclosed_mix
EMIXQ_c020_2_06 (mix_q_src_c020_2_06 0 bpf_c020_2 0) vcvs gain=5.555702330196e-01
SMIXQ_c020_2_06 (mix_q_src_c020_2_06 mix_q_c020_2 win_2_06 0) relay vt1=-1m vt2=1m ropen=ropen_mix rclosed=rclosed_mix
EMIXI_c020_2_07 (mix_i_src_c020_2_07 0 bpf_c020_2 0) vcvs gain=-9.807852804032e-01
SMIXI_c020_2_07 (mix_i_src_c020_2_07 mix_i_c020_2 win_2_07 0) relay vt1=-1m vt2=1m ropen=ropen_mix rclosed=rclosed_mix
EMIXQ_c020_2_07 (mix_q_src_c020_2_07 0 bpf_c020_2 0) vcvs gain=1.950903220161e-01
SMIXQ_c020_2_07 (mix_q_src_c020_2_07 mix_q_c020_2 win_2_07 0) relay vt1=-1m vt2=1m ropen=ropen_mix rclosed=rclosed_mix
EMIXI_c020_2_08 (mix_i_src_c020_2_08 0 bpf_c020_2 0) vcvs gain=-9.807852804032e-01
SMIXI_c020_2_08 (mix_i_src_c020_2_08 mix_i_c020_2 win_2_08 0) relay vt1=-1m vt2=1m ropen=ropen_mix rclosed=rclosed_mix
EMIXQ_c020_2_08 (mix_q_src_c020_2_08 0 bpf_c020_2 0) vcvs gain=-1.950903220161e-01
SMIXQ_c020_2_08 (mix_q_src_c020_2_08 mix_q_c020_2 win_2_08 0) relay vt1=-1m vt2=1m ropen=ropen_mix rclosed=rclosed_mix
EMIXI_c020_2_09 (mix_i_src_c020_2_09 0 bpf_c020_2 0) vcvs gain=-8.314696123025e-01
SMIXI_c020_2_09 (mix_i_src_c020_2_09 mix_i_c020_2 win_2_09 0) relay vt1=-1m vt2=1m ropen=ropen_mix rclosed=rclosed_mix
EMIXQ_c020_2_09 (mix_q_src_c020_2_09 0 bpf_c020_2 0) vcvs gain=-5.555702330196e-01
SMIXQ_c020_2_09 (mix_q_src_c020_2_09 mix_q_c020_2 win_2_09 0) relay vt1=-1m vt2=1m ropen=ropen_mix rclosed=rclosed_mix
EMIXI_c020_2_10 (mix_i_src_c020_2_10 0 bpf_c020_2 0) vcvs gain=-5.555702330196e-01
SMIXI_c020_2_10 (mix_i_src_c020_2_10 mix_i_c020_2 win_2_10 0) relay vt1=-1m vt2=1m ropen=ropen_mix rclosed=rclosed_mix
EMIXQ_c020_2_10 (mix_q_src_c020_2_10 0 bpf_c020_2 0) vcvs gain=-8.314696123025e-01
SMIXQ_c020_2_10 (mix_q_src_c020_2_10 mix_q_c020_2 win_2_10 0) relay vt1=-1m vt2=1m ropen=ropen_mix rclosed=rclosed_mix
EMIXI_c020_2_11 (mix_i_src_c020_2_11 0 bpf_c020_2 0) vcvs gain=-1.950903220161e-01
SMIXI_c020_2_11 (mix_i_src_c020_2_11 mix_i_c020_2 win_2_11 0) relay vt1=-1m vt2=1m ropen=ropen_mix rclosed=rclosed_mix
EMIXQ_c020_2_11 (mix_q_src_c020_2_11 0 bpf_c020_2 0) vcvs gain=-9.807852804032e-01
SMIXQ_c020_2_11 (mix_q_src_c020_2_11 mix_q_c020_2 win_2_11 0) relay vt1=-1m vt2=1m ropen=ropen_mix rclosed=rclosed_mix
EMIXI_c020_2_12 (mix_i_src_c020_2_12 0 bpf_c020_2 0) vcvs gain=1.950903220161e-01
SMIXI_c020_2_12 (mix_i_src_c020_2_12 mix_i_c020_2 win_2_12 0) relay vt1=-1m vt2=1m ropen=ropen_mix rclosed=rclosed_mix
EMIXQ_c020_2_12 (mix_q_src_c020_2_12 0 bpf_c020_2 0) vcvs gain=-9.807852804032e-01
SMIXQ_c020_2_12 (mix_q_src_c020_2_12 mix_q_c020_2 win_2_12 0) relay vt1=-1m vt2=1m ropen=ropen_mix rclosed=rclosed_mix
EMIXI_c020_2_13 (mix_i_src_c020_2_13 0 bpf_c020_2 0) vcvs gain=5.555702330196e-01
SMIXI_c020_2_13 (mix_i_src_c020_2_13 mix_i_c020_2 win_2_13 0) relay vt1=-1m vt2=1m ropen=ropen_mix rclosed=rclosed_mix
EMIXQ_c020_2_13 (mix_q_src_c020_2_13 0 bpf_c020_2 0) vcvs gain=-8.314696123025e-01
SMIXQ_c020_2_13 (mix_q_src_c020_2_13 mix_q_c020_2 win_2_13 0) relay vt1=-1m vt2=1m ropen=ropen_mix rclosed=rclosed_mix
EMIXI_c020_2_14 (mix_i_src_c020_2_14 0 bpf_c020_2 0) vcvs gain=8.314696123025e-01
SMIXI_c020_2_14 (mix_i_src_c020_2_14 mix_i_c020_2 win_2_14 0) relay vt1=-1m vt2=1m ropen=ropen_mix rclosed=rclosed_mix
EMIXQ_c020_2_14 (mix_q_src_c020_2_14 0 bpf_c020_2 0) vcvs gain=-5.555702330196e-01
SMIXQ_c020_2_14 (mix_q_src_c020_2_14 mix_q_c020_2 win_2_14 0) relay vt1=-1m vt2=1m ropen=ropen_mix rclosed=rclosed_mix
EMIXI_c020_2_15 (mix_i_src_c020_2_15 0 bpf_c020_2 0) vcvs gain=9.807852804032e-01
SMIXI_c020_2_15 (mix_i_src_c020_2_15 mix_i_c020_2 win_2_15 0) relay vt1=-1m vt2=1m ropen=ropen_mix rclosed=rclosed_mix
EMIXQ_c020_2_15 (mix_q_src_c020_2_15 0 bpf_c020_2 0) vcvs gain=-1.950903220161e-01
SMIXQ_c020_2_15 (mix_q_src_c020_2_15 mix_q_c020_2 win_2_15 0) relay vt1=-1m vt2=1m ropen=ropen_mix rclosed=rclosed_mix
RMIXI_c020_2 (mix_i_c020_2 0) resistor r=1G
RMIXQ_c020_2 (mix_q_c020_2 0) resistor r=1G
RINTI_c020_2 (mix_i_c020_2 Icar_c020_2) resistor r=1k
CINTI_c020_2 (Icar_c020_2 0) capacitor c=80p
RINTQ_c020_2 (mix_q_c020_2 Qcar_c020_2) resistor r=1k
CINTQ_c020_2 (Qcar_c020_2 0) capacitor c=80p
save bpf_c020_2 Icar_c020_2 Qcar_c020_2

// bl020, carrier_3: 1000000000 Hz coherent I/Q phase-window verification-demod path
CBPF_c020_3 (bl020 n_cbpf_c020_3) capacitor c=2.533029591058e-14
LBPF_c020_3 (n_cbpf_c020_3 bpf_c020_3) inductor l=1.000000000000e-06
RBPF_c020_3 (bpf_c020_3 0) resistor r=3.141592653590e+02
EMIXI_c020_3_00 (mix_i_src_c020_3_00 0 bpf_c020_3 0) vcvs gain=9.807852804032e-01
SMIXI_c020_3_00 (mix_i_src_c020_3_00 mix_i_c020_3 win_3_00 0) relay vt1=-1m vt2=1m ropen=ropen_mix rclosed=rclosed_mix
EMIXQ_c020_3_00 (mix_q_src_c020_3_00 0 bpf_c020_3 0) vcvs gain=1.950903220161e-01
SMIXQ_c020_3_00 (mix_q_src_c020_3_00 mix_q_c020_3 win_3_00 0) relay vt1=-1m vt2=1m ropen=ropen_mix rclosed=rclosed_mix
EMIXI_c020_3_01 (mix_i_src_c020_3_01 0 bpf_c020_3 0) vcvs gain=8.314696123025e-01
SMIXI_c020_3_01 (mix_i_src_c020_3_01 mix_i_c020_3 win_3_01 0) relay vt1=-1m vt2=1m ropen=ropen_mix rclosed=rclosed_mix
EMIXQ_c020_3_01 (mix_q_src_c020_3_01 0 bpf_c020_3 0) vcvs gain=5.555702330196e-01
SMIXQ_c020_3_01 (mix_q_src_c020_3_01 mix_q_c020_3 win_3_01 0) relay vt1=-1m vt2=1m ropen=ropen_mix rclosed=rclosed_mix
EMIXI_c020_3_02 (mix_i_src_c020_3_02 0 bpf_c020_3 0) vcvs gain=5.555702330196e-01
SMIXI_c020_3_02 (mix_i_src_c020_3_02 mix_i_c020_3 win_3_02 0) relay vt1=-1m vt2=1m ropen=ropen_mix rclosed=rclosed_mix
EMIXQ_c020_3_02 (mix_q_src_c020_3_02 0 bpf_c020_3 0) vcvs gain=8.314696123025e-01
SMIXQ_c020_3_02 (mix_q_src_c020_3_02 mix_q_c020_3 win_3_02 0) relay vt1=-1m vt2=1m ropen=ropen_mix rclosed=rclosed_mix
EMIXI_c020_3_03 (mix_i_src_c020_3_03 0 bpf_c020_3 0) vcvs gain=1.950903220161e-01
SMIXI_c020_3_03 (mix_i_src_c020_3_03 mix_i_c020_3 win_3_03 0) relay vt1=-1m vt2=1m ropen=ropen_mix rclosed=rclosed_mix
EMIXQ_c020_3_03 (mix_q_src_c020_3_03 0 bpf_c020_3 0) vcvs gain=9.807852804032e-01
SMIXQ_c020_3_03 (mix_q_src_c020_3_03 mix_q_c020_3 win_3_03 0) relay vt1=-1m vt2=1m ropen=ropen_mix rclosed=rclosed_mix
EMIXI_c020_3_04 (mix_i_src_c020_3_04 0 bpf_c020_3 0) vcvs gain=-1.950903220161e-01
SMIXI_c020_3_04 (mix_i_src_c020_3_04 mix_i_c020_3 win_3_04 0) relay vt1=-1m vt2=1m ropen=ropen_mix rclosed=rclosed_mix
EMIXQ_c020_3_04 (mix_q_src_c020_3_04 0 bpf_c020_3 0) vcvs gain=9.807852804032e-01
SMIXQ_c020_3_04 (mix_q_src_c020_3_04 mix_q_c020_3 win_3_04 0) relay vt1=-1m vt2=1m ropen=ropen_mix rclosed=rclosed_mix
EMIXI_c020_3_05 (mix_i_src_c020_3_05 0 bpf_c020_3 0) vcvs gain=-5.555702330196e-01
SMIXI_c020_3_05 (mix_i_src_c020_3_05 mix_i_c020_3 win_3_05 0) relay vt1=-1m vt2=1m ropen=ropen_mix rclosed=rclosed_mix
EMIXQ_c020_3_05 (mix_q_src_c020_3_05 0 bpf_c020_3 0) vcvs gain=8.314696123025e-01
SMIXQ_c020_3_05 (mix_q_src_c020_3_05 mix_q_c020_3 win_3_05 0) relay vt1=-1m vt2=1m ropen=ropen_mix rclosed=rclosed_mix
EMIXI_c020_3_06 (mix_i_src_c020_3_06 0 bpf_c020_3 0) vcvs gain=-8.314696123025e-01
SMIXI_c020_3_06 (mix_i_src_c020_3_06 mix_i_c020_3 win_3_06 0) relay vt1=-1m vt2=1m ropen=ropen_mix rclosed=rclosed_mix
EMIXQ_c020_3_06 (mix_q_src_c020_3_06 0 bpf_c020_3 0) vcvs gain=5.555702330196e-01
SMIXQ_c020_3_06 (mix_q_src_c020_3_06 mix_q_c020_3 win_3_06 0) relay vt1=-1m vt2=1m ropen=ropen_mix rclosed=rclosed_mix
EMIXI_c020_3_07 (mix_i_src_c020_3_07 0 bpf_c020_3 0) vcvs gain=-9.807852804032e-01
SMIXI_c020_3_07 (mix_i_src_c020_3_07 mix_i_c020_3 win_3_07 0) relay vt1=-1m vt2=1m ropen=ropen_mix rclosed=rclosed_mix
EMIXQ_c020_3_07 (mix_q_src_c020_3_07 0 bpf_c020_3 0) vcvs gain=1.950903220161e-01
SMIXQ_c020_3_07 (mix_q_src_c020_3_07 mix_q_c020_3 win_3_07 0) relay vt1=-1m vt2=1m ropen=ropen_mix rclosed=rclosed_mix
EMIXI_c020_3_08 (mix_i_src_c020_3_08 0 bpf_c020_3 0) vcvs gain=-9.807852804032e-01
SMIXI_c020_3_08 (mix_i_src_c020_3_08 mix_i_c020_3 win_3_08 0) relay vt1=-1m vt2=1m ropen=ropen_mix rclosed=rclosed_mix
EMIXQ_c020_3_08 (mix_q_src_c020_3_08 0 bpf_c020_3 0) vcvs gain=-1.950903220161e-01
SMIXQ_c020_3_08 (mix_q_src_c020_3_08 mix_q_c020_3 win_3_08 0) relay vt1=-1m vt2=1m ropen=ropen_mix rclosed=rclosed_mix
EMIXI_c020_3_09 (mix_i_src_c020_3_09 0 bpf_c020_3 0) vcvs gain=-8.314696123025e-01
SMIXI_c020_3_09 (mix_i_src_c020_3_09 mix_i_c020_3 win_3_09 0) relay vt1=-1m vt2=1m ropen=ropen_mix rclosed=rclosed_mix
EMIXQ_c020_3_09 (mix_q_src_c020_3_09 0 bpf_c020_3 0) vcvs gain=-5.555702330196e-01
SMIXQ_c020_3_09 (mix_q_src_c020_3_09 mix_q_c020_3 win_3_09 0) relay vt1=-1m vt2=1m ropen=ropen_mix rclosed=rclosed_mix
EMIXI_c020_3_10 (mix_i_src_c020_3_10 0 bpf_c020_3 0) vcvs gain=-5.555702330196e-01
SMIXI_c020_3_10 (mix_i_src_c020_3_10 mix_i_c020_3 win_3_10 0) relay vt1=-1m vt2=1m ropen=ropen_mix rclosed=rclosed_mix
EMIXQ_c020_3_10 (mix_q_src_c020_3_10 0 bpf_c020_3 0) vcvs gain=-8.314696123025e-01
SMIXQ_c020_3_10 (mix_q_src_c020_3_10 mix_q_c020_3 win_3_10 0) relay vt1=-1m vt2=1m ropen=ropen_mix rclosed=rclosed_mix
EMIXI_c020_3_11 (mix_i_src_c020_3_11 0 bpf_c020_3 0) vcvs gain=-1.950903220161e-01
SMIXI_c020_3_11 (mix_i_src_c020_3_11 mix_i_c020_3 win_3_11 0) relay vt1=-1m vt2=1m ropen=ropen_mix rclosed=rclosed_mix
EMIXQ_c020_3_11 (mix_q_src_c020_3_11 0 bpf_c020_3 0) vcvs gain=-9.807852804032e-01
SMIXQ_c020_3_11 (mix_q_src_c020_3_11 mix_q_c020_3 win_3_11 0) relay vt1=-1m vt2=1m ropen=ropen_mix rclosed=rclosed_mix
EMIXI_c020_3_12 (mix_i_src_c020_3_12 0 bpf_c020_3 0) vcvs gain=1.950903220161e-01
SMIXI_c020_3_12 (mix_i_src_c020_3_12 mix_i_c020_3 win_3_12 0) relay vt1=-1m vt2=1m ropen=ropen_mix rclosed=rclosed_mix
EMIXQ_c020_3_12 (mix_q_src_c020_3_12 0 bpf_c020_3 0) vcvs gain=-9.807852804032e-01
SMIXQ_c020_3_12 (mix_q_src_c020_3_12 mix_q_c020_3 win_3_12 0) relay vt1=-1m vt2=1m ropen=ropen_mix rclosed=rclosed_mix
EMIXI_c020_3_13 (mix_i_src_c020_3_13 0 bpf_c020_3 0) vcvs gain=5.555702330196e-01
SMIXI_c020_3_13 (mix_i_src_c020_3_13 mix_i_c020_3 win_3_13 0) relay vt1=-1m vt2=1m ropen=ropen_mix rclosed=rclosed_mix
EMIXQ_c020_3_13 (mix_q_src_c020_3_13 0 bpf_c020_3 0) vcvs gain=-8.314696123025e-01
SMIXQ_c020_3_13 (mix_q_src_c020_3_13 mix_q_c020_3 win_3_13 0) relay vt1=-1m vt2=1m ropen=ropen_mix rclosed=rclosed_mix
EMIXI_c020_3_14 (mix_i_src_c020_3_14 0 bpf_c020_3 0) vcvs gain=8.314696123025e-01
SMIXI_c020_3_14 (mix_i_src_c020_3_14 mix_i_c020_3 win_3_14 0) relay vt1=-1m vt2=1m ropen=ropen_mix rclosed=rclosed_mix
EMIXQ_c020_3_14 (mix_q_src_c020_3_14 0 bpf_c020_3 0) vcvs gain=-5.555702330196e-01
SMIXQ_c020_3_14 (mix_q_src_c020_3_14 mix_q_c020_3 win_3_14 0) relay vt1=-1m vt2=1m ropen=ropen_mix rclosed=rclosed_mix
EMIXI_c020_3_15 (mix_i_src_c020_3_15 0 bpf_c020_3 0) vcvs gain=9.807852804032e-01
SMIXI_c020_3_15 (mix_i_src_c020_3_15 mix_i_c020_3 win_3_15 0) relay vt1=-1m vt2=1m ropen=ropen_mix rclosed=rclosed_mix
EMIXQ_c020_3_15 (mix_q_src_c020_3_15 0 bpf_c020_3 0) vcvs gain=-1.950903220161e-01
SMIXQ_c020_3_15 (mix_q_src_c020_3_15 mix_q_c020_3 win_3_15 0) relay vt1=-1m vt2=1m ropen=ropen_mix rclosed=rclosed_mix
RMIXI_c020_3 (mix_i_c020_3 0) resistor r=1G
RMIXQ_c020_3 (mix_q_c020_3 0) resistor r=1G
RINTI_c020_3 (mix_i_c020_3 Icar_c020_3) resistor r=1k
CINTI_c020_3 (Icar_c020_3 0) capacitor c=80p
RINTQ_c020_3 (mix_q_c020_3 Qcar_c020_3) resistor r=1k
CINTQ_c020_3 (Qcar_c020_3 0) capacitor c=80p
save bpf_c020_3 Icar_c020_3 Qcar_c020_3

// bl021, carrier_0: 250000000 Hz coherent I/Q phase-window verification-demod path
CBPF_c021_0 (bl021 n_cbpf_c021_0) capacitor c=4.052847345694e-13
LBPF_c021_0 (n_cbpf_c021_0 bpf_c021_0) inductor l=1.000000000000e-06
RBPF_c021_0 (bpf_c021_0 0) resistor r=7.853981633974e+01
EMIXI_c021_0_00 (mix_i_src_c021_0_00 0 bpf_c021_0 0) vcvs gain=9.807852804032e-01
SMIXI_c021_0_00 (mix_i_src_c021_0_00 mix_i_c021_0 win_0_00 0) relay vt1=-1m vt2=1m ropen=ropen_mix rclosed=rclosed_mix
EMIXQ_c021_0_00 (mix_q_src_c021_0_00 0 bpf_c021_0 0) vcvs gain=1.950903220161e-01
SMIXQ_c021_0_00 (mix_q_src_c021_0_00 mix_q_c021_0 win_0_00 0) relay vt1=-1m vt2=1m ropen=ropen_mix rclosed=rclosed_mix
EMIXI_c021_0_01 (mix_i_src_c021_0_01 0 bpf_c021_0 0) vcvs gain=8.314696123025e-01
SMIXI_c021_0_01 (mix_i_src_c021_0_01 mix_i_c021_0 win_0_01 0) relay vt1=-1m vt2=1m ropen=ropen_mix rclosed=rclosed_mix
EMIXQ_c021_0_01 (mix_q_src_c021_0_01 0 bpf_c021_0 0) vcvs gain=5.555702330196e-01
SMIXQ_c021_0_01 (mix_q_src_c021_0_01 mix_q_c021_0 win_0_01 0) relay vt1=-1m vt2=1m ropen=ropen_mix rclosed=rclosed_mix
EMIXI_c021_0_02 (mix_i_src_c021_0_02 0 bpf_c021_0 0) vcvs gain=5.555702330196e-01
SMIXI_c021_0_02 (mix_i_src_c021_0_02 mix_i_c021_0 win_0_02 0) relay vt1=-1m vt2=1m ropen=ropen_mix rclosed=rclosed_mix
EMIXQ_c021_0_02 (mix_q_src_c021_0_02 0 bpf_c021_0 0) vcvs gain=8.314696123025e-01
SMIXQ_c021_0_02 (mix_q_src_c021_0_02 mix_q_c021_0 win_0_02 0) relay vt1=-1m vt2=1m ropen=ropen_mix rclosed=rclosed_mix
EMIXI_c021_0_03 (mix_i_src_c021_0_03 0 bpf_c021_0 0) vcvs gain=1.950903220161e-01
SMIXI_c021_0_03 (mix_i_src_c021_0_03 mix_i_c021_0 win_0_03 0) relay vt1=-1m vt2=1m ropen=ropen_mix rclosed=rclosed_mix
EMIXQ_c021_0_03 (mix_q_src_c021_0_03 0 bpf_c021_0 0) vcvs gain=9.807852804032e-01
SMIXQ_c021_0_03 (mix_q_src_c021_0_03 mix_q_c021_0 win_0_03 0) relay vt1=-1m vt2=1m ropen=ropen_mix rclosed=rclosed_mix
EMIXI_c021_0_04 (mix_i_src_c021_0_04 0 bpf_c021_0 0) vcvs gain=-1.950903220161e-01
SMIXI_c021_0_04 (mix_i_src_c021_0_04 mix_i_c021_0 win_0_04 0) relay vt1=-1m vt2=1m ropen=ropen_mix rclosed=rclosed_mix
EMIXQ_c021_0_04 (mix_q_src_c021_0_04 0 bpf_c021_0 0) vcvs gain=9.807852804032e-01
SMIXQ_c021_0_04 (mix_q_src_c021_0_04 mix_q_c021_0 win_0_04 0) relay vt1=-1m vt2=1m ropen=ropen_mix rclosed=rclosed_mix
EMIXI_c021_0_05 (mix_i_src_c021_0_05 0 bpf_c021_0 0) vcvs gain=-5.555702330196e-01
SMIXI_c021_0_05 (mix_i_src_c021_0_05 mix_i_c021_0 win_0_05 0) relay vt1=-1m vt2=1m ropen=ropen_mix rclosed=rclosed_mix
EMIXQ_c021_0_05 (mix_q_src_c021_0_05 0 bpf_c021_0 0) vcvs gain=8.314696123025e-01
SMIXQ_c021_0_05 (mix_q_src_c021_0_05 mix_q_c021_0 win_0_05 0) relay vt1=-1m vt2=1m ropen=ropen_mix rclosed=rclosed_mix
EMIXI_c021_0_06 (mix_i_src_c021_0_06 0 bpf_c021_0 0) vcvs gain=-8.314696123025e-01
SMIXI_c021_0_06 (mix_i_src_c021_0_06 mix_i_c021_0 win_0_06 0) relay vt1=-1m vt2=1m ropen=ropen_mix rclosed=rclosed_mix
EMIXQ_c021_0_06 (mix_q_src_c021_0_06 0 bpf_c021_0 0) vcvs gain=5.555702330196e-01
SMIXQ_c021_0_06 (mix_q_src_c021_0_06 mix_q_c021_0 win_0_06 0) relay vt1=-1m vt2=1m ropen=ropen_mix rclosed=rclosed_mix
EMIXI_c021_0_07 (mix_i_src_c021_0_07 0 bpf_c021_0 0) vcvs gain=-9.807852804032e-01
SMIXI_c021_0_07 (mix_i_src_c021_0_07 mix_i_c021_0 win_0_07 0) relay vt1=-1m vt2=1m ropen=ropen_mix rclosed=rclosed_mix
EMIXQ_c021_0_07 (mix_q_src_c021_0_07 0 bpf_c021_0 0) vcvs gain=1.950903220161e-01
SMIXQ_c021_0_07 (mix_q_src_c021_0_07 mix_q_c021_0 win_0_07 0) relay vt1=-1m vt2=1m ropen=ropen_mix rclosed=rclosed_mix
EMIXI_c021_0_08 (mix_i_src_c021_0_08 0 bpf_c021_0 0) vcvs gain=-9.807852804032e-01
SMIXI_c021_0_08 (mix_i_src_c021_0_08 mix_i_c021_0 win_0_08 0) relay vt1=-1m vt2=1m ropen=ropen_mix rclosed=rclosed_mix
EMIXQ_c021_0_08 (mix_q_src_c021_0_08 0 bpf_c021_0 0) vcvs gain=-1.950903220161e-01
SMIXQ_c021_0_08 (mix_q_src_c021_0_08 mix_q_c021_0 win_0_08 0) relay vt1=-1m vt2=1m ropen=ropen_mix rclosed=rclosed_mix
EMIXI_c021_0_09 (mix_i_src_c021_0_09 0 bpf_c021_0 0) vcvs gain=-8.314696123025e-01
SMIXI_c021_0_09 (mix_i_src_c021_0_09 mix_i_c021_0 win_0_09 0) relay vt1=-1m vt2=1m ropen=ropen_mix rclosed=rclosed_mix
EMIXQ_c021_0_09 (mix_q_src_c021_0_09 0 bpf_c021_0 0) vcvs gain=-5.555702330196e-01
SMIXQ_c021_0_09 (mix_q_src_c021_0_09 mix_q_c021_0 win_0_09 0) relay vt1=-1m vt2=1m ropen=ropen_mix rclosed=rclosed_mix
EMIXI_c021_0_10 (mix_i_src_c021_0_10 0 bpf_c021_0 0) vcvs gain=-5.555702330196e-01
SMIXI_c021_0_10 (mix_i_src_c021_0_10 mix_i_c021_0 win_0_10 0) relay vt1=-1m vt2=1m ropen=ropen_mix rclosed=rclosed_mix
EMIXQ_c021_0_10 (mix_q_src_c021_0_10 0 bpf_c021_0 0) vcvs gain=-8.314696123025e-01
SMIXQ_c021_0_10 (mix_q_src_c021_0_10 mix_q_c021_0 win_0_10 0) relay vt1=-1m vt2=1m ropen=ropen_mix rclosed=rclosed_mix
EMIXI_c021_0_11 (mix_i_src_c021_0_11 0 bpf_c021_0 0) vcvs gain=-1.950903220161e-01
SMIXI_c021_0_11 (mix_i_src_c021_0_11 mix_i_c021_0 win_0_11 0) relay vt1=-1m vt2=1m ropen=ropen_mix rclosed=rclosed_mix
EMIXQ_c021_0_11 (mix_q_src_c021_0_11 0 bpf_c021_0 0) vcvs gain=-9.807852804032e-01
SMIXQ_c021_0_11 (mix_q_src_c021_0_11 mix_q_c021_0 win_0_11 0) relay vt1=-1m vt2=1m ropen=ropen_mix rclosed=rclosed_mix
EMIXI_c021_0_12 (mix_i_src_c021_0_12 0 bpf_c021_0 0) vcvs gain=1.950903220161e-01
SMIXI_c021_0_12 (mix_i_src_c021_0_12 mix_i_c021_0 win_0_12 0) relay vt1=-1m vt2=1m ropen=ropen_mix rclosed=rclosed_mix
EMIXQ_c021_0_12 (mix_q_src_c021_0_12 0 bpf_c021_0 0) vcvs gain=-9.807852804032e-01
SMIXQ_c021_0_12 (mix_q_src_c021_0_12 mix_q_c021_0 win_0_12 0) relay vt1=-1m vt2=1m ropen=ropen_mix rclosed=rclosed_mix
EMIXI_c021_0_13 (mix_i_src_c021_0_13 0 bpf_c021_0 0) vcvs gain=5.555702330196e-01
SMIXI_c021_0_13 (mix_i_src_c021_0_13 mix_i_c021_0 win_0_13 0) relay vt1=-1m vt2=1m ropen=ropen_mix rclosed=rclosed_mix
EMIXQ_c021_0_13 (mix_q_src_c021_0_13 0 bpf_c021_0 0) vcvs gain=-8.314696123025e-01
SMIXQ_c021_0_13 (mix_q_src_c021_0_13 mix_q_c021_0 win_0_13 0) relay vt1=-1m vt2=1m ropen=ropen_mix rclosed=rclosed_mix
EMIXI_c021_0_14 (mix_i_src_c021_0_14 0 bpf_c021_0 0) vcvs gain=8.314696123025e-01
SMIXI_c021_0_14 (mix_i_src_c021_0_14 mix_i_c021_0 win_0_14 0) relay vt1=-1m vt2=1m ropen=ropen_mix rclosed=rclosed_mix
EMIXQ_c021_0_14 (mix_q_src_c021_0_14 0 bpf_c021_0 0) vcvs gain=-5.555702330196e-01
SMIXQ_c021_0_14 (mix_q_src_c021_0_14 mix_q_c021_0 win_0_14 0) relay vt1=-1m vt2=1m ropen=ropen_mix rclosed=rclosed_mix
EMIXI_c021_0_15 (mix_i_src_c021_0_15 0 bpf_c021_0 0) vcvs gain=9.807852804032e-01
SMIXI_c021_0_15 (mix_i_src_c021_0_15 mix_i_c021_0 win_0_15 0) relay vt1=-1m vt2=1m ropen=ropen_mix rclosed=rclosed_mix
EMIXQ_c021_0_15 (mix_q_src_c021_0_15 0 bpf_c021_0 0) vcvs gain=-1.950903220161e-01
SMIXQ_c021_0_15 (mix_q_src_c021_0_15 mix_q_c021_0 win_0_15 0) relay vt1=-1m vt2=1m ropen=ropen_mix rclosed=rclosed_mix
RMIXI_c021_0 (mix_i_c021_0 0) resistor r=1G
RMIXQ_c021_0 (mix_q_c021_0 0) resistor r=1G
RINTI_c021_0 (mix_i_c021_0 Icar_c021_0) resistor r=1k
CINTI_c021_0 (Icar_c021_0 0) capacitor c=80p
RINTQ_c021_0 (mix_q_c021_0 Qcar_c021_0) resistor r=1k
CINTQ_c021_0 (Qcar_c021_0 0) capacitor c=80p
save bpf_c021_0 Icar_c021_0 Qcar_c021_0

// bl021, carrier_1: 500000000 Hz coherent I/Q phase-window verification-demod path
CBPF_c021_1 (bl021 n_cbpf_c021_1) capacitor c=1.013211836423e-13
LBPF_c021_1 (n_cbpf_c021_1 bpf_c021_1) inductor l=1.000000000000e-06
RBPF_c021_1 (bpf_c021_1 0) resistor r=1.570796326795e+02
EMIXI_c021_1_00 (mix_i_src_c021_1_00 0 bpf_c021_1 0) vcvs gain=9.807852804032e-01
SMIXI_c021_1_00 (mix_i_src_c021_1_00 mix_i_c021_1 win_1_00 0) relay vt1=-1m vt2=1m ropen=ropen_mix rclosed=rclosed_mix
EMIXQ_c021_1_00 (mix_q_src_c021_1_00 0 bpf_c021_1 0) vcvs gain=1.950903220161e-01
SMIXQ_c021_1_00 (mix_q_src_c021_1_00 mix_q_c021_1 win_1_00 0) relay vt1=-1m vt2=1m ropen=ropen_mix rclosed=rclosed_mix
EMIXI_c021_1_01 (mix_i_src_c021_1_01 0 bpf_c021_1 0) vcvs gain=8.314696123025e-01
SMIXI_c021_1_01 (mix_i_src_c021_1_01 mix_i_c021_1 win_1_01 0) relay vt1=-1m vt2=1m ropen=ropen_mix rclosed=rclosed_mix
EMIXQ_c021_1_01 (mix_q_src_c021_1_01 0 bpf_c021_1 0) vcvs gain=5.555702330196e-01
SMIXQ_c021_1_01 (mix_q_src_c021_1_01 mix_q_c021_1 win_1_01 0) relay vt1=-1m vt2=1m ropen=ropen_mix rclosed=rclosed_mix
EMIXI_c021_1_02 (mix_i_src_c021_1_02 0 bpf_c021_1 0) vcvs gain=5.555702330196e-01
SMIXI_c021_1_02 (mix_i_src_c021_1_02 mix_i_c021_1 win_1_02 0) relay vt1=-1m vt2=1m ropen=ropen_mix rclosed=rclosed_mix
EMIXQ_c021_1_02 (mix_q_src_c021_1_02 0 bpf_c021_1 0) vcvs gain=8.314696123025e-01
SMIXQ_c021_1_02 (mix_q_src_c021_1_02 mix_q_c021_1 win_1_02 0) relay vt1=-1m vt2=1m ropen=ropen_mix rclosed=rclosed_mix
EMIXI_c021_1_03 (mix_i_src_c021_1_03 0 bpf_c021_1 0) vcvs gain=1.950903220161e-01
SMIXI_c021_1_03 (mix_i_src_c021_1_03 mix_i_c021_1 win_1_03 0) relay vt1=-1m vt2=1m ropen=ropen_mix rclosed=rclosed_mix
EMIXQ_c021_1_03 (mix_q_src_c021_1_03 0 bpf_c021_1 0) vcvs gain=9.807852804032e-01
SMIXQ_c021_1_03 (mix_q_src_c021_1_03 mix_q_c021_1 win_1_03 0) relay vt1=-1m vt2=1m ropen=ropen_mix rclosed=rclosed_mix
EMIXI_c021_1_04 (mix_i_src_c021_1_04 0 bpf_c021_1 0) vcvs gain=-1.950903220161e-01
SMIXI_c021_1_04 (mix_i_src_c021_1_04 mix_i_c021_1 win_1_04 0) relay vt1=-1m vt2=1m ropen=ropen_mix rclosed=rclosed_mix
EMIXQ_c021_1_04 (mix_q_src_c021_1_04 0 bpf_c021_1 0) vcvs gain=9.807852804032e-01
SMIXQ_c021_1_04 (mix_q_src_c021_1_04 mix_q_c021_1 win_1_04 0) relay vt1=-1m vt2=1m ropen=ropen_mix rclosed=rclosed_mix
EMIXI_c021_1_05 (mix_i_src_c021_1_05 0 bpf_c021_1 0) vcvs gain=-5.555702330196e-01
SMIXI_c021_1_05 (mix_i_src_c021_1_05 mix_i_c021_1 win_1_05 0) relay vt1=-1m vt2=1m ropen=ropen_mix rclosed=rclosed_mix
EMIXQ_c021_1_05 (mix_q_src_c021_1_05 0 bpf_c021_1 0) vcvs gain=8.314696123025e-01
SMIXQ_c021_1_05 (mix_q_src_c021_1_05 mix_q_c021_1 win_1_05 0) relay vt1=-1m vt2=1m ropen=ropen_mix rclosed=rclosed_mix
EMIXI_c021_1_06 (mix_i_src_c021_1_06 0 bpf_c021_1 0) vcvs gain=-8.314696123025e-01
SMIXI_c021_1_06 (mix_i_src_c021_1_06 mix_i_c021_1 win_1_06 0) relay vt1=-1m vt2=1m ropen=ropen_mix rclosed=rclosed_mix
EMIXQ_c021_1_06 (mix_q_src_c021_1_06 0 bpf_c021_1 0) vcvs gain=5.555702330196e-01
SMIXQ_c021_1_06 (mix_q_src_c021_1_06 mix_q_c021_1 win_1_06 0) relay vt1=-1m vt2=1m ropen=ropen_mix rclosed=rclosed_mix
EMIXI_c021_1_07 (mix_i_src_c021_1_07 0 bpf_c021_1 0) vcvs gain=-9.807852804032e-01
SMIXI_c021_1_07 (mix_i_src_c021_1_07 mix_i_c021_1 win_1_07 0) relay vt1=-1m vt2=1m ropen=ropen_mix rclosed=rclosed_mix
EMIXQ_c021_1_07 (mix_q_src_c021_1_07 0 bpf_c021_1 0) vcvs gain=1.950903220161e-01
SMIXQ_c021_1_07 (mix_q_src_c021_1_07 mix_q_c021_1 win_1_07 0) relay vt1=-1m vt2=1m ropen=ropen_mix rclosed=rclosed_mix
EMIXI_c021_1_08 (mix_i_src_c021_1_08 0 bpf_c021_1 0) vcvs gain=-9.807852804032e-01
SMIXI_c021_1_08 (mix_i_src_c021_1_08 mix_i_c021_1 win_1_08 0) relay vt1=-1m vt2=1m ropen=ropen_mix rclosed=rclosed_mix
EMIXQ_c021_1_08 (mix_q_src_c021_1_08 0 bpf_c021_1 0) vcvs gain=-1.950903220161e-01
SMIXQ_c021_1_08 (mix_q_src_c021_1_08 mix_q_c021_1 win_1_08 0) relay vt1=-1m vt2=1m ropen=ropen_mix rclosed=rclosed_mix
EMIXI_c021_1_09 (mix_i_src_c021_1_09 0 bpf_c021_1 0) vcvs gain=-8.314696123025e-01
SMIXI_c021_1_09 (mix_i_src_c021_1_09 mix_i_c021_1 win_1_09 0) relay vt1=-1m vt2=1m ropen=ropen_mix rclosed=rclosed_mix
EMIXQ_c021_1_09 (mix_q_src_c021_1_09 0 bpf_c021_1 0) vcvs gain=-5.555702330196e-01
SMIXQ_c021_1_09 (mix_q_src_c021_1_09 mix_q_c021_1 win_1_09 0) relay vt1=-1m vt2=1m ropen=ropen_mix rclosed=rclosed_mix
EMIXI_c021_1_10 (mix_i_src_c021_1_10 0 bpf_c021_1 0) vcvs gain=-5.555702330196e-01
SMIXI_c021_1_10 (mix_i_src_c021_1_10 mix_i_c021_1 win_1_10 0) relay vt1=-1m vt2=1m ropen=ropen_mix rclosed=rclosed_mix
EMIXQ_c021_1_10 (mix_q_src_c021_1_10 0 bpf_c021_1 0) vcvs gain=-8.314696123025e-01
SMIXQ_c021_1_10 (mix_q_src_c021_1_10 mix_q_c021_1 win_1_10 0) relay vt1=-1m vt2=1m ropen=ropen_mix rclosed=rclosed_mix
EMIXI_c021_1_11 (mix_i_src_c021_1_11 0 bpf_c021_1 0) vcvs gain=-1.950903220161e-01
SMIXI_c021_1_11 (mix_i_src_c021_1_11 mix_i_c021_1 win_1_11 0) relay vt1=-1m vt2=1m ropen=ropen_mix rclosed=rclosed_mix
EMIXQ_c021_1_11 (mix_q_src_c021_1_11 0 bpf_c021_1 0) vcvs gain=-9.807852804032e-01
SMIXQ_c021_1_11 (mix_q_src_c021_1_11 mix_q_c021_1 win_1_11 0) relay vt1=-1m vt2=1m ropen=ropen_mix rclosed=rclosed_mix
EMIXI_c021_1_12 (mix_i_src_c021_1_12 0 bpf_c021_1 0) vcvs gain=1.950903220161e-01
SMIXI_c021_1_12 (mix_i_src_c021_1_12 mix_i_c021_1 win_1_12 0) relay vt1=-1m vt2=1m ropen=ropen_mix rclosed=rclosed_mix
EMIXQ_c021_1_12 (mix_q_src_c021_1_12 0 bpf_c021_1 0) vcvs gain=-9.807852804032e-01
SMIXQ_c021_1_12 (mix_q_src_c021_1_12 mix_q_c021_1 win_1_12 0) relay vt1=-1m vt2=1m ropen=ropen_mix rclosed=rclosed_mix
EMIXI_c021_1_13 (mix_i_src_c021_1_13 0 bpf_c021_1 0) vcvs gain=5.555702330196e-01
SMIXI_c021_1_13 (mix_i_src_c021_1_13 mix_i_c021_1 win_1_13 0) relay vt1=-1m vt2=1m ropen=ropen_mix rclosed=rclosed_mix
EMIXQ_c021_1_13 (mix_q_src_c021_1_13 0 bpf_c021_1 0) vcvs gain=-8.314696123025e-01
SMIXQ_c021_1_13 (mix_q_src_c021_1_13 mix_q_c021_1 win_1_13 0) relay vt1=-1m vt2=1m ropen=ropen_mix rclosed=rclosed_mix
EMIXI_c021_1_14 (mix_i_src_c021_1_14 0 bpf_c021_1 0) vcvs gain=8.314696123025e-01
SMIXI_c021_1_14 (mix_i_src_c021_1_14 mix_i_c021_1 win_1_14 0) relay vt1=-1m vt2=1m ropen=ropen_mix rclosed=rclosed_mix
EMIXQ_c021_1_14 (mix_q_src_c021_1_14 0 bpf_c021_1 0) vcvs gain=-5.555702330196e-01
SMIXQ_c021_1_14 (mix_q_src_c021_1_14 mix_q_c021_1 win_1_14 0) relay vt1=-1m vt2=1m ropen=ropen_mix rclosed=rclosed_mix
EMIXI_c021_1_15 (mix_i_src_c021_1_15 0 bpf_c021_1 0) vcvs gain=9.807852804032e-01
SMIXI_c021_1_15 (mix_i_src_c021_1_15 mix_i_c021_1 win_1_15 0) relay vt1=-1m vt2=1m ropen=ropen_mix rclosed=rclosed_mix
EMIXQ_c021_1_15 (mix_q_src_c021_1_15 0 bpf_c021_1 0) vcvs gain=-1.950903220161e-01
SMIXQ_c021_1_15 (mix_q_src_c021_1_15 mix_q_c021_1 win_1_15 0) relay vt1=-1m vt2=1m ropen=ropen_mix rclosed=rclosed_mix
RMIXI_c021_1 (mix_i_c021_1 0) resistor r=1G
RMIXQ_c021_1 (mix_q_c021_1 0) resistor r=1G
RINTI_c021_1 (mix_i_c021_1 Icar_c021_1) resistor r=1k
CINTI_c021_1 (Icar_c021_1 0) capacitor c=80p
RINTQ_c021_1 (mix_q_c021_1 Qcar_c021_1) resistor r=1k
CINTQ_c021_1 (Qcar_c021_1 0) capacitor c=80p
save bpf_c021_1 Icar_c021_1 Qcar_c021_1

// bl021, carrier_2: 750000000 Hz coherent I/Q phase-window verification-demod path
CBPF_c021_2 (bl021 n_cbpf_c021_2) capacitor c=4.503163717437e-14
LBPF_c021_2 (n_cbpf_c021_2 bpf_c021_2) inductor l=1.000000000000e-06
RBPF_c021_2 (bpf_c021_2 0) resistor r=2.356194490192e+02
EMIXI_c021_2_00 (mix_i_src_c021_2_00 0 bpf_c021_2 0) vcvs gain=9.807852804032e-01
SMIXI_c021_2_00 (mix_i_src_c021_2_00 mix_i_c021_2 win_2_00 0) relay vt1=-1m vt2=1m ropen=ropen_mix rclosed=rclosed_mix
EMIXQ_c021_2_00 (mix_q_src_c021_2_00 0 bpf_c021_2 0) vcvs gain=1.950903220161e-01
SMIXQ_c021_2_00 (mix_q_src_c021_2_00 mix_q_c021_2 win_2_00 0) relay vt1=-1m vt2=1m ropen=ropen_mix rclosed=rclosed_mix
EMIXI_c021_2_01 (mix_i_src_c021_2_01 0 bpf_c021_2 0) vcvs gain=8.314696123025e-01
SMIXI_c021_2_01 (mix_i_src_c021_2_01 mix_i_c021_2 win_2_01 0) relay vt1=-1m vt2=1m ropen=ropen_mix rclosed=rclosed_mix
EMIXQ_c021_2_01 (mix_q_src_c021_2_01 0 bpf_c021_2 0) vcvs gain=5.555702330196e-01
SMIXQ_c021_2_01 (mix_q_src_c021_2_01 mix_q_c021_2 win_2_01 0) relay vt1=-1m vt2=1m ropen=ropen_mix rclosed=rclosed_mix
EMIXI_c021_2_02 (mix_i_src_c021_2_02 0 bpf_c021_2 0) vcvs gain=5.555702330196e-01
SMIXI_c021_2_02 (mix_i_src_c021_2_02 mix_i_c021_2 win_2_02 0) relay vt1=-1m vt2=1m ropen=ropen_mix rclosed=rclosed_mix
EMIXQ_c021_2_02 (mix_q_src_c021_2_02 0 bpf_c021_2 0) vcvs gain=8.314696123025e-01
SMIXQ_c021_2_02 (mix_q_src_c021_2_02 mix_q_c021_2 win_2_02 0) relay vt1=-1m vt2=1m ropen=ropen_mix rclosed=rclosed_mix
EMIXI_c021_2_03 (mix_i_src_c021_2_03 0 bpf_c021_2 0) vcvs gain=1.950903220161e-01
SMIXI_c021_2_03 (mix_i_src_c021_2_03 mix_i_c021_2 win_2_03 0) relay vt1=-1m vt2=1m ropen=ropen_mix rclosed=rclosed_mix
EMIXQ_c021_2_03 (mix_q_src_c021_2_03 0 bpf_c021_2 0) vcvs gain=9.807852804032e-01
SMIXQ_c021_2_03 (mix_q_src_c021_2_03 mix_q_c021_2 win_2_03 0) relay vt1=-1m vt2=1m ropen=ropen_mix rclosed=rclosed_mix
EMIXI_c021_2_04 (mix_i_src_c021_2_04 0 bpf_c021_2 0) vcvs gain=-1.950903220161e-01
SMIXI_c021_2_04 (mix_i_src_c021_2_04 mix_i_c021_2 win_2_04 0) relay vt1=-1m vt2=1m ropen=ropen_mix rclosed=rclosed_mix
EMIXQ_c021_2_04 (mix_q_src_c021_2_04 0 bpf_c021_2 0) vcvs gain=9.807852804032e-01
SMIXQ_c021_2_04 (mix_q_src_c021_2_04 mix_q_c021_2 win_2_04 0) relay vt1=-1m vt2=1m ropen=ropen_mix rclosed=rclosed_mix
EMIXI_c021_2_05 (mix_i_src_c021_2_05 0 bpf_c021_2 0) vcvs gain=-5.555702330196e-01
SMIXI_c021_2_05 (mix_i_src_c021_2_05 mix_i_c021_2 win_2_05 0) relay vt1=-1m vt2=1m ropen=ropen_mix rclosed=rclosed_mix
EMIXQ_c021_2_05 (mix_q_src_c021_2_05 0 bpf_c021_2 0) vcvs gain=8.314696123025e-01
SMIXQ_c021_2_05 (mix_q_src_c021_2_05 mix_q_c021_2 win_2_05 0) relay vt1=-1m vt2=1m ropen=ropen_mix rclosed=rclosed_mix
EMIXI_c021_2_06 (mix_i_src_c021_2_06 0 bpf_c021_2 0) vcvs gain=-8.314696123025e-01
SMIXI_c021_2_06 (mix_i_src_c021_2_06 mix_i_c021_2 win_2_06 0) relay vt1=-1m vt2=1m ropen=ropen_mix rclosed=rclosed_mix
EMIXQ_c021_2_06 (mix_q_src_c021_2_06 0 bpf_c021_2 0) vcvs gain=5.555702330196e-01
SMIXQ_c021_2_06 (mix_q_src_c021_2_06 mix_q_c021_2 win_2_06 0) relay vt1=-1m vt2=1m ropen=ropen_mix rclosed=rclosed_mix
EMIXI_c021_2_07 (mix_i_src_c021_2_07 0 bpf_c021_2 0) vcvs gain=-9.807852804032e-01
SMIXI_c021_2_07 (mix_i_src_c021_2_07 mix_i_c021_2 win_2_07 0) relay vt1=-1m vt2=1m ropen=ropen_mix rclosed=rclosed_mix
EMIXQ_c021_2_07 (mix_q_src_c021_2_07 0 bpf_c021_2 0) vcvs gain=1.950903220161e-01
SMIXQ_c021_2_07 (mix_q_src_c021_2_07 mix_q_c021_2 win_2_07 0) relay vt1=-1m vt2=1m ropen=ropen_mix rclosed=rclosed_mix
EMIXI_c021_2_08 (mix_i_src_c021_2_08 0 bpf_c021_2 0) vcvs gain=-9.807852804032e-01
SMIXI_c021_2_08 (mix_i_src_c021_2_08 mix_i_c021_2 win_2_08 0) relay vt1=-1m vt2=1m ropen=ropen_mix rclosed=rclosed_mix
EMIXQ_c021_2_08 (mix_q_src_c021_2_08 0 bpf_c021_2 0) vcvs gain=-1.950903220161e-01
SMIXQ_c021_2_08 (mix_q_src_c021_2_08 mix_q_c021_2 win_2_08 0) relay vt1=-1m vt2=1m ropen=ropen_mix rclosed=rclosed_mix
EMIXI_c021_2_09 (mix_i_src_c021_2_09 0 bpf_c021_2 0) vcvs gain=-8.314696123025e-01
SMIXI_c021_2_09 (mix_i_src_c021_2_09 mix_i_c021_2 win_2_09 0) relay vt1=-1m vt2=1m ropen=ropen_mix rclosed=rclosed_mix
EMIXQ_c021_2_09 (mix_q_src_c021_2_09 0 bpf_c021_2 0) vcvs gain=-5.555702330196e-01
SMIXQ_c021_2_09 (mix_q_src_c021_2_09 mix_q_c021_2 win_2_09 0) relay vt1=-1m vt2=1m ropen=ropen_mix rclosed=rclosed_mix
EMIXI_c021_2_10 (mix_i_src_c021_2_10 0 bpf_c021_2 0) vcvs gain=-5.555702330196e-01
SMIXI_c021_2_10 (mix_i_src_c021_2_10 mix_i_c021_2 win_2_10 0) relay vt1=-1m vt2=1m ropen=ropen_mix rclosed=rclosed_mix
EMIXQ_c021_2_10 (mix_q_src_c021_2_10 0 bpf_c021_2 0) vcvs gain=-8.314696123025e-01
SMIXQ_c021_2_10 (mix_q_src_c021_2_10 mix_q_c021_2 win_2_10 0) relay vt1=-1m vt2=1m ropen=ropen_mix rclosed=rclosed_mix
EMIXI_c021_2_11 (mix_i_src_c021_2_11 0 bpf_c021_2 0) vcvs gain=-1.950903220161e-01
SMIXI_c021_2_11 (mix_i_src_c021_2_11 mix_i_c021_2 win_2_11 0) relay vt1=-1m vt2=1m ropen=ropen_mix rclosed=rclosed_mix
EMIXQ_c021_2_11 (mix_q_src_c021_2_11 0 bpf_c021_2 0) vcvs gain=-9.807852804032e-01
SMIXQ_c021_2_11 (mix_q_src_c021_2_11 mix_q_c021_2 win_2_11 0) relay vt1=-1m vt2=1m ropen=ropen_mix rclosed=rclosed_mix
EMIXI_c021_2_12 (mix_i_src_c021_2_12 0 bpf_c021_2 0) vcvs gain=1.950903220161e-01
SMIXI_c021_2_12 (mix_i_src_c021_2_12 mix_i_c021_2 win_2_12 0) relay vt1=-1m vt2=1m ropen=ropen_mix rclosed=rclosed_mix
EMIXQ_c021_2_12 (mix_q_src_c021_2_12 0 bpf_c021_2 0) vcvs gain=-9.807852804032e-01
SMIXQ_c021_2_12 (mix_q_src_c021_2_12 mix_q_c021_2 win_2_12 0) relay vt1=-1m vt2=1m ropen=ropen_mix rclosed=rclosed_mix
EMIXI_c021_2_13 (mix_i_src_c021_2_13 0 bpf_c021_2 0) vcvs gain=5.555702330196e-01
SMIXI_c021_2_13 (mix_i_src_c021_2_13 mix_i_c021_2 win_2_13 0) relay vt1=-1m vt2=1m ropen=ropen_mix rclosed=rclosed_mix
EMIXQ_c021_2_13 (mix_q_src_c021_2_13 0 bpf_c021_2 0) vcvs gain=-8.314696123025e-01
SMIXQ_c021_2_13 (mix_q_src_c021_2_13 mix_q_c021_2 win_2_13 0) relay vt1=-1m vt2=1m ropen=ropen_mix rclosed=rclosed_mix
EMIXI_c021_2_14 (mix_i_src_c021_2_14 0 bpf_c021_2 0) vcvs gain=8.314696123025e-01
SMIXI_c021_2_14 (mix_i_src_c021_2_14 mix_i_c021_2 win_2_14 0) relay vt1=-1m vt2=1m ropen=ropen_mix rclosed=rclosed_mix
EMIXQ_c021_2_14 (mix_q_src_c021_2_14 0 bpf_c021_2 0) vcvs gain=-5.555702330196e-01
SMIXQ_c021_2_14 (mix_q_src_c021_2_14 mix_q_c021_2 win_2_14 0) relay vt1=-1m vt2=1m ropen=ropen_mix rclosed=rclosed_mix
EMIXI_c021_2_15 (mix_i_src_c021_2_15 0 bpf_c021_2 0) vcvs gain=9.807852804032e-01
SMIXI_c021_2_15 (mix_i_src_c021_2_15 mix_i_c021_2 win_2_15 0) relay vt1=-1m vt2=1m ropen=ropen_mix rclosed=rclosed_mix
EMIXQ_c021_2_15 (mix_q_src_c021_2_15 0 bpf_c021_2 0) vcvs gain=-1.950903220161e-01
SMIXQ_c021_2_15 (mix_q_src_c021_2_15 mix_q_c021_2 win_2_15 0) relay vt1=-1m vt2=1m ropen=ropen_mix rclosed=rclosed_mix
RMIXI_c021_2 (mix_i_c021_2 0) resistor r=1G
RMIXQ_c021_2 (mix_q_c021_2 0) resistor r=1G
RINTI_c021_2 (mix_i_c021_2 Icar_c021_2) resistor r=1k
CINTI_c021_2 (Icar_c021_2 0) capacitor c=80p
RINTQ_c021_2 (mix_q_c021_2 Qcar_c021_2) resistor r=1k
CINTQ_c021_2 (Qcar_c021_2 0) capacitor c=80p
save bpf_c021_2 Icar_c021_2 Qcar_c021_2

// bl021, carrier_3: 1000000000 Hz coherent I/Q phase-window verification-demod path
CBPF_c021_3 (bl021 n_cbpf_c021_3) capacitor c=2.533029591058e-14
LBPF_c021_3 (n_cbpf_c021_3 bpf_c021_3) inductor l=1.000000000000e-06
RBPF_c021_3 (bpf_c021_3 0) resistor r=3.141592653590e+02
EMIXI_c021_3_00 (mix_i_src_c021_3_00 0 bpf_c021_3 0) vcvs gain=9.807852804032e-01
SMIXI_c021_3_00 (mix_i_src_c021_3_00 mix_i_c021_3 win_3_00 0) relay vt1=-1m vt2=1m ropen=ropen_mix rclosed=rclosed_mix
EMIXQ_c021_3_00 (mix_q_src_c021_3_00 0 bpf_c021_3 0) vcvs gain=1.950903220161e-01
SMIXQ_c021_3_00 (mix_q_src_c021_3_00 mix_q_c021_3 win_3_00 0) relay vt1=-1m vt2=1m ropen=ropen_mix rclosed=rclosed_mix
EMIXI_c021_3_01 (mix_i_src_c021_3_01 0 bpf_c021_3 0) vcvs gain=8.314696123025e-01
SMIXI_c021_3_01 (mix_i_src_c021_3_01 mix_i_c021_3 win_3_01 0) relay vt1=-1m vt2=1m ropen=ropen_mix rclosed=rclosed_mix
EMIXQ_c021_3_01 (mix_q_src_c021_3_01 0 bpf_c021_3 0) vcvs gain=5.555702330196e-01
SMIXQ_c021_3_01 (mix_q_src_c021_3_01 mix_q_c021_3 win_3_01 0) relay vt1=-1m vt2=1m ropen=ropen_mix rclosed=rclosed_mix
EMIXI_c021_3_02 (mix_i_src_c021_3_02 0 bpf_c021_3 0) vcvs gain=5.555702330196e-01
SMIXI_c021_3_02 (mix_i_src_c021_3_02 mix_i_c021_3 win_3_02 0) relay vt1=-1m vt2=1m ropen=ropen_mix rclosed=rclosed_mix
EMIXQ_c021_3_02 (mix_q_src_c021_3_02 0 bpf_c021_3 0) vcvs gain=8.314696123025e-01
SMIXQ_c021_3_02 (mix_q_src_c021_3_02 mix_q_c021_3 win_3_02 0) relay vt1=-1m vt2=1m ropen=ropen_mix rclosed=rclosed_mix
EMIXI_c021_3_03 (mix_i_src_c021_3_03 0 bpf_c021_3 0) vcvs gain=1.950903220161e-01
SMIXI_c021_3_03 (mix_i_src_c021_3_03 mix_i_c021_3 win_3_03 0) relay vt1=-1m vt2=1m ropen=ropen_mix rclosed=rclosed_mix
EMIXQ_c021_3_03 (mix_q_src_c021_3_03 0 bpf_c021_3 0) vcvs gain=9.807852804032e-01
SMIXQ_c021_3_03 (mix_q_src_c021_3_03 mix_q_c021_3 win_3_03 0) relay vt1=-1m vt2=1m ropen=ropen_mix rclosed=rclosed_mix
EMIXI_c021_3_04 (mix_i_src_c021_3_04 0 bpf_c021_3 0) vcvs gain=-1.950903220161e-01
SMIXI_c021_3_04 (mix_i_src_c021_3_04 mix_i_c021_3 win_3_04 0) relay vt1=-1m vt2=1m ropen=ropen_mix rclosed=rclosed_mix
EMIXQ_c021_3_04 (mix_q_src_c021_3_04 0 bpf_c021_3 0) vcvs gain=9.807852804032e-01
SMIXQ_c021_3_04 (mix_q_src_c021_3_04 mix_q_c021_3 win_3_04 0) relay vt1=-1m vt2=1m ropen=ropen_mix rclosed=rclosed_mix
EMIXI_c021_3_05 (mix_i_src_c021_3_05 0 bpf_c021_3 0) vcvs gain=-5.555702330196e-01
SMIXI_c021_3_05 (mix_i_src_c021_3_05 mix_i_c021_3 win_3_05 0) relay vt1=-1m vt2=1m ropen=ropen_mix rclosed=rclosed_mix
EMIXQ_c021_3_05 (mix_q_src_c021_3_05 0 bpf_c021_3 0) vcvs gain=8.314696123025e-01
SMIXQ_c021_3_05 (mix_q_src_c021_3_05 mix_q_c021_3 win_3_05 0) relay vt1=-1m vt2=1m ropen=ropen_mix rclosed=rclosed_mix
EMIXI_c021_3_06 (mix_i_src_c021_3_06 0 bpf_c021_3 0) vcvs gain=-8.314696123025e-01
SMIXI_c021_3_06 (mix_i_src_c021_3_06 mix_i_c021_3 win_3_06 0) relay vt1=-1m vt2=1m ropen=ropen_mix rclosed=rclosed_mix
EMIXQ_c021_3_06 (mix_q_src_c021_3_06 0 bpf_c021_3 0) vcvs gain=5.555702330196e-01
SMIXQ_c021_3_06 (mix_q_src_c021_3_06 mix_q_c021_3 win_3_06 0) relay vt1=-1m vt2=1m ropen=ropen_mix rclosed=rclosed_mix
EMIXI_c021_3_07 (mix_i_src_c021_3_07 0 bpf_c021_3 0) vcvs gain=-9.807852804032e-01
SMIXI_c021_3_07 (mix_i_src_c021_3_07 mix_i_c021_3 win_3_07 0) relay vt1=-1m vt2=1m ropen=ropen_mix rclosed=rclosed_mix
EMIXQ_c021_3_07 (mix_q_src_c021_3_07 0 bpf_c021_3 0) vcvs gain=1.950903220161e-01
SMIXQ_c021_3_07 (mix_q_src_c021_3_07 mix_q_c021_3 win_3_07 0) relay vt1=-1m vt2=1m ropen=ropen_mix rclosed=rclosed_mix
EMIXI_c021_3_08 (mix_i_src_c021_3_08 0 bpf_c021_3 0) vcvs gain=-9.807852804032e-01
SMIXI_c021_3_08 (mix_i_src_c021_3_08 mix_i_c021_3 win_3_08 0) relay vt1=-1m vt2=1m ropen=ropen_mix rclosed=rclosed_mix
EMIXQ_c021_3_08 (mix_q_src_c021_3_08 0 bpf_c021_3 0) vcvs gain=-1.950903220161e-01
SMIXQ_c021_3_08 (mix_q_src_c021_3_08 mix_q_c021_3 win_3_08 0) relay vt1=-1m vt2=1m ropen=ropen_mix rclosed=rclosed_mix
EMIXI_c021_3_09 (mix_i_src_c021_3_09 0 bpf_c021_3 0) vcvs gain=-8.314696123025e-01
SMIXI_c021_3_09 (mix_i_src_c021_3_09 mix_i_c021_3 win_3_09 0) relay vt1=-1m vt2=1m ropen=ropen_mix rclosed=rclosed_mix
EMIXQ_c021_3_09 (mix_q_src_c021_3_09 0 bpf_c021_3 0) vcvs gain=-5.555702330196e-01
SMIXQ_c021_3_09 (mix_q_src_c021_3_09 mix_q_c021_3 win_3_09 0) relay vt1=-1m vt2=1m ropen=ropen_mix rclosed=rclosed_mix
EMIXI_c021_3_10 (mix_i_src_c021_3_10 0 bpf_c021_3 0) vcvs gain=-5.555702330196e-01
SMIXI_c021_3_10 (mix_i_src_c021_3_10 mix_i_c021_3 win_3_10 0) relay vt1=-1m vt2=1m ropen=ropen_mix rclosed=rclosed_mix
EMIXQ_c021_3_10 (mix_q_src_c021_3_10 0 bpf_c021_3 0) vcvs gain=-8.314696123025e-01
SMIXQ_c021_3_10 (mix_q_src_c021_3_10 mix_q_c021_3 win_3_10 0) relay vt1=-1m vt2=1m ropen=ropen_mix rclosed=rclosed_mix
EMIXI_c021_3_11 (mix_i_src_c021_3_11 0 bpf_c021_3 0) vcvs gain=-1.950903220161e-01
SMIXI_c021_3_11 (mix_i_src_c021_3_11 mix_i_c021_3 win_3_11 0) relay vt1=-1m vt2=1m ropen=ropen_mix rclosed=rclosed_mix
EMIXQ_c021_3_11 (mix_q_src_c021_3_11 0 bpf_c021_3 0) vcvs gain=-9.807852804032e-01
SMIXQ_c021_3_11 (mix_q_src_c021_3_11 mix_q_c021_3 win_3_11 0) relay vt1=-1m vt2=1m ropen=ropen_mix rclosed=rclosed_mix
EMIXI_c021_3_12 (mix_i_src_c021_3_12 0 bpf_c021_3 0) vcvs gain=1.950903220161e-01
SMIXI_c021_3_12 (mix_i_src_c021_3_12 mix_i_c021_3 win_3_12 0) relay vt1=-1m vt2=1m ropen=ropen_mix rclosed=rclosed_mix
EMIXQ_c021_3_12 (mix_q_src_c021_3_12 0 bpf_c021_3 0) vcvs gain=-9.807852804032e-01
SMIXQ_c021_3_12 (mix_q_src_c021_3_12 mix_q_c021_3 win_3_12 0) relay vt1=-1m vt2=1m ropen=ropen_mix rclosed=rclosed_mix
EMIXI_c021_3_13 (mix_i_src_c021_3_13 0 bpf_c021_3 0) vcvs gain=5.555702330196e-01
SMIXI_c021_3_13 (mix_i_src_c021_3_13 mix_i_c021_3 win_3_13 0) relay vt1=-1m vt2=1m ropen=ropen_mix rclosed=rclosed_mix
EMIXQ_c021_3_13 (mix_q_src_c021_3_13 0 bpf_c021_3 0) vcvs gain=-8.314696123025e-01
SMIXQ_c021_3_13 (mix_q_src_c021_3_13 mix_q_c021_3 win_3_13 0) relay vt1=-1m vt2=1m ropen=ropen_mix rclosed=rclosed_mix
EMIXI_c021_3_14 (mix_i_src_c021_3_14 0 bpf_c021_3 0) vcvs gain=8.314696123025e-01
SMIXI_c021_3_14 (mix_i_src_c021_3_14 mix_i_c021_3 win_3_14 0) relay vt1=-1m vt2=1m ropen=ropen_mix rclosed=rclosed_mix
EMIXQ_c021_3_14 (mix_q_src_c021_3_14 0 bpf_c021_3 0) vcvs gain=-5.555702330196e-01
SMIXQ_c021_3_14 (mix_q_src_c021_3_14 mix_q_c021_3 win_3_14 0) relay vt1=-1m vt2=1m ropen=ropen_mix rclosed=rclosed_mix
EMIXI_c021_3_15 (mix_i_src_c021_3_15 0 bpf_c021_3 0) vcvs gain=9.807852804032e-01
SMIXI_c021_3_15 (mix_i_src_c021_3_15 mix_i_c021_3 win_3_15 0) relay vt1=-1m vt2=1m ropen=ropen_mix rclosed=rclosed_mix
EMIXQ_c021_3_15 (mix_q_src_c021_3_15 0 bpf_c021_3 0) vcvs gain=-1.950903220161e-01
SMIXQ_c021_3_15 (mix_q_src_c021_3_15 mix_q_c021_3 win_3_15 0) relay vt1=-1m vt2=1m ropen=ropen_mix rclosed=rclosed_mix
RMIXI_c021_3 (mix_i_c021_3 0) resistor r=1G
RMIXQ_c021_3 (mix_q_c021_3 0) resistor r=1G
RINTI_c021_3 (mix_i_c021_3 Icar_c021_3) resistor r=1k
CINTI_c021_3 (Icar_c021_3 0) capacitor c=80p
RINTQ_c021_3 (mix_q_c021_3 Qcar_c021_3) resistor r=1k
CINTQ_c021_3 (Qcar_c021_3 0) capacitor c=80p
save bpf_c021_3 Icar_c021_3 Qcar_c021_3

// bl022, carrier_0: 250000000 Hz coherent I/Q phase-window verification-demod path
CBPF_c022_0 (bl022 n_cbpf_c022_0) capacitor c=4.052847345694e-13
LBPF_c022_0 (n_cbpf_c022_0 bpf_c022_0) inductor l=1.000000000000e-06
RBPF_c022_0 (bpf_c022_0 0) resistor r=7.853981633974e+01
EMIXI_c022_0_00 (mix_i_src_c022_0_00 0 bpf_c022_0 0) vcvs gain=9.807852804032e-01
SMIXI_c022_0_00 (mix_i_src_c022_0_00 mix_i_c022_0 win_0_00 0) relay vt1=-1m vt2=1m ropen=ropen_mix rclosed=rclosed_mix
EMIXQ_c022_0_00 (mix_q_src_c022_0_00 0 bpf_c022_0 0) vcvs gain=1.950903220161e-01
SMIXQ_c022_0_00 (mix_q_src_c022_0_00 mix_q_c022_0 win_0_00 0) relay vt1=-1m vt2=1m ropen=ropen_mix rclosed=rclosed_mix
EMIXI_c022_0_01 (mix_i_src_c022_0_01 0 bpf_c022_0 0) vcvs gain=8.314696123025e-01
SMIXI_c022_0_01 (mix_i_src_c022_0_01 mix_i_c022_0 win_0_01 0) relay vt1=-1m vt2=1m ropen=ropen_mix rclosed=rclosed_mix
EMIXQ_c022_0_01 (mix_q_src_c022_0_01 0 bpf_c022_0 0) vcvs gain=5.555702330196e-01
SMIXQ_c022_0_01 (mix_q_src_c022_0_01 mix_q_c022_0 win_0_01 0) relay vt1=-1m vt2=1m ropen=ropen_mix rclosed=rclosed_mix
EMIXI_c022_0_02 (mix_i_src_c022_0_02 0 bpf_c022_0 0) vcvs gain=5.555702330196e-01
SMIXI_c022_0_02 (mix_i_src_c022_0_02 mix_i_c022_0 win_0_02 0) relay vt1=-1m vt2=1m ropen=ropen_mix rclosed=rclosed_mix
EMIXQ_c022_0_02 (mix_q_src_c022_0_02 0 bpf_c022_0 0) vcvs gain=8.314696123025e-01
SMIXQ_c022_0_02 (mix_q_src_c022_0_02 mix_q_c022_0 win_0_02 0) relay vt1=-1m vt2=1m ropen=ropen_mix rclosed=rclosed_mix
EMIXI_c022_0_03 (mix_i_src_c022_0_03 0 bpf_c022_0 0) vcvs gain=1.950903220161e-01
SMIXI_c022_0_03 (mix_i_src_c022_0_03 mix_i_c022_0 win_0_03 0) relay vt1=-1m vt2=1m ropen=ropen_mix rclosed=rclosed_mix
EMIXQ_c022_0_03 (mix_q_src_c022_0_03 0 bpf_c022_0 0) vcvs gain=9.807852804032e-01
SMIXQ_c022_0_03 (mix_q_src_c022_0_03 mix_q_c022_0 win_0_03 0) relay vt1=-1m vt2=1m ropen=ropen_mix rclosed=rclosed_mix
EMIXI_c022_0_04 (mix_i_src_c022_0_04 0 bpf_c022_0 0) vcvs gain=-1.950903220161e-01
SMIXI_c022_0_04 (mix_i_src_c022_0_04 mix_i_c022_0 win_0_04 0) relay vt1=-1m vt2=1m ropen=ropen_mix rclosed=rclosed_mix
EMIXQ_c022_0_04 (mix_q_src_c022_0_04 0 bpf_c022_0 0) vcvs gain=9.807852804032e-01
SMIXQ_c022_0_04 (mix_q_src_c022_0_04 mix_q_c022_0 win_0_04 0) relay vt1=-1m vt2=1m ropen=ropen_mix rclosed=rclosed_mix
EMIXI_c022_0_05 (mix_i_src_c022_0_05 0 bpf_c022_0 0) vcvs gain=-5.555702330196e-01
SMIXI_c022_0_05 (mix_i_src_c022_0_05 mix_i_c022_0 win_0_05 0) relay vt1=-1m vt2=1m ropen=ropen_mix rclosed=rclosed_mix
EMIXQ_c022_0_05 (mix_q_src_c022_0_05 0 bpf_c022_0 0) vcvs gain=8.314696123025e-01
SMIXQ_c022_0_05 (mix_q_src_c022_0_05 mix_q_c022_0 win_0_05 0) relay vt1=-1m vt2=1m ropen=ropen_mix rclosed=rclosed_mix
EMIXI_c022_0_06 (mix_i_src_c022_0_06 0 bpf_c022_0 0) vcvs gain=-8.314696123025e-01
SMIXI_c022_0_06 (mix_i_src_c022_0_06 mix_i_c022_0 win_0_06 0) relay vt1=-1m vt2=1m ropen=ropen_mix rclosed=rclosed_mix
EMIXQ_c022_0_06 (mix_q_src_c022_0_06 0 bpf_c022_0 0) vcvs gain=5.555702330196e-01
SMIXQ_c022_0_06 (mix_q_src_c022_0_06 mix_q_c022_0 win_0_06 0) relay vt1=-1m vt2=1m ropen=ropen_mix rclosed=rclosed_mix
EMIXI_c022_0_07 (mix_i_src_c022_0_07 0 bpf_c022_0 0) vcvs gain=-9.807852804032e-01
SMIXI_c022_0_07 (mix_i_src_c022_0_07 mix_i_c022_0 win_0_07 0) relay vt1=-1m vt2=1m ropen=ropen_mix rclosed=rclosed_mix
EMIXQ_c022_0_07 (mix_q_src_c022_0_07 0 bpf_c022_0 0) vcvs gain=1.950903220161e-01
SMIXQ_c022_0_07 (mix_q_src_c022_0_07 mix_q_c022_0 win_0_07 0) relay vt1=-1m vt2=1m ropen=ropen_mix rclosed=rclosed_mix
EMIXI_c022_0_08 (mix_i_src_c022_0_08 0 bpf_c022_0 0) vcvs gain=-9.807852804032e-01
SMIXI_c022_0_08 (mix_i_src_c022_0_08 mix_i_c022_0 win_0_08 0) relay vt1=-1m vt2=1m ropen=ropen_mix rclosed=rclosed_mix
EMIXQ_c022_0_08 (mix_q_src_c022_0_08 0 bpf_c022_0 0) vcvs gain=-1.950903220161e-01
SMIXQ_c022_0_08 (mix_q_src_c022_0_08 mix_q_c022_0 win_0_08 0) relay vt1=-1m vt2=1m ropen=ropen_mix rclosed=rclosed_mix
EMIXI_c022_0_09 (mix_i_src_c022_0_09 0 bpf_c022_0 0) vcvs gain=-8.314696123025e-01
SMIXI_c022_0_09 (mix_i_src_c022_0_09 mix_i_c022_0 win_0_09 0) relay vt1=-1m vt2=1m ropen=ropen_mix rclosed=rclosed_mix
EMIXQ_c022_0_09 (mix_q_src_c022_0_09 0 bpf_c022_0 0) vcvs gain=-5.555702330196e-01
SMIXQ_c022_0_09 (mix_q_src_c022_0_09 mix_q_c022_0 win_0_09 0) relay vt1=-1m vt2=1m ropen=ropen_mix rclosed=rclosed_mix
EMIXI_c022_0_10 (mix_i_src_c022_0_10 0 bpf_c022_0 0) vcvs gain=-5.555702330196e-01
SMIXI_c022_0_10 (mix_i_src_c022_0_10 mix_i_c022_0 win_0_10 0) relay vt1=-1m vt2=1m ropen=ropen_mix rclosed=rclosed_mix
EMIXQ_c022_0_10 (mix_q_src_c022_0_10 0 bpf_c022_0 0) vcvs gain=-8.314696123025e-01
SMIXQ_c022_0_10 (mix_q_src_c022_0_10 mix_q_c022_0 win_0_10 0) relay vt1=-1m vt2=1m ropen=ropen_mix rclosed=rclosed_mix
EMIXI_c022_0_11 (mix_i_src_c022_0_11 0 bpf_c022_0 0) vcvs gain=-1.950903220161e-01
SMIXI_c022_0_11 (mix_i_src_c022_0_11 mix_i_c022_0 win_0_11 0) relay vt1=-1m vt2=1m ropen=ropen_mix rclosed=rclosed_mix
EMIXQ_c022_0_11 (mix_q_src_c022_0_11 0 bpf_c022_0 0) vcvs gain=-9.807852804032e-01
SMIXQ_c022_0_11 (mix_q_src_c022_0_11 mix_q_c022_0 win_0_11 0) relay vt1=-1m vt2=1m ropen=ropen_mix rclosed=rclosed_mix
EMIXI_c022_0_12 (mix_i_src_c022_0_12 0 bpf_c022_0 0) vcvs gain=1.950903220161e-01
SMIXI_c022_0_12 (mix_i_src_c022_0_12 mix_i_c022_0 win_0_12 0) relay vt1=-1m vt2=1m ropen=ropen_mix rclosed=rclosed_mix
EMIXQ_c022_0_12 (mix_q_src_c022_0_12 0 bpf_c022_0 0) vcvs gain=-9.807852804032e-01
SMIXQ_c022_0_12 (mix_q_src_c022_0_12 mix_q_c022_0 win_0_12 0) relay vt1=-1m vt2=1m ropen=ropen_mix rclosed=rclosed_mix
EMIXI_c022_0_13 (mix_i_src_c022_0_13 0 bpf_c022_0 0) vcvs gain=5.555702330196e-01
SMIXI_c022_0_13 (mix_i_src_c022_0_13 mix_i_c022_0 win_0_13 0) relay vt1=-1m vt2=1m ropen=ropen_mix rclosed=rclosed_mix
EMIXQ_c022_0_13 (mix_q_src_c022_0_13 0 bpf_c022_0 0) vcvs gain=-8.314696123025e-01
SMIXQ_c022_0_13 (mix_q_src_c022_0_13 mix_q_c022_0 win_0_13 0) relay vt1=-1m vt2=1m ropen=ropen_mix rclosed=rclosed_mix
EMIXI_c022_0_14 (mix_i_src_c022_0_14 0 bpf_c022_0 0) vcvs gain=8.314696123025e-01
SMIXI_c022_0_14 (mix_i_src_c022_0_14 mix_i_c022_0 win_0_14 0) relay vt1=-1m vt2=1m ropen=ropen_mix rclosed=rclosed_mix
EMIXQ_c022_0_14 (mix_q_src_c022_0_14 0 bpf_c022_0 0) vcvs gain=-5.555702330196e-01
SMIXQ_c022_0_14 (mix_q_src_c022_0_14 mix_q_c022_0 win_0_14 0) relay vt1=-1m vt2=1m ropen=ropen_mix rclosed=rclosed_mix
EMIXI_c022_0_15 (mix_i_src_c022_0_15 0 bpf_c022_0 0) vcvs gain=9.807852804032e-01
SMIXI_c022_0_15 (mix_i_src_c022_0_15 mix_i_c022_0 win_0_15 0) relay vt1=-1m vt2=1m ropen=ropen_mix rclosed=rclosed_mix
EMIXQ_c022_0_15 (mix_q_src_c022_0_15 0 bpf_c022_0 0) vcvs gain=-1.950903220161e-01
SMIXQ_c022_0_15 (mix_q_src_c022_0_15 mix_q_c022_0 win_0_15 0) relay vt1=-1m vt2=1m ropen=ropen_mix rclosed=rclosed_mix
RMIXI_c022_0 (mix_i_c022_0 0) resistor r=1G
RMIXQ_c022_0 (mix_q_c022_0 0) resistor r=1G
RINTI_c022_0 (mix_i_c022_0 Icar_c022_0) resistor r=1k
CINTI_c022_0 (Icar_c022_0 0) capacitor c=80p
RINTQ_c022_0 (mix_q_c022_0 Qcar_c022_0) resistor r=1k
CINTQ_c022_0 (Qcar_c022_0 0) capacitor c=80p
save bpf_c022_0 Icar_c022_0 Qcar_c022_0

// bl022, carrier_1: 500000000 Hz coherent I/Q phase-window verification-demod path
CBPF_c022_1 (bl022 n_cbpf_c022_1) capacitor c=1.013211836423e-13
LBPF_c022_1 (n_cbpf_c022_1 bpf_c022_1) inductor l=1.000000000000e-06
RBPF_c022_1 (bpf_c022_1 0) resistor r=1.570796326795e+02
EMIXI_c022_1_00 (mix_i_src_c022_1_00 0 bpf_c022_1 0) vcvs gain=9.807852804032e-01
SMIXI_c022_1_00 (mix_i_src_c022_1_00 mix_i_c022_1 win_1_00 0) relay vt1=-1m vt2=1m ropen=ropen_mix rclosed=rclosed_mix
EMIXQ_c022_1_00 (mix_q_src_c022_1_00 0 bpf_c022_1 0) vcvs gain=1.950903220161e-01
SMIXQ_c022_1_00 (mix_q_src_c022_1_00 mix_q_c022_1 win_1_00 0) relay vt1=-1m vt2=1m ropen=ropen_mix rclosed=rclosed_mix
EMIXI_c022_1_01 (mix_i_src_c022_1_01 0 bpf_c022_1 0) vcvs gain=8.314696123025e-01
SMIXI_c022_1_01 (mix_i_src_c022_1_01 mix_i_c022_1 win_1_01 0) relay vt1=-1m vt2=1m ropen=ropen_mix rclosed=rclosed_mix
EMIXQ_c022_1_01 (mix_q_src_c022_1_01 0 bpf_c022_1 0) vcvs gain=5.555702330196e-01
SMIXQ_c022_1_01 (mix_q_src_c022_1_01 mix_q_c022_1 win_1_01 0) relay vt1=-1m vt2=1m ropen=ropen_mix rclosed=rclosed_mix
EMIXI_c022_1_02 (mix_i_src_c022_1_02 0 bpf_c022_1 0) vcvs gain=5.555702330196e-01
SMIXI_c022_1_02 (mix_i_src_c022_1_02 mix_i_c022_1 win_1_02 0) relay vt1=-1m vt2=1m ropen=ropen_mix rclosed=rclosed_mix
EMIXQ_c022_1_02 (mix_q_src_c022_1_02 0 bpf_c022_1 0) vcvs gain=8.314696123025e-01
SMIXQ_c022_1_02 (mix_q_src_c022_1_02 mix_q_c022_1 win_1_02 0) relay vt1=-1m vt2=1m ropen=ropen_mix rclosed=rclosed_mix
EMIXI_c022_1_03 (mix_i_src_c022_1_03 0 bpf_c022_1 0) vcvs gain=1.950903220161e-01
SMIXI_c022_1_03 (mix_i_src_c022_1_03 mix_i_c022_1 win_1_03 0) relay vt1=-1m vt2=1m ropen=ropen_mix rclosed=rclosed_mix
EMIXQ_c022_1_03 (mix_q_src_c022_1_03 0 bpf_c022_1 0) vcvs gain=9.807852804032e-01
SMIXQ_c022_1_03 (mix_q_src_c022_1_03 mix_q_c022_1 win_1_03 0) relay vt1=-1m vt2=1m ropen=ropen_mix rclosed=rclosed_mix
EMIXI_c022_1_04 (mix_i_src_c022_1_04 0 bpf_c022_1 0) vcvs gain=-1.950903220161e-01
SMIXI_c022_1_04 (mix_i_src_c022_1_04 mix_i_c022_1 win_1_04 0) relay vt1=-1m vt2=1m ropen=ropen_mix rclosed=rclosed_mix
EMIXQ_c022_1_04 (mix_q_src_c022_1_04 0 bpf_c022_1 0) vcvs gain=9.807852804032e-01
SMIXQ_c022_1_04 (mix_q_src_c022_1_04 mix_q_c022_1 win_1_04 0) relay vt1=-1m vt2=1m ropen=ropen_mix rclosed=rclosed_mix
EMIXI_c022_1_05 (mix_i_src_c022_1_05 0 bpf_c022_1 0) vcvs gain=-5.555702330196e-01
SMIXI_c022_1_05 (mix_i_src_c022_1_05 mix_i_c022_1 win_1_05 0) relay vt1=-1m vt2=1m ropen=ropen_mix rclosed=rclosed_mix
EMIXQ_c022_1_05 (mix_q_src_c022_1_05 0 bpf_c022_1 0) vcvs gain=8.314696123025e-01
SMIXQ_c022_1_05 (mix_q_src_c022_1_05 mix_q_c022_1 win_1_05 0) relay vt1=-1m vt2=1m ropen=ropen_mix rclosed=rclosed_mix
EMIXI_c022_1_06 (mix_i_src_c022_1_06 0 bpf_c022_1 0) vcvs gain=-8.314696123025e-01
SMIXI_c022_1_06 (mix_i_src_c022_1_06 mix_i_c022_1 win_1_06 0) relay vt1=-1m vt2=1m ropen=ropen_mix rclosed=rclosed_mix
EMIXQ_c022_1_06 (mix_q_src_c022_1_06 0 bpf_c022_1 0) vcvs gain=5.555702330196e-01
SMIXQ_c022_1_06 (mix_q_src_c022_1_06 mix_q_c022_1 win_1_06 0) relay vt1=-1m vt2=1m ropen=ropen_mix rclosed=rclosed_mix
EMIXI_c022_1_07 (mix_i_src_c022_1_07 0 bpf_c022_1 0) vcvs gain=-9.807852804032e-01
SMIXI_c022_1_07 (mix_i_src_c022_1_07 mix_i_c022_1 win_1_07 0) relay vt1=-1m vt2=1m ropen=ropen_mix rclosed=rclosed_mix
EMIXQ_c022_1_07 (mix_q_src_c022_1_07 0 bpf_c022_1 0) vcvs gain=1.950903220161e-01
SMIXQ_c022_1_07 (mix_q_src_c022_1_07 mix_q_c022_1 win_1_07 0) relay vt1=-1m vt2=1m ropen=ropen_mix rclosed=rclosed_mix
EMIXI_c022_1_08 (mix_i_src_c022_1_08 0 bpf_c022_1 0) vcvs gain=-9.807852804032e-01
SMIXI_c022_1_08 (mix_i_src_c022_1_08 mix_i_c022_1 win_1_08 0) relay vt1=-1m vt2=1m ropen=ropen_mix rclosed=rclosed_mix
EMIXQ_c022_1_08 (mix_q_src_c022_1_08 0 bpf_c022_1 0) vcvs gain=-1.950903220161e-01
SMIXQ_c022_1_08 (mix_q_src_c022_1_08 mix_q_c022_1 win_1_08 0) relay vt1=-1m vt2=1m ropen=ropen_mix rclosed=rclosed_mix
EMIXI_c022_1_09 (mix_i_src_c022_1_09 0 bpf_c022_1 0) vcvs gain=-8.314696123025e-01
SMIXI_c022_1_09 (mix_i_src_c022_1_09 mix_i_c022_1 win_1_09 0) relay vt1=-1m vt2=1m ropen=ropen_mix rclosed=rclosed_mix
EMIXQ_c022_1_09 (mix_q_src_c022_1_09 0 bpf_c022_1 0) vcvs gain=-5.555702330196e-01
SMIXQ_c022_1_09 (mix_q_src_c022_1_09 mix_q_c022_1 win_1_09 0) relay vt1=-1m vt2=1m ropen=ropen_mix rclosed=rclosed_mix
EMIXI_c022_1_10 (mix_i_src_c022_1_10 0 bpf_c022_1 0) vcvs gain=-5.555702330196e-01
SMIXI_c022_1_10 (mix_i_src_c022_1_10 mix_i_c022_1 win_1_10 0) relay vt1=-1m vt2=1m ropen=ropen_mix rclosed=rclosed_mix
EMIXQ_c022_1_10 (mix_q_src_c022_1_10 0 bpf_c022_1 0) vcvs gain=-8.314696123025e-01
SMIXQ_c022_1_10 (mix_q_src_c022_1_10 mix_q_c022_1 win_1_10 0) relay vt1=-1m vt2=1m ropen=ropen_mix rclosed=rclosed_mix
EMIXI_c022_1_11 (mix_i_src_c022_1_11 0 bpf_c022_1 0) vcvs gain=-1.950903220161e-01
SMIXI_c022_1_11 (mix_i_src_c022_1_11 mix_i_c022_1 win_1_11 0) relay vt1=-1m vt2=1m ropen=ropen_mix rclosed=rclosed_mix
EMIXQ_c022_1_11 (mix_q_src_c022_1_11 0 bpf_c022_1 0) vcvs gain=-9.807852804032e-01
SMIXQ_c022_1_11 (mix_q_src_c022_1_11 mix_q_c022_1 win_1_11 0) relay vt1=-1m vt2=1m ropen=ropen_mix rclosed=rclosed_mix
EMIXI_c022_1_12 (mix_i_src_c022_1_12 0 bpf_c022_1 0) vcvs gain=1.950903220161e-01
SMIXI_c022_1_12 (mix_i_src_c022_1_12 mix_i_c022_1 win_1_12 0) relay vt1=-1m vt2=1m ropen=ropen_mix rclosed=rclosed_mix
EMIXQ_c022_1_12 (mix_q_src_c022_1_12 0 bpf_c022_1 0) vcvs gain=-9.807852804032e-01
SMIXQ_c022_1_12 (mix_q_src_c022_1_12 mix_q_c022_1 win_1_12 0) relay vt1=-1m vt2=1m ropen=ropen_mix rclosed=rclosed_mix
EMIXI_c022_1_13 (mix_i_src_c022_1_13 0 bpf_c022_1 0) vcvs gain=5.555702330196e-01
SMIXI_c022_1_13 (mix_i_src_c022_1_13 mix_i_c022_1 win_1_13 0) relay vt1=-1m vt2=1m ropen=ropen_mix rclosed=rclosed_mix
EMIXQ_c022_1_13 (mix_q_src_c022_1_13 0 bpf_c022_1 0) vcvs gain=-8.314696123025e-01
SMIXQ_c022_1_13 (mix_q_src_c022_1_13 mix_q_c022_1 win_1_13 0) relay vt1=-1m vt2=1m ropen=ropen_mix rclosed=rclosed_mix
EMIXI_c022_1_14 (mix_i_src_c022_1_14 0 bpf_c022_1 0) vcvs gain=8.314696123025e-01
SMIXI_c022_1_14 (mix_i_src_c022_1_14 mix_i_c022_1 win_1_14 0) relay vt1=-1m vt2=1m ropen=ropen_mix rclosed=rclosed_mix
EMIXQ_c022_1_14 (mix_q_src_c022_1_14 0 bpf_c022_1 0) vcvs gain=-5.555702330196e-01
SMIXQ_c022_1_14 (mix_q_src_c022_1_14 mix_q_c022_1 win_1_14 0) relay vt1=-1m vt2=1m ropen=ropen_mix rclosed=rclosed_mix
EMIXI_c022_1_15 (mix_i_src_c022_1_15 0 bpf_c022_1 0) vcvs gain=9.807852804032e-01
SMIXI_c022_1_15 (mix_i_src_c022_1_15 mix_i_c022_1 win_1_15 0) relay vt1=-1m vt2=1m ropen=ropen_mix rclosed=rclosed_mix
EMIXQ_c022_1_15 (mix_q_src_c022_1_15 0 bpf_c022_1 0) vcvs gain=-1.950903220161e-01
SMIXQ_c022_1_15 (mix_q_src_c022_1_15 mix_q_c022_1 win_1_15 0) relay vt1=-1m vt2=1m ropen=ropen_mix rclosed=rclosed_mix
RMIXI_c022_1 (mix_i_c022_1 0) resistor r=1G
RMIXQ_c022_1 (mix_q_c022_1 0) resistor r=1G
RINTI_c022_1 (mix_i_c022_1 Icar_c022_1) resistor r=1k
CINTI_c022_1 (Icar_c022_1 0) capacitor c=80p
RINTQ_c022_1 (mix_q_c022_1 Qcar_c022_1) resistor r=1k
CINTQ_c022_1 (Qcar_c022_1 0) capacitor c=80p
save bpf_c022_1 Icar_c022_1 Qcar_c022_1

// bl022, carrier_2: 750000000 Hz coherent I/Q phase-window verification-demod path
CBPF_c022_2 (bl022 n_cbpf_c022_2) capacitor c=4.503163717437e-14
LBPF_c022_2 (n_cbpf_c022_2 bpf_c022_2) inductor l=1.000000000000e-06
RBPF_c022_2 (bpf_c022_2 0) resistor r=2.356194490192e+02
EMIXI_c022_2_00 (mix_i_src_c022_2_00 0 bpf_c022_2 0) vcvs gain=9.807852804032e-01
SMIXI_c022_2_00 (mix_i_src_c022_2_00 mix_i_c022_2 win_2_00 0) relay vt1=-1m vt2=1m ropen=ropen_mix rclosed=rclosed_mix
EMIXQ_c022_2_00 (mix_q_src_c022_2_00 0 bpf_c022_2 0) vcvs gain=1.950903220161e-01
SMIXQ_c022_2_00 (mix_q_src_c022_2_00 mix_q_c022_2 win_2_00 0) relay vt1=-1m vt2=1m ropen=ropen_mix rclosed=rclosed_mix
EMIXI_c022_2_01 (mix_i_src_c022_2_01 0 bpf_c022_2 0) vcvs gain=8.314696123025e-01
SMIXI_c022_2_01 (mix_i_src_c022_2_01 mix_i_c022_2 win_2_01 0) relay vt1=-1m vt2=1m ropen=ropen_mix rclosed=rclosed_mix
EMIXQ_c022_2_01 (mix_q_src_c022_2_01 0 bpf_c022_2 0) vcvs gain=5.555702330196e-01
SMIXQ_c022_2_01 (mix_q_src_c022_2_01 mix_q_c022_2 win_2_01 0) relay vt1=-1m vt2=1m ropen=ropen_mix rclosed=rclosed_mix
EMIXI_c022_2_02 (mix_i_src_c022_2_02 0 bpf_c022_2 0) vcvs gain=5.555702330196e-01
SMIXI_c022_2_02 (mix_i_src_c022_2_02 mix_i_c022_2 win_2_02 0) relay vt1=-1m vt2=1m ropen=ropen_mix rclosed=rclosed_mix
EMIXQ_c022_2_02 (mix_q_src_c022_2_02 0 bpf_c022_2 0) vcvs gain=8.314696123025e-01
SMIXQ_c022_2_02 (mix_q_src_c022_2_02 mix_q_c022_2 win_2_02 0) relay vt1=-1m vt2=1m ropen=ropen_mix rclosed=rclosed_mix
EMIXI_c022_2_03 (mix_i_src_c022_2_03 0 bpf_c022_2 0) vcvs gain=1.950903220161e-01
SMIXI_c022_2_03 (mix_i_src_c022_2_03 mix_i_c022_2 win_2_03 0) relay vt1=-1m vt2=1m ropen=ropen_mix rclosed=rclosed_mix
EMIXQ_c022_2_03 (mix_q_src_c022_2_03 0 bpf_c022_2 0) vcvs gain=9.807852804032e-01
SMIXQ_c022_2_03 (mix_q_src_c022_2_03 mix_q_c022_2 win_2_03 0) relay vt1=-1m vt2=1m ropen=ropen_mix rclosed=rclosed_mix
EMIXI_c022_2_04 (mix_i_src_c022_2_04 0 bpf_c022_2 0) vcvs gain=-1.950903220161e-01
SMIXI_c022_2_04 (mix_i_src_c022_2_04 mix_i_c022_2 win_2_04 0) relay vt1=-1m vt2=1m ropen=ropen_mix rclosed=rclosed_mix
EMIXQ_c022_2_04 (mix_q_src_c022_2_04 0 bpf_c022_2 0) vcvs gain=9.807852804032e-01
SMIXQ_c022_2_04 (mix_q_src_c022_2_04 mix_q_c022_2 win_2_04 0) relay vt1=-1m vt2=1m ropen=ropen_mix rclosed=rclosed_mix
EMIXI_c022_2_05 (mix_i_src_c022_2_05 0 bpf_c022_2 0) vcvs gain=-5.555702330196e-01
SMIXI_c022_2_05 (mix_i_src_c022_2_05 mix_i_c022_2 win_2_05 0) relay vt1=-1m vt2=1m ropen=ropen_mix rclosed=rclosed_mix
EMIXQ_c022_2_05 (mix_q_src_c022_2_05 0 bpf_c022_2 0) vcvs gain=8.314696123025e-01
SMIXQ_c022_2_05 (mix_q_src_c022_2_05 mix_q_c022_2 win_2_05 0) relay vt1=-1m vt2=1m ropen=ropen_mix rclosed=rclosed_mix
EMIXI_c022_2_06 (mix_i_src_c022_2_06 0 bpf_c022_2 0) vcvs gain=-8.314696123025e-01
SMIXI_c022_2_06 (mix_i_src_c022_2_06 mix_i_c022_2 win_2_06 0) relay vt1=-1m vt2=1m ropen=ropen_mix rclosed=rclosed_mix
EMIXQ_c022_2_06 (mix_q_src_c022_2_06 0 bpf_c022_2 0) vcvs gain=5.555702330196e-01
SMIXQ_c022_2_06 (mix_q_src_c022_2_06 mix_q_c022_2 win_2_06 0) relay vt1=-1m vt2=1m ropen=ropen_mix rclosed=rclosed_mix
EMIXI_c022_2_07 (mix_i_src_c022_2_07 0 bpf_c022_2 0) vcvs gain=-9.807852804032e-01
SMIXI_c022_2_07 (mix_i_src_c022_2_07 mix_i_c022_2 win_2_07 0) relay vt1=-1m vt2=1m ropen=ropen_mix rclosed=rclosed_mix
EMIXQ_c022_2_07 (mix_q_src_c022_2_07 0 bpf_c022_2 0) vcvs gain=1.950903220161e-01
SMIXQ_c022_2_07 (mix_q_src_c022_2_07 mix_q_c022_2 win_2_07 0) relay vt1=-1m vt2=1m ropen=ropen_mix rclosed=rclosed_mix
EMIXI_c022_2_08 (mix_i_src_c022_2_08 0 bpf_c022_2 0) vcvs gain=-9.807852804032e-01
SMIXI_c022_2_08 (mix_i_src_c022_2_08 mix_i_c022_2 win_2_08 0) relay vt1=-1m vt2=1m ropen=ropen_mix rclosed=rclosed_mix
EMIXQ_c022_2_08 (mix_q_src_c022_2_08 0 bpf_c022_2 0) vcvs gain=-1.950903220161e-01
SMIXQ_c022_2_08 (mix_q_src_c022_2_08 mix_q_c022_2 win_2_08 0) relay vt1=-1m vt2=1m ropen=ropen_mix rclosed=rclosed_mix
EMIXI_c022_2_09 (mix_i_src_c022_2_09 0 bpf_c022_2 0) vcvs gain=-8.314696123025e-01
SMIXI_c022_2_09 (mix_i_src_c022_2_09 mix_i_c022_2 win_2_09 0) relay vt1=-1m vt2=1m ropen=ropen_mix rclosed=rclosed_mix
EMIXQ_c022_2_09 (mix_q_src_c022_2_09 0 bpf_c022_2 0) vcvs gain=-5.555702330196e-01
SMIXQ_c022_2_09 (mix_q_src_c022_2_09 mix_q_c022_2 win_2_09 0) relay vt1=-1m vt2=1m ropen=ropen_mix rclosed=rclosed_mix
EMIXI_c022_2_10 (mix_i_src_c022_2_10 0 bpf_c022_2 0) vcvs gain=-5.555702330196e-01
SMIXI_c022_2_10 (mix_i_src_c022_2_10 mix_i_c022_2 win_2_10 0) relay vt1=-1m vt2=1m ropen=ropen_mix rclosed=rclosed_mix
EMIXQ_c022_2_10 (mix_q_src_c022_2_10 0 bpf_c022_2 0) vcvs gain=-8.314696123025e-01
SMIXQ_c022_2_10 (mix_q_src_c022_2_10 mix_q_c022_2 win_2_10 0) relay vt1=-1m vt2=1m ropen=ropen_mix rclosed=rclosed_mix
EMIXI_c022_2_11 (mix_i_src_c022_2_11 0 bpf_c022_2 0) vcvs gain=-1.950903220161e-01
SMIXI_c022_2_11 (mix_i_src_c022_2_11 mix_i_c022_2 win_2_11 0) relay vt1=-1m vt2=1m ropen=ropen_mix rclosed=rclosed_mix
EMIXQ_c022_2_11 (mix_q_src_c022_2_11 0 bpf_c022_2 0) vcvs gain=-9.807852804032e-01
SMIXQ_c022_2_11 (mix_q_src_c022_2_11 mix_q_c022_2 win_2_11 0) relay vt1=-1m vt2=1m ropen=ropen_mix rclosed=rclosed_mix
EMIXI_c022_2_12 (mix_i_src_c022_2_12 0 bpf_c022_2 0) vcvs gain=1.950903220161e-01
SMIXI_c022_2_12 (mix_i_src_c022_2_12 mix_i_c022_2 win_2_12 0) relay vt1=-1m vt2=1m ropen=ropen_mix rclosed=rclosed_mix
EMIXQ_c022_2_12 (mix_q_src_c022_2_12 0 bpf_c022_2 0) vcvs gain=-9.807852804032e-01
SMIXQ_c022_2_12 (mix_q_src_c022_2_12 mix_q_c022_2 win_2_12 0) relay vt1=-1m vt2=1m ropen=ropen_mix rclosed=rclosed_mix
EMIXI_c022_2_13 (mix_i_src_c022_2_13 0 bpf_c022_2 0) vcvs gain=5.555702330196e-01
SMIXI_c022_2_13 (mix_i_src_c022_2_13 mix_i_c022_2 win_2_13 0) relay vt1=-1m vt2=1m ropen=ropen_mix rclosed=rclosed_mix
EMIXQ_c022_2_13 (mix_q_src_c022_2_13 0 bpf_c022_2 0) vcvs gain=-8.314696123025e-01
SMIXQ_c022_2_13 (mix_q_src_c022_2_13 mix_q_c022_2 win_2_13 0) relay vt1=-1m vt2=1m ropen=ropen_mix rclosed=rclosed_mix
EMIXI_c022_2_14 (mix_i_src_c022_2_14 0 bpf_c022_2 0) vcvs gain=8.314696123025e-01
SMIXI_c022_2_14 (mix_i_src_c022_2_14 mix_i_c022_2 win_2_14 0) relay vt1=-1m vt2=1m ropen=ropen_mix rclosed=rclosed_mix
EMIXQ_c022_2_14 (mix_q_src_c022_2_14 0 bpf_c022_2 0) vcvs gain=-5.555702330196e-01
SMIXQ_c022_2_14 (mix_q_src_c022_2_14 mix_q_c022_2 win_2_14 0) relay vt1=-1m vt2=1m ropen=ropen_mix rclosed=rclosed_mix
EMIXI_c022_2_15 (mix_i_src_c022_2_15 0 bpf_c022_2 0) vcvs gain=9.807852804032e-01
SMIXI_c022_2_15 (mix_i_src_c022_2_15 mix_i_c022_2 win_2_15 0) relay vt1=-1m vt2=1m ropen=ropen_mix rclosed=rclosed_mix
EMIXQ_c022_2_15 (mix_q_src_c022_2_15 0 bpf_c022_2 0) vcvs gain=-1.950903220161e-01
SMIXQ_c022_2_15 (mix_q_src_c022_2_15 mix_q_c022_2 win_2_15 0) relay vt1=-1m vt2=1m ropen=ropen_mix rclosed=rclosed_mix
RMIXI_c022_2 (mix_i_c022_2 0) resistor r=1G
RMIXQ_c022_2 (mix_q_c022_2 0) resistor r=1G
RINTI_c022_2 (mix_i_c022_2 Icar_c022_2) resistor r=1k
CINTI_c022_2 (Icar_c022_2 0) capacitor c=80p
RINTQ_c022_2 (mix_q_c022_2 Qcar_c022_2) resistor r=1k
CINTQ_c022_2 (Qcar_c022_2 0) capacitor c=80p
save bpf_c022_2 Icar_c022_2 Qcar_c022_2

// bl022, carrier_3: 1000000000 Hz coherent I/Q phase-window verification-demod path
CBPF_c022_3 (bl022 n_cbpf_c022_3) capacitor c=2.533029591058e-14
LBPF_c022_3 (n_cbpf_c022_3 bpf_c022_3) inductor l=1.000000000000e-06
RBPF_c022_3 (bpf_c022_3 0) resistor r=3.141592653590e+02
EMIXI_c022_3_00 (mix_i_src_c022_3_00 0 bpf_c022_3 0) vcvs gain=9.807852804032e-01
SMIXI_c022_3_00 (mix_i_src_c022_3_00 mix_i_c022_3 win_3_00 0) relay vt1=-1m vt2=1m ropen=ropen_mix rclosed=rclosed_mix
EMIXQ_c022_3_00 (mix_q_src_c022_3_00 0 bpf_c022_3 0) vcvs gain=1.950903220161e-01
SMIXQ_c022_3_00 (mix_q_src_c022_3_00 mix_q_c022_3 win_3_00 0) relay vt1=-1m vt2=1m ropen=ropen_mix rclosed=rclosed_mix
EMIXI_c022_3_01 (mix_i_src_c022_3_01 0 bpf_c022_3 0) vcvs gain=8.314696123025e-01
SMIXI_c022_3_01 (mix_i_src_c022_3_01 mix_i_c022_3 win_3_01 0) relay vt1=-1m vt2=1m ropen=ropen_mix rclosed=rclosed_mix
EMIXQ_c022_3_01 (mix_q_src_c022_3_01 0 bpf_c022_3 0) vcvs gain=5.555702330196e-01
SMIXQ_c022_3_01 (mix_q_src_c022_3_01 mix_q_c022_3 win_3_01 0) relay vt1=-1m vt2=1m ropen=ropen_mix rclosed=rclosed_mix
EMIXI_c022_3_02 (mix_i_src_c022_3_02 0 bpf_c022_3 0) vcvs gain=5.555702330196e-01
SMIXI_c022_3_02 (mix_i_src_c022_3_02 mix_i_c022_3 win_3_02 0) relay vt1=-1m vt2=1m ropen=ropen_mix rclosed=rclosed_mix
EMIXQ_c022_3_02 (mix_q_src_c022_3_02 0 bpf_c022_3 0) vcvs gain=8.314696123025e-01
SMIXQ_c022_3_02 (mix_q_src_c022_3_02 mix_q_c022_3 win_3_02 0) relay vt1=-1m vt2=1m ropen=ropen_mix rclosed=rclosed_mix
EMIXI_c022_3_03 (mix_i_src_c022_3_03 0 bpf_c022_3 0) vcvs gain=1.950903220161e-01
SMIXI_c022_3_03 (mix_i_src_c022_3_03 mix_i_c022_3 win_3_03 0) relay vt1=-1m vt2=1m ropen=ropen_mix rclosed=rclosed_mix
EMIXQ_c022_3_03 (mix_q_src_c022_3_03 0 bpf_c022_3 0) vcvs gain=9.807852804032e-01
SMIXQ_c022_3_03 (mix_q_src_c022_3_03 mix_q_c022_3 win_3_03 0) relay vt1=-1m vt2=1m ropen=ropen_mix rclosed=rclosed_mix
EMIXI_c022_3_04 (mix_i_src_c022_3_04 0 bpf_c022_3 0) vcvs gain=-1.950903220161e-01
SMIXI_c022_3_04 (mix_i_src_c022_3_04 mix_i_c022_3 win_3_04 0) relay vt1=-1m vt2=1m ropen=ropen_mix rclosed=rclosed_mix
EMIXQ_c022_3_04 (mix_q_src_c022_3_04 0 bpf_c022_3 0) vcvs gain=9.807852804032e-01
SMIXQ_c022_3_04 (mix_q_src_c022_3_04 mix_q_c022_3 win_3_04 0) relay vt1=-1m vt2=1m ropen=ropen_mix rclosed=rclosed_mix
EMIXI_c022_3_05 (mix_i_src_c022_3_05 0 bpf_c022_3 0) vcvs gain=-5.555702330196e-01
SMIXI_c022_3_05 (mix_i_src_c022_3_05 mix_i_c022_3 win_3_05 0) relay vt1=-1m vt2=1m ropen=ropen_mix rclosed=rclosed_mix
EMIXQ_c022_3_05 (mix_q_src_c022_3_05 0 bpf_c022_3 0) vcvs gain=8.314696123025e-01
SMIXQ_c022_3_05 (mix_q_src_c022_3_05 mix_q_c022_3 win_3_05 0) relay vt1=-1m vt2=1m ropen=ropen_mix rclosed=rclosed_mix
EMIXI_c022_3_06 (mix_i_src_c022_3_06 0 bpf_c022_3 0) vcvs gain=-8.314696123025e-01
SMIXI_c022_3_06 (mix_i_src_c022_3_06 mix_i_c022_3 win_3_06 0) relay vt1=-1m vt2=1m ropen=ropen_mix rclosed=rclosed_mix
EMIXQ_c022_3_06 (mix_q_src_c022_3_06 0 bpf_c022_3 0) vcvs gain=5.555702330196e-01
SMIXQ_c022_3_06 (mix_q_src_c022_3_06 mix_q_c022_3 win_3_06 0) relay vt1=-1m vt2=1m ropen=ropen_mix rclosed=rclosed_mix
EMIXI_c022_3_07 (mix_i_src_c022_3_07 0 bpf_c022_3 0) vcvs gain=-9.807852804032e-01
SMIXI_c022_3_07 (mix_i_src_c022_3_07 mix_i_c022_3 win_3_07 0) relay vt1=-1m vt2=1m ropen=ropen_mix rclosed=rclosed_mix
EMIXQ_c022_3_07 (mix_q_src_c022_3_07 0 bpf_c022_3 0) vcvs gain=1.950903220161e-01
SMIXQ_c022_3_07 (mix_q_src_c022_3_07 mix_q_c022_3 win_3_07 0) relay vt1=-1m vt2=1m ropen=ropen_mix rclosed=rclosed_mix
EMIXI_c022_3_08 (mix_i_src_c022_3_08 0 bpf_c022_3 0) vcvs gain=-9.807852804032e-01
SMIXI_c022_3_08 (mix_i_src_c022_3_08 mix_i_c022_3 win_3_08 0) relay vt1=-1m vt2=1m ropen=ropen_mix rclosed=rclosed_mix
EMIXQ_c022_3_08 (mix_q_src_c022_3_08 0 bpf_c022_3 0) vcvs gain=-1.950903220161e-01
SMIXQ_c022_3_08 (mix_q_src_c022_3_08 mix_q_c022_3 win_3_08 0) relay vt1=-1m vt2=1m ropen=ropen_mix rclosed=rclosed_mix
EMIXI_c022_3_09 (mix_i_src_c022_3_09 0 bpf_c022_3 0) vcvs gain=-8.314696123025e-01
SMIXI_c022_3_09 (mix_i_src_c022_3_09 mix_i_c022_3 win_3_09 0) relay vt1=-1m vt2=1m ropen=ropen_mix rclosed=rclosed_mix
EMIXQ_c022_3_09 (mix_q_src_c022_3_09 0 bpf_c022_3 0) vcvs gain=-5.555702330196e-01
SMIXQ_c022_3_09 (mix_q_src_c022_3_09 mix_q_c022_3 win_3_09 0) relay vt1=-1m vt2=1m ropen=ropen_mix rclosed=rclosed_mix
EMIXI_c022_3_10 (mix_i_src_c022_3_10 0 bpf_c022_3 0) vcvs gain=-5.555702330196e-01
SMIXI_c022_3_10 (mix_i_src_c022_3_10 mix_i_c022_3 win_3_10 0) relay vt1=-1m vt2=1m ropen=ropen_mix rclosed=rclosed_mix
EMIXQ_c022_3_10 (mix_q_src_c022_3_10 0 bpf_c022_3 0) vcvs gain=-8.314696123025e-01
SMIXQ_c022_3_10 (mix_q_src_c022_3_10 mix_q_c022_3 win_3_10 0) relay vt1=-1m vt2=1m ropen=ropen_mix rclosed=rclosed_mix
EMIXI_c022_3_11 (mix_i_src_c022_3_11 0 bpf_c022_3 0) vcvs gain=-1.950903220161e-01
SMIXI_c022_3_11 (mix_i_src_c022_3_11 mix_i_c022_3 win_3_11 0) relay vt1=-1m vt2=1m ropen=ropen_mix rclosed=rclosed_mix
EMIXQ_c022_3_11 (mix_q_src_c022_3_11 0 bpf_c022_3 0) vcvs gain=-9.807852804032e-01
SMIXQ_c022_3_11 (mix_q_src_c022_3_11 mix_q_c022_3 win_3_11 0) relay vt1=-1m vt2=1m ropen=ropen_mix rclosed=rclosed_mix
EMIXI_c022_3_12 (mix_i_src_c022_3_12 0 bpf_c022_3 0) vcvs gain=1.950903220161e-01
SMIXI_c022_3_12 (mix_i_src_c022_3_12 mix_i_c022_3 win_3_12 0) relay vt1=-1m vt2=1m ropen=ropen_mix rclosed=rclosed_mix
EMIXQ_c022_3_12 (mix_q_src_c022_3_12 0 bpf_c022_3 0) vcvs gain=-9.807852804032e-01
SMIXQ_c022_3_12 (mix_q_src_c022_3_12 mix_q_c022_3 win_3_12 0) relay vt1=-1m vt2=1m ropen=ropen_mix rclosed=rclosed_mix
EMIXI_c022_3_13 (mix_i_src_c022_3_13 0 bpf_c022_3 0) vcvs gain=5.555702330196e-01
SMIXI_c022_3_13 (mix_i_src_c022_3_13 mix_i_c022_3 win_3_13 0) relay vt1=-1m vt2=1m ropen=ropen_mix rclosed=rclosed_mix
EMIXQ_c022_3_13 (mix_q_src_c022_3_13 0 bpf_c022_3 0) vcvs gain=-8.314696123025e-01
SMIXQ_c022_3_13 (mix_q_src_c022_3_13 mix_q_c022_3 win_3_13 0) relay vt1=-1m vt2=1m ropen=ropen_mix rclosed=rclosed_mix
EMIXI_c022_3_14 (mix_i_src_c022_3_14 0 bpf_c022_3 0) vcvs gain=8.314696123025e-01
SMIXI_c022_3_14 (mix_i_src_c022_3_14 mix_i_c022_3 win_3_14 0) relay vt1=-1m vt2=1m ropen=ropen_mix rclosed=rclosed_mix
EMIXQ_c022_3_14 (mix_q_src_c022_3_14 0 bpf_c022_3 0) vcvs gain=-5.555702330196e-01
SMIXQ_c022_3_14 (mix_q_src_c022_3_14 mix_q_c022_3 win_3_14 0) relay vt1=-1m vt2=1m ropen=ropen_mix rclosed=rclosed_mix
EMIXI_c022_3_15 (mix_i_src_c022_3_15 0 bpf_c022_3 0) vcvs gain=9.807852804032e-01
SMIXI_c022_3_15 (mix_i_src_c022_3_15 mix_i_c022_3 win_3_15 0) relay vt1=-1m vt2=1m ropen=ropen_mix rclosed=rclosed_mix
EMIXQ_c022_3_15 (mix_q_src_c022_3_15 0 bpf_c022_3 0) vcvs gain=-1.950903220161e-01
SMIXQ_c022_3_15 (mix_q_src_c022_3_15 mix_q_c022_3 win_3_15 0) relay vt1=-1m vt2=1m ropen=ropen_mix rclosed=rclosed_mix
RMIXI_c022_3 (mix_i_c022_3 0) resistor r=1G
RMIXQ_c022_3 (mix_q_c022_3 0) resistor r=1G
RINTI_c022_3 (mix_i_c022_3 Icar_c022_3) resistor r=1k
CINTI_c022_3 (Icar_c022_3 0) capacitor c=80p
RINTQ_c022_3 (mix_q_c022_3 Qcar_c022_3) resistor r=1k
CINTQ_c022_3 (Qcar_c022_3 0) capacitor c=80p
save bpf_c022_3 Icar_c022_3 Qcar_c022_3

// bl023, carrier_0: 250000000 Hz coherent I/Q phase-window verification-demod path
CBPF_c023_0 (bl023 n_cbpf_c023_0) capacitor c=4.052847345694e-13
LBPF_c023_0 (n_cbpf_c023_0 bpf_c023_0) inductor l=1.000000000000e-06
RBPF_c023_0 (bpf_c023_0 0) resistor r=7.853981633974e+01
EMIXI_c023_0_00 (mix_i_src_c023_0_00 0 bpf_c023_0 0) vcvs gain=9.807852804032e-01
SMIXI_c023_0_00 (mix_i_src_c023_0_00 mix_i_c023_0 win_0_00 0) relay vt1=-1m vt2=1m ropen=ropen_mix rclosed=rclosed_mix
EMIXQ_c023_0_00 (mix_q_src_c023_0_00 0 bpf_c023_0 0) vcvs gain=1.950903220161e-01
SMIXQ_c023_0_00 (mix_q_src_c023_0_00 mix_q_c023_0 win_0_00 0) relay vt1=-1m vt2=1m ropen=ropen_mix rclosed=rclosed_mix
EMIXI_c023_0_01 (mix_i_src_c023_0_01 0 bpf_c023_0 0) vcvs gain=8.314696123025e-01
SMIXI_c023_0_01 (mix_i_src_c023_0_01 mix_i_c023_0 win_0_01 0) relay vt1=-1m vt2=1m ropen=ropen_mix rclosed=rclosed_mix
EMIXQ_c023_0_01 (mix_q_src_c023_0_01 0 bpf_c023_0 0) vcvs gain=5.555702330196e-01
SMIXQ_c023_0_01 (mix_q_src_c023_0_01 mix_q_c023_0 win_0_01 0) relay vt1=-1m vt2=1m ropen=ropen_mix rclosed=rclosed_mix
EMIXI_c023_0_02 (mix_i_src_c023_0_02 0 bpf_c023_0 0) vcvs gain=5.555702330196e-01
SMIXI_c023_0_02 (mix_i_src_c023_0_02 mix_i_c023_0 win_0_02 0) relay vt1=-1m vt2=1m ropen=ropen_mix rclosed=rclosed_mix
EMIXQ_c023_0_02 (mix_q_src_c023_0_02 0 bpf_c023_0 0) vcvs gain=8.314696123025e-01
SMIXQ_c023_0_02 (mix_q_src_c023_0_02 mix_q_c023_0 win_0_02 0) relay vt1=-1m vt2=1m ropen=ropen_mix rclosed=rclosed_mix
EMIXI_c023_0_03 (mix_i_src_c023_0_03 0 bpf_c023_0 0) vcvs gain=1.950903220161e-01
SMIXI_c023_0_03 (mix_i_src_c023_0_03 mix_i_c023_0 win_0_03 0) relay vt1=-1m vt2=1m ropen=ropen_mix rclosed=rclosed_mix
EMIXQ_c023_0_03 (mix_q_src_c023_0_03 0 bpf_c023_0 0) vcvs gain=9.807852804032e-01
SMIXQ_c023_0_03 (mix_q_src_c023_0_03 mix_q_c023_0 win_0_03 0) relay vt1=-1m vt2=1m ropen=ropen_mix rclosed=rclosed_mix
EMIXI_c023_0_04 (mix_i_src_c023_0_04 0 bpf_c023_0 0) vcvs gain=-1.950903220161e-01
SMIXI_c023_0_04 (mix_i_src_c023_0_04 mix_i_c023_0 win_0_04 0) relay vt1=-1m vt2=1m ropen=ropen_mix rclosed=rclosed_mix
EMIXQ_c023_0_04 (mix_q_src_c023_0_04 0 bpf_c023_0 0) vcvs gain=9.807852804032e-01
SMIXQ_c023_0_04 (mix_q_src_c023_0_04 mix_q_c023_0 win_0_04 0) relay vt1=-1m vt2=1m ropen=ropen_mix rclosed=rclosed_mix
EMIXI_c023_0_05 (mix_i_src_c023_0_05 0 bpf_c023_0 0) vcvs gain=-5.555702330196e-01
SMIXI_c023_0_05 (mix_i_src_c023_0_05 mix_i_c023_0 win_0_05 0) relay vt1=-1m vt2=1m ropen=ropen_mix rclosed=rclosed_mix
EMIXQ_c023_0_05 (mix_q_src_c023_0_05 0 bpf_c023_0 0) vcvs gain=8.314696123025e-01
SMIXQ_c023_0_05 (mix_q_src_c023_0_05 mix_q_c023_0 win_0_05 0) relay vt1=-1m vt2=1m ropen=ropen_mix rclosed=rclosed_mix
EMIXI_c023_0_06 (mix_i_src_c023_0_06 0 bpf_c023_0 0) vcvs gain=-8.314696123025e-01
SMIXI_c023_0_06 (mix_i_src_c023_0_06 mix_i_c023_0 win_0_06 0) relay vt1=-1m vt2=1m ropen=ropen_mix rclosed=rclosed_mix
EMIXQ_c023_0_06 (mix_q_src_c023_0_06 0 bpf_c023_0 0) vcvs gain=5.555702330196e-01
SMIXQ_c023_0_06 (mix_q_src_c023_0_06 mix_q_c023_0 win_0_06 0) relay vt1=-1m vt2=1m ropen=ropen_mix rclosed=rclosed_mix
EMIXI_c023_0_07 (mix_i_src_c023_0_07 0 bpf_c023_0 0) vcvs gain=-9.807852804032e-01
SMIXI_c023_0_07 (mix_i_src_c023_0_07 mix_i_c023_0 win_0_07 0) relay vt1=-1m vt2=1m ropen=ropen_mix rclosed=rclosed_mix
EMIXQ_c023_0_07 (mix_q_src_c023_0_07 0 bpf_c023_0 0) vcvs gain=1.950903220161e-01
SMIXQ_c023_0_07 (mix_q_src_c023_0_07 mix_q_c023_0 win_0_07 0) relay vt1=-1m vt2=1m ropen=ropen_mix rclosed=rclosed_mix
EMIXI_c023_0_08 (mix_i_src_c023_0_08 0 bpf_c023_0 0) vcvs gain=-9.807852804032e-01
SMIXI_c023_0_08 (mix_i_src_c023_0_08 mix_i_c023_0 win_0_08 0) relay vt1=-1m vt2=1m ropen=ropen_mix rclosed=rclosed_mix
EMIXQ_c023_0_08 (mix_q_src_c023_0_08 0 bpf_c023_0 0) vcvs gain=-1.950903220161e-01
SMIXQ_c023_0_08 (mix_q_src_c023_0_08 mix_q_c023_0 win_0_08 0) relay vt1=-1m vt2=1m ropen=ropen_mix rclosed=rclosed_mix
EMIXI_c023_0_09 (mix_i_src_c023_0_09 0 bpf_c023_0 0) vcvs gain=-8.314696123025e-01
SMIXI_c023_0_09 (mix_i_src_c023_0_09 mix_i_c023_0 win_0_09 0) relay vt1=-1m vt2=1m ropen=ropen_mix rclosed=rclosed_mix
EMIXQ_c023_0_09 (mix_q_src_c023_0_09 0 bpf_c023_0 0) vcvs gain=-5.555702330196e-01
SMIXQ_c023_0_09 (mix_q_src_c023_0_09 mix_q_c023_0 win_0_09 0) relay vt1=-1m vt2=1m ropen=ropen_mix rclosed=rclosed_mix
EMIXI_c023_0_10 (mix_i_src_c023_0_10 0 bpf_c023_0 0) vcvs gain=-5.555702330196e-01
SMIXI_c023_0_10 (mix_i_src_c023_0_10 mix_i_c023_0 win_0_10 0) relay vt1=-1m vt2=1m ropen=ropen_mix rclosed=rclosed_mix
EMIXQ_c023_0_10 (mix_q_src_c023_0_10 0 bpf_c023_0 0) vcvs gain=-8.314696123025e-01
SMIXQ_c023_0_10 (mix_q_src_c023_0_10 mix_q_c023_0 win_0_10 0) relay vt1=-1m vt2=1m ropen=ropen_mix rclosed=rclosed_mix
EMIXI_c023_0_11 (mix_i_src_c023_0_11 0 bpf_c023_0 0) vcvs gain=-1.950903220161e-01
SMIXI_c023_0_11 (mix_i_src_c023_0_11 mix_i_c023_0 win_0_11 0) relay vt1=-1m vt2=1m ropen=ropen_mix rclosed=rclosed_mix
EMIXQ_c023_0_11 (mix_q_src_c023_0_11 0 bpf_c023_0 0) vcvs gain=-9.807852804032e-01
SMIXQ_c023_0_11 (mix_q_src_c023_0_11 mix_q_c023_0 win_0_11 0) relay vt1=-1m vt2=1m ropen=ropen_mix rclosed=rclosed_mix
EMIXI_c023_0_12 (mix_i_src_c023_0_12 0 bpf_c023_0 0) vcvs gain=1.950903220161e-01
SMIXI_c023_0_12 (mix_i_src_c023_0_12 mix_i_c023_0 win_0_12 0) relay vt1=-1m vt2=1m ropen=ropen_mix rclosed=rclosed_mix
EMIXQ_c023_0_12 (mix_q_src_c023_0_12 0 bpf_c023_0 0) vcvs gain=-9.807852804032e-01
SMIXQ_c023_0_12 (mix_q_src_c023_0_12 mix_q_c023_0 win_0_12 0) relay vt1=-1m vt2=1m ropen=ropen_mix rclosed=rclosed_mix
EMIXI_c023_0_13 (mix_i_src_c023_0_13 0 bpf_c023_0 0) vcvs gain=5.555702330196e-01
SMIXI_c023_0_13 (mix_i_src_c023_0_13 mix_i_c023_0 win_0_13 0) relay vt1=-1m vt2=1m ropen=ropen_mix rclosed=rclosed_mix
EMIXQ_c023_0_13 (mix_q_src_c023_0_13 0 bpf_c023_0 0) vcvs gain=-8.314696123025e-01
SMIXQ_c023_0_13 (mix_q_src_c023_0_13 mix_q_c023_0 win_0_13 0) relay vt1=-1m vt2=1m ropen=ropen_mix rclosed=rclosed_mix
EMIXI_c023_0_14 (mix_i_src_c023_0_14 0 bpf_c023_0 0) vcvs gain=8.314696123025e-01
SMIXI_c023_0_14 (mix_i_src_c023_0_14 mix_i_c023_0 win_0_14 0) relay vt1=-1m vt2=1m ropen=ropen_mix rclosed=rclosed_mix
EMIXQ_c023_0_14 (mix_q_src_c023_0_14 0 bpf_c023_0 0) vcvs gain=-5.555702330196e-01
SMIXQ_c023_0_14 (mix_q_src_c023_0_14 mix_q_c023_0 win_0_14 0) relay vt1=-1m vt2=1m ropen=ropen_mix rclosed=rclosed_mix
EMIXI_c023_0_15 (mix_i_src_c023_0_15 0 bpf_c023_0 0) vcvs gain=9.807852804032e-01
SMIXI_c023_0_15 (mix_i_src_c023_0_15 mix_i_c023_0 win_0_15 0) relay vt1=-1m vt2=1m ropen=ropen_mix rclosed=rclosed_mix
EMIXQ_c023_0_15 (mix_q_src_c023_0_15 0 bpf_c023_0 0) vcvs gain=-1.950903220161e-01
SMIXQ_c023_0_15 (mix_q_src_c023_0_15 mix_q_c023_0 win_0_15 0) relay vt1=-1m vt2=1m ropen=ropen_mix rclosed=rclosed_mix
RMIXI_c023_0 (mix_i_c023_0 0) resistor r=1G
RMIXQ_c023_0 (mix_q_c023_0 0) resistor r=1G
RINTI_c023_0 (mix_i_c023_0 Icar_c023_0) resistor r=1k
CINTI_c023_0 (Icar_c023_0 0) capacitor c=80p
RINTQ_c023_0 (mix_q_c023_0 Qcar_c023_0) resistor r=1k
CINTQ_c023_0 (Qcar_c023_0 0) capacitor c=80p
save bpf_c023_0 Icar_c023_0 Qcar_c023_0

// bl023, carrier_1: 500000000 Hz coherent I/Q phase-window verification-demod path
CBPF_c023_1 (bl023 n_cbpf_c023_1) capacitor c=1.013211836423e-13
LBPF_c023_1 (n_cbpf_c023_1 bpf_c023_1) inductor l=1.000000000000e-06
RBPF_c023_1 (bpf_c023_1 0) resistor r=1.570796326795e+02
EMIXI_c023_1_00 (mix_i_src_c023_1_00 0 bpf_c023_1 0) vcvs gain=9.807852804032e-01
SMIXI_c023_1_00 (mix_i_src_c023_1_00 mix_i_c023_1 win_1_00 0) relay vt1=-1m vt2=1m ropen=ropen_mix rclosed=rclosed_mix
EMIXQ_c023_1_00 (mix_q_src_c023_1_00 0 bpf_c023_1 0) vcvs gain=1.950903220161e-01
SMIXQ_c023_1_00 (mix_q_src_c023_1_00 mix_q_c023_1 win_1_00 0) relay vt1=-1m vt2=1m ropen=ropen_mix rclosed=rclosed_mix
EMIXI_c023_1_01 (mix_i_src_c023_1_01 0 bpf_c023_1 0) vcvs gain=8.314696123025e-01
SMIXI_c023_1_01 (mix_i_src_c023_1_01 mix_i_c023_1 win_1_01 0) relay vt1=-1m vt2=1m ropen=ropen_mix rclosed=rclosed_mix
EMIXQ_c023_1_01 (mix_q_src_c023_1_01 0 bpf_c023_1 0) vcvs gain=5.555702330196e-01
SMIXQ_c023_1_01 (mix_q_src_c023_1_01 mix_q_c023_1 win_1_01 0) relay vt1=-1m vt2=1m ropen=ropen_mix rclosed=rclosed_mix
EMIXI_c023_1_02 (mix_i_src_c023_1_02 0 bpf_c023_1 0) vcvs gain=5.555702330196e-01
SMIXI_c023_1_02 (mix_i_src_c023_1_02 mix_i_c023_1 win_1_02 0) relay vt1=-1m vt2=1m ropen=ropen_mix rclosed=rclosed_mix
EMIXQ_c023_1_02 (mix_q_src_c023_1_02 0 bpf_c023_1 0) vcvs gain=8.314696123025e-01
SMIXQ_c023_1_02 (mix_q_src_c023_1_02 mix_q_c023_1 win_1_02 0) relay vt1=-1m vt2=1m ropen=ropen_mix rclosed=rclosed_mix
EMIXI_c023_1_03 (mix_i_src_c023_1_03 0 bpf_c023_1 0) vcvs gain=1.950903220161e-01
SMIXI_c023_1_03 (mix_i_src_c023_1_03 mix_i_c023_1 win_1_03 0) relay vt1=-1m vt2=1m ropen=ropen_mix rclosed=rclosed_mix
EMIXQ_c023_1_03 (mix_q_src_c023_1_03 0 bpf_c023_1 0) vcvs gain=9.807852804032e-01
SMIXQ_c023_1_03 (mix_q_src_c023_1_03 mix_q_c023_1 win_1_03 0) relay vt1=-1m vt2=1m ropen=ropen_mix rclosed=rclosed_mix
EMIXI_c023_1_04 (mix_i_src_c023_1_04 0 bpf_c023_1 0) vcvs gain=-1.950903220161e-01
SMIXI_c023_1_04 (mix_i_src_c023_1_04 mix_i_c023_1 win_1_04 0) relay vt1=-1m vt2=1m ropen=ropen_mix rclosed=rclosed_mix
EMIXQ_c023_1_04 (mix_q_src_c023_1_04 0 bpf_c023_1 0) vcvs gain=9.807852804032e-01
SMIXQ_c023_1_04 (mix_q_src_c023_1_04 mix_q_c023_1 win_1_04 0) relay vt1=-1m vt2=1m ropen=ropen_mix rclosed=rclosed_mix
EMIXI_c023_1_05 (mix_i_src_c023_1_05 0 bpf_c023_1 0) vcvs gain=-5.555702330196e-01
SMIXI_c023_1_05 (mix_i_src_c023_1_05 mix_i_c023_1 win_1_05 0) relay vt1=-1m vt2=1m ropen=ropen_mix rclosed=rclosed_mix
EMIXQ_c023_1_05 (mix_q_src_c023_1_05 0 bpf_c023_1 0) vcvs gain=8.314696123025e-01
SMIXQ_c023_1_05 (mix_q_src_c023_1_05 mix_q_c023_1 win_1_05 0) relay vt1=-1m vt2=1m ropen=ropen_mix rclosed=rclosed_mix
EMIXI_c023_1_06 (mix_i_src_c023_1_06 0 bpf_c023_1 0) vcvs gain=-8.314696123025e-01
SMIXI_c023_1_06 (mix_i_src_c023_1_06 mix_i_c023_1 win_1_06 0) relay vt1=-1m vt2=1m ropen=ropen_mix rclosed=rclosed_mix
EMIXQ_c023_1_06 (mix_q_src_c023_1_06 0 bpf_c023_1 0) vcvs gain=5.555702330196e-01
SMIXQ_c023_1_06 (mix_q_src_c023_1_06 mix_q_c023_1 win_1_06 0) relay vt1=-1m vt2=1m ropen=ropen_mix rclosed=rclosed_mix
EMIXI_c023_1_07 (mix_i_src_c023_1_07 0 bpf_c023_1 0) vcvs gain=-9.807852804032e-01
SMIXI_c023_1_07 (mix_i_src_c023_1_07 mix_i_c023_1 win_1_07 0) relay vt1=-1m vt2=1m ropen=ropen_mix rclosed=rclosed_mix
EMIXQ_c023_1_07 (mix_q_src_c023_1_07 0 bpf_c023_1 0) vcvs gain=1.950903220161e-01
SMIXQ_c023_1_07 (mix_q_src_c023_1_07 mix_q_c023_1 win_1_07 0) relay vt1=-1m vt2=1m ropen=ropen_mix rclosed=rclosed_mix
EMIXI_c023_1_08 (mix_i_src_c023_1_08 0 bpf_c023_1 0) vcvs gain=-9.807852804032e-01
SMIXI_c023_1_08 (mix_i_src_c023_1_08 mix_i_c023_1 win_1_08 0) relay vt1=-1m vt2=1m ropen=ropen_mix rclosed=rclosed_mix
EMIXQ_c023_1_08 (mix_q_src_c023_1_08 0 bpf_c023_1 0) vcvs gain=-1.950903220161e-01
SMIXQ_c023_1_08 (mix_q_src_c023_1_08 mix_q_c023_1 win_1_08 0) relay vt1=-1m vt2=1m ropen=ropen_mix rclosed=rclosed_mix
EMIXI_c023_1_09 (mix_i_src_c023_1_09 0 bpf_c023_1 0) vcvs gain=-8.314696123025e-01
SMIXI_c023_1_09 (mix_i_src_c023_1_09 mix_i_c023_1 win_1_09 0) relay vt1=-1m vt2=1m ropen=ropen_mix rclosed=rclosed_mix
EMIXQ_c023_1_09 (mix_q_src_c023_1_09 0 bpf_c023_1 0) vcvs gain=-5.555702330196e-01
SMIXQ_c023_1_09 (mix_q_src_c023_1_09 mix_q_c023_1 win_1_09 0) relay vt1=-1m vt2=1m ropen=ropen_mix rclosed=rclosed_mix
EMIXI_c023_1_10 (mix_i_src_c023_1_10 0 bpf_c023_1 0) vcvs gain=-5.555702330196e-01
SMIXI_c023_1_10 (mix_i_src_c023_1_10 mix_i_c023_1 win_1_10 0) relay vt1=-1m vt2=1m ropen=ropen_mix rclosed=rclosed_mix
EMIXQ_c023_1_10 (mix_q_src_c023_1_10 0 bpf_c023_1 0) vcvs gain=-8.314696123025e-01
SMIXQ_c023_1_10 (mix_q_src_c023_1_10 mix_q_c023_1 win_1_10 0) relay vt1=-1m vt2=1m ropen=ropen_mix rclosed=rclosed_mix
EMIXI_c023_1_11 (mix_i_src_c023_1_11 0 bpf_c023_1 0) vcvs gain=-1.950903220161e-01
SMIXI_c023_1_11 (mix_i_src_c023_1_11 mix_i_c023_1 win_1_11 0) relay vt1=-1m vt2=1m ropen=ropen_mix rclosed=rclosed_mix
EMIXQ_c023_1_11 (mix_q_src_c023_1_11 0 bpf_c023_1 0) vcvs gain=-9.807852804032e-01
SMIXQ_c023_1_11 (mix_q_src_c023_1_11 mix_q_c023_1 win_1_11 0) relay vt1=-1m vt2=1m ropen=ropen_mix rclosed=rclosed_mix
EMIXI_c023_1_12 (mix_i_src_c023_1_12 0 bpf_c023_1 0) vcvs gain=1.950903220161e-01
SMIXI_c023_1_12 (mix_i_src_c023_1_12 mix_i_c023_1 win_1_12 0) relay vt1=-1m vt2=1m ropen=ropen_mix rclosed=rclosed_mix
EMIXQ_c023_1_12 (mix_q_src_c023_1_12 0 bpf_c023_1 0) vcvs gain=-9.807852804032e-01
SMIXQ_c023_1_12 (mix_q_src_c023_1_12 mix_q_c023_1 win_1_12 0) relay vt1=-1m vt2=1m ropen=ropen_mix rclosed=rclosed_mix
EMIXI_c023_1_13 (mix_i_src_c023_1_13 0 bpf_c023_1 0) vcvs gain=5.555702330196e-01
SMIXI_c023_1_13 (mix_i_src_c023_1_13 mix_i_c023_1 win_1_13 0) relay vt1=-1m vt2=1m ropen=ropen_mix rclosed=rclosed_mix
EMIXQ_c023_1_13 (mix_q_src_c023_1_13 0 bpf_c023_1 0) vcvs gain=-8.314696123025e-01
SMIXQ_c023_1_13 (mix_q_src_c023_1_13 mix_q_c023_1 win_1_13 0) relay vt1=-1m vt2=1m ropen=ropen_mix rclosed=rclosed_mix
EMIXI_c023_1_14 (mix_i_src_c023_1_14 0 bpf_c023_1 0) vcvs gain=8.314696123025e-01
SMIXI_c023_1_14 (mix_i_src_c023_1_14 mix_i_c023_1 win_1_14 0) relay vt1=-1m vt2=1m ropen=ropen_mix rclosed=rclosed_mix
EMIXQ_c023_1_14 (mix_q_src_c023_1_14 0 bpf_c023_1 0) vcvs gain=-5.555702330196e-01
SMIXQ_c023_1_14 (mix_q_src_c023_1_14 mix_q_c023_1 win_1_14 0) relay vt1=-1m vt2=1m ropen=ropen_mix rclosed=rclosed_mix
EMIXI_c023_1_15 (mix_i_src_c023_1_15 0 bpf_c023_1 0) vcvs gain=9.807852804032e-01
SMIXI_c023_1_15 (mix_i_src_c023_1_15 mix_i_c023_1 win_1_15 0) relay vt1=-1m vt2=1m ropen=ropen_mix rclosed=rclosed_mix
EMIXQ_c023_1_15 (mix_q_src_c023_1_15 0 bpf_c023_1 0) vcvs gain=-1.950903220161e-01
SMIXQ_c023_1_15 (mix_q_src_c023_1_15 mix_q_c023_1 win_1_15 0) relay vt1=-1m vt2=1m ropen=ropen_mix rclosed=rclosed_mix
RMIXI_c023_1 (mix_i_c023_1 0) resistor r=1G
RMIXQ_c023_1 (mix_q_c023_1 0) resistor r=1G
RINTI_c023_1 (mix_i_c023_1 Icar_c023_1) resistor r=1k
CINTI_c023_1 (Icar_c023_1 0) capacitor c=80p
RINTQ_c023_1 (mix_q_c023_1 Qcar_c023_1) resistor r=1k
CINTQ_c023_1 (Qcar_c023_1 0) capacitor c=80p
save bpf_c023_1 Icar_c023_1 Qcar_c023_1

// bl023, carrier_2: 750000000 Hz coherent I/Q phase-window verification-demod path
CBPF_c023_2 (bl023 n_cbpf_c023_2) capacitor c=4.503163717437e-14
LBPF_c023_2 (n_cbpf_c023_2 bpf_c023_2) inductor l=1.000000000000e-06
RBPF_c023_2 (bpf_c023_2 0) resistor r=2.356194490192e+02
EMIXI_c023_2_00 (mix_i_src_c023_2_00 0 bpf_c023_2 0) vcvs gain=9.807852804032e-01
SMIXI_c023_2_00 (mix_i_src_c023_2_00 mix_i_c023_2 win_2_00 0) relay vt1=-1m vt2=1m ropen=ropen_mix rclosed=rclosed_mix
EMIXQ_c023_2_00 (mix_q_src_c023_2_00 0 bpf_c023_2 0) vcvs gain=1.950903220161e-01
SMIXQ_c023_2_00 (mix_q_src_c023_2_00 mix_q_c023_2 win_2_00 0) relay vt1=-1m vt2=1m ropen=ropen_mix rclosed=rclosed_mix
EMIXI_c023_2_01 (mix_i_src_c023_2_01 0 bpf_c023_2 0) vcvs gain=8.314696123025e-01
SMIXI_c023_2_01 (mix_i_src_c023_2_01 mix_i_c023_2 win_2_01 0) relay vt1=-1m vt2=1m ropen=ropen_mix rclosed=rclosed_mix
EMIXQ_c023_2_01 (mix_q_src_c023_2_01 0 bpf_c023_2 0) vcvs gain=5.555702330196e-01
SMIXQ_c023_2_01 (mix_q_src_c023_2_01 mix_q_c023_2 win_2_01 0) relay vt1=-1m vt2=1m ropen=ropen_mix rclosed=rclosed_mix
EMIXI_c023_2_02 (mix_i_src_c023_2_02 0 bpf_c023_2 0) vcvs gain=5.555702330196e-01
SMIXI_c023_2_02 (mix_i_src_c023_2_02 mix_i_c023_2 win_2_02 0) relay vt1=-1m vt2=1m ropen=ropen_mix rclosed=rclosed_mix
EMIXQ_c023_2_02 (mix_q_src_c023_2_02 0 bpf_c023_2 0) vcvs gain=8.314696123025e-01
SMIXQ_c023_2_02 (mix_q_src_c023_2_02 mix_q_c023_2 win_2_02 0) relay vt1=-1m vt2=1m ropen=ropen_mix rclosed=rclosed_mix
EMIXI_c023_2_03 (mix_i_src_c023_2_03 0 bpf_c023_2 0) vcvs gain=1.950903220161e-01
SMIXI_c023_2_03 (mix_i_src_c023_2_03 mix_i_c023_2 win_2_03 0) relay vt1=-1m vt2=1m ropen=ropen_mix rclosed=rclosed_mix
EMIXQ_c023_2_03 (mix_q_src_c023_2_03 0 bpf_c023_2 0) vcvs gain=9.807852804032e-01
SMIXQ_c023_2_03 (mix_q_src_c023_2_03 mix_q_c023_2 win_2_03 0) relay vt1=-1m vt2=1m ropen=ropen_mix rclosed=rclosed_mix
EMIXI_c023_2_04 (mix_i_src_c023_2_04 0 bpf_c023_2 0) vcvs gain=-1.950903220161e-01
SMIXI_c023_2_04 (mix_i_src_c023_2_04 mix_i_c023_2 win_2_04 0) relay vt1=-1m vt2=1m ropen=ropen_mix rclosed=rclosed_mix
EMIXQ_c023_2_04 (mix_q_src_c023_2_04 0 bpf_c023_2 0) vcvs gain=9.807852804032e-01
SMIXQ_c023_2_04 (mix_q_src_c023_2_04 mix_q_c023_2 win_2_04 0) relay vt1=-1m vt2=1m ropen=ropen_mix rclosed=rclosed_mix
EMIXI_c023_2_05 (mix_i_src_c023_2_05 0 bpf_c023_2 0) vcvs gain=-5.555702330196e-01
SMIXI_c023_2_05 (mix_i_src_c023_2_05 mix_i_c023_2 win_2_05 0) relay vt1=-1m vt2=1m ropen=ropen_mix rclosed=rclosed_mix
EMIXQ_c023_2_05 (mix_q_src_c023_2_05 0 bpf_c023_2 0) vcvs gain=8.314696123025e-01
SMIXQ_c023_2_05 (mix_q_src_c023_2_05 mix_q_c023_2 win_2_05 0) relay vt1=-1m vt2=1m ropen=ropen_mix rclosed=rclosed_mix
EMIXI_c023_2_06 (mix_i_src_c023_2_06 0 bpf_c023_2 0) vcvs gain=-8.314696123025e-01
SMIXI_c023_2_06 (mix_i_src_c023_2_06 mix_i_c023_2 win_2_06 0) relay vt1=-1m vt2=1m ropen=ropen_mix rclosed=rclosed_mix
EMIXQ_c023_2_06 (mix_q_src_c023_2_06 0 bpf_c023_2 0) vcvs gain=5.555702330196e-01
SMIXQ_c023_2_06 (mix_q_src_c023_2_06 mix_q_c023_2 win_2_06 0) relay vt1=-1m vt2=1m ropen=ropen_mix rclosed=rclosed_mix
EMIXI_c023_2_07 (mix_i_src_c023_2_07 0 bpf_c023_2 0) vcvs gain=-9.807852804032e-01
SMIXI_c023_2_07 (mix_i_src_c023_2_07 mix_i_c023_2 win_2_07 0) relay vt1=-1m vt2=1m ropen=ropen_mix rclosed=rclosed_mix
EMIXQ_c023_2_07 (mix_q_src_c023_2_07 0 bpf_c023_2 0) vcvs gain=1.950903220161e-01
SMIXQ_c023_2_07 (mix_q_src_c023_2_07 mix_q_c023_2 win_2_07 0) relay vt1=-1m vt2=1m ropen=ropen_mix rclosed=rclosed_mix
EMIXI_c023_2_08 (mix_i_src_c023_2_08 0 bpf_c023_2 0) vcvs gain=-9.807852804032e-01
SMIXI_c023_2_08 (mix_i_src_c023_2_08 mix_i_c023_2 win_2_08 0) relay vt1=-1m vt2=1m ropen=ropen_mix rclosed=rclosed_mix
EMIXQ_c023_2_08 (mix_q_src_c023_2_08 0 bpf_c023_2 0) vcvs gain=-1.950903220161e-01
SMIXQ_c023_2_08 (mix_q_src_c023_2_08 mix_q_c023_2 win_2_08 0) relay vt1=-1m vt2=1m ropen=ropen_mix rclosed=rclosed_mix
EMIXI_c023_2_09 (mix_i_src_c023_2_09 0 bpf_c023_2 0) vcvs gain=-8.314696123025e-01
SMIXI_c023_2_09 (mix_i_src_c023_2_09 mix_i_c023_2 win_2_09 0) relay vt1=-1m vt2=1m ropen=ropen_mix rclosed=rclosed_mix
EMIXQ_c023_2_09 (mix_q_src_c023_2_09 0 bpf_c023_2 0) vcvs gain=-5.555702330196e-01
SMIXQ_c023_2_09 (mix_q_src_c023_2_09 mix_q_c023_2 win_2_09 0) relay vt1=-1m vt2=1m ropen=ropen_mix rclosed=rclosed_mix
EMIXI_c023_2_10 (mix_i_src_c023_2_10 0 bpf_c023_2 0) vcvs gain=-5.555702330196e-01
SMIXI_c023_2_10 (mix_i_src_c023_2_10 mix_i_c023_2 win_2_10 0) relay vt1=-1m vt2=1m ropen=ropen_mix rclosed=rclosed_mix
EMIXQ_c023_2_10 (mix_q_src_c023_2_10 0 bpf_c023_2 0) vcvs gain=-8.314696123025e-01
SMIXQ_c023_2_10 (mix_q_src_c023_2_10 mix_q_c023_2 win_2_10 0) relay vt1=-1m vt2=1m ropen=ropen_mix rclosed=rclosed_mix
EMIXI_c023_2_11 (mix_i_src_c023_2_11 0 bpf_c023_2 0) vcvs gain=-1.950903220161e-01
SMIXI_c023_2_11 (mix_i_src_c023_2_11 mix_i_c023_2 win_2_11 0) relay vt1=-1m vt2=1m ropen=ropen_mix rclosed=rclosed_mix
EMIXQ_c023_2_11 (mix_q_src_c023_2_11 0 bpf_c023_2 0) vcvs gain=-9.807852804032e-01
SMIXQ_c023_2_11 (mix_q_src_c023_2_11 mix_q_c023_2 win_2_11 0) relay vt1=-1m vt2=1m ropen=ropen_mix rclosed=rclosed_mix
EMIXI_c023_2_12 (mix_i_src_c023_2_12 0 bpf_c023_2 0) vcvs gain=1.950903220161e-01
SMIXI_c023_2_12 (mix_i_src_c023_2_12 mix_i_c023_2 win_2_12 0) relay vt1=-1m vt2=1m ropen=ropen_mix rclosed=rclosed_mix
EMIXQ_c023_2_12 (mix_q_src_c023_2_12 0 bpf_c023_2 0) vcvs gain=-9.807852804032e-01
SMIXQ_c023_2_12 (mix_q_src_c023_2_12 mix_q_c023_2 win_2_12 0) relay vt1=-1m vt2=1m ropen=ropen_mix rclosed=rclosed_mix
EMIXI_c023_2_13 (mix_i_src_c023_2_13 0 bpf_c023_2 0) vcvs gain=5.555702330196e-01
SMIXI_c023_2_13 (mix_i_src_c023_2_13 mix_i_c023_2 win_2_13 0) relay vt1=-1m vt2=1m ropen=ropen_mix rclosed=rclosed_mix
EMIXQ_c023_2_13 (mix_q_src_c023_2_13 0 bpf_c023_2 0) vcvs gain=-8.314696123025e-01
SMIXQ_c023_2_13 (mix_q_src_c023_2_13 mix_q_c023_2 win_2_13 0) relay vt1=-1m vt2=1m ropen=ropen_mix rclosed=rclosed_mix
EMIXI_c023_2_14 (mix_i_src_c023_2_14 0 bpf_c023_2 0) vcvs gain=8.314696123025e-01
SMIXI_c023_2_14 (mix_i_src_c023_2_14 mix_i_c023_2 win_2_14 0) relay vt1=-1m vt2=1m ropen=ropen_mix rclosed=rclosed_mix
EMIXQ_c023_2_14 (mix_q_src_c023_2_14 0 bpf_c023_2 0) vcvs gain=-5.555702330196e-01
SMIXQ_c023_2_14 (mix_q_src_c023_2_14 mix_q_c023_2 win_2_14 0) relay vt1=-1m vt2=1m ropen=ropen_mix rclosed=rclosed_mix
EMIXI_c023_2_15 (mix_i_src_c023_2_15 0 bpf_c023_2 0) vcvs gain=9.807852804032e-01
SMIXI_c023_2_15 (mix_i_src_c023_2_15 mix_i_c023_2 win_2_15 0) relay vt1=-1m vt2=1m ropen=ropen_mix rclosed=rclosed_mix
EMIXQ_c023_2_15 (mix_q_src_c023_2_15 0 bpf_c023_2 0) vcvs gain=-1.950903220161e-01
SMIXQ_c023_2_15 (mix_q_src_c023_2_15 mix_q_c023_2 win_2_15 0) relay vt1=-1m vt2=1m ropen=ropen_mix rclosed=rclosed_mix
RMIXI_c023_2 (mix_i_c023_2 0) resistor r=1G
RMIXQ_c023_2 (mix_q_c023_2 0) resistor r=1G
RINTI_c023_2 (mix_i_c023_2 Icar_c023_2) resistor r=1k
CINTI_c023_2 (Icar_c023_2 0) capacitor c=80p
RINTQ_c023_2 (mix_q_c023_2 Qcar_c023_2) resistor r=1k
CINTQ_c023_2 (Qcar_c023_2 0) capacitor c=80p
save bpf_c023_2 Icar_c023_2 Qcar_c023_2

// bl023, carrier_3: 1000000000 Hz coherent I/Q phase-window verification-demod path
CBPF_c023_3 (bl023 n_cbpf_c023_3) capacitor c=2.533029591058e-14
LBPF_c023_3 (n_cbpf_c023_3 bpf_c023_3) inductor l=1.000000000000e-06
RBPF_c023_3 (bpf_c023_3 0) resistor r=3.141592653590e+02
EMIXI_c023_3_00 (mix_i_src_c023_3_00 0 bpf_c023_3 0) vcvs gain=9.807852804032e-01
SMIXI_c023_3_00 (mix_i_src_c023_3_00 mix_i_c023_3 win_3_00 0) relay vt1=-1m vt2=1m ropen=ropen_mix rclosed=rclosed_mix
EMIXQ_c023_3_00 (mix_q_src_c023_3_00 0 bpf_c023_3 0) vcvs gain=1.950903220161e-01
SMIXQ_c023_3_00 (mix_q_src_c023_3_00 mix_q_c023_3 win_3_00 0) relay vt1=-1m vt2=1m ropen=ropen_mix rclosed=rclosed_mix
EMIXI_c023_3_01 (mix_i_src_c023_3_01 0 bpf_c023_3 0) vcvs gain=8.314696123025e-01
SMIXI_c023_3_01 (mix_i_src_c023_3_01 mix_i_c023_3 win_3_01 0) relay vt1=-1m vt2=1m ropen=ropen_mix rclosed=rclosed_mix
EMIXQ_c023_3_01 (mix_q_src_c023_3_01 0 bpf_c023_3 0) vcvs gain=5.555702330196e-01
SMIXQ_c023_3_01 (mix_q_src_c023_3_01 mix_q_c023_3 win_3_01 0) relay vt1=-1m vt2=1m ropen=ropen_mix rclosed=rclosed_mix
EMIXI_c023_3_02 (mix_i_src_c023_3_02 0 bpf_c023_3 0) vcvs gain=5.555702330196e-01
SMIXI_c023_3_02 (mix_i_src_c023_3_02 mix_i_c023_3 win_3_02 0) relay vt1=-1m vt2=1m ropen=ropen_mix rclosed=rclosed_mix
EMIXQ_c023_3_02 (mix_q_src_c023_3_02 0 bpf_c023_3 0) vcvs gain=8.314696123025e-01
SMIXQ_c023_3_02 (mix_q_src_c023_3_02 mix_q_c023_3 win_3_02 0) relay vt1=-1m vt2=1m ropen=ropen_mix rclosed=rclosed_mix
EMIXI_c023_3_03 (mix_i_src_c023_3_03 0 bpf_c023_3 0) vcvs gain=1.950903220161e-01
SMIXI_c023_3_03 (mix_i_src_c023_3_03 mix_i_c023_3 win_3_03 0) relay vt1=-1m vt2=1m ropen=ropen_mix rclosed=rclosed_mix
EMIXQ_c023_3_03 (mix_q_src_c023_3_03 0 bpf_c023_3 0) vcvs gain=9.807852804032e-01
SMIXQ_c023_3_03 (mix_q_src_c023_3_03 mix_q_c023_3 win_3_03 0) relay vt1=-1m vt2=1m ropen=ropen_mix rclosed=rclosed_mix
EMIXI_c023_3_04 (mix_i_src_c023_3_04 0 bpf_c023_3 0) vcvs gain=-1.950903220161e-01
SMIXI_c023_3_04 (mix_i_src_c023_3_04 mix_i_c023_3 win_3_04 0) relay vt1=-1m vt2=1m ropen=ropen_mix rclosed=rclosed_mix
EMIXQ_c023_3_04 (mix_q_src_c023_3_04 0 bpf_c023_3 0) vcvs gain=9.807852804032e-01
SMIXQ_c023_3_04 (mix_q_src_c023_3_04 mix_q_c023_3 win_3_04 0) relay vt1=-1m vt2=1m ropen=ropen_mix rclosed=rclosed_mix
EMIXI_c023_3_05 (mix_i_src_c023_3_05 0 bpf_c023_3 0) vcvs gain=-5.555702330196e-01
SMIXI_c023_3_05 (mix_i_src_c023_3_05 mix_i_c023_3 win_3_05 0) relay vt1=-1m vt2=1m ropen=ropen_mix rclosed=rclosed_mix
EMIXQ_c023_3_05 (mix_q_src_c023_3_05 0 bpf_c023_3 0) vcvs gain=8.314696123025e-01
SMIXQ_c023_3_05 (mix_q_src_c023_3_05 mix_q_c023_3 win_3_05 0) relay vt1=-1m vt2=1m ropen=ropen_mix rclosed=rclosed_mix
EMIXI_c023_3_06 (mix_i_src_c023_3_06 0 bpf_c023_3 0) vcvs gain=-8.314696123025e-01
SMIXI_c023_3_06 (mix_i_src_c023_3_06 mix_i_c023_3 win_3_06 0) relay vt1=-1m vt2=1m ropen=ropen_mix rclosed=rclosed_mix
EMIXQ_c023_3_06 (mix_q_src_c023_3_06 0 bpf_c023_3 0) vcvs gain=5.555702330196e-01
SMIXQ_c023_3_06 (mix_q_src_c023_3_06 mix_q_c023_3 win_3_06 0) relay vt1=-1m vt2=1m ropen=ropen_mix rclosed=rclosed_mix
EMIXI_c023_3_07 (mix_i_src_c023_3_07 0 bpf_c023_3 0) vcvs gain=-9.807852804032e-01
SMIXI_c023_3_07 (mix_i_src_c023_3_07 mix_i_c023_3 win_3_07 0) relay vt1=-1m vt2=1m ropen=ropen_mix rclosed=rclosed_mix
EMIXQ_c023_3_07 (mix_q_src_c023_3_07 0 bpf_c023_3 0) vcvs gain=1.950903220161e-01
SMIXQ_c023_3_07 (mix_q_src_c023_3_07 mix_q_c023_3 win_3_07 0) relay vt1=-1m vt2=1m ropen=ropen_mix rclosed=rclosed_mix
EMIXI_c023_3_08 (mix_i_src_c023_3_08 0 bpf_c023_3 0) vcvs gain=-9.807852804032e-01
SMIXI_c023_3_08 (mix_i_src_c023_3_08 mix_i_c023_3 win_3_08 0) relay vt1=-1m vt2=1m ropen=ropen_mix rclosed=rclosed_mix
EMIXQ_c023_3_08 (mix_q_src_c023_3_08 0 bpf_c023_3 0) vcvs gain=-1.950903220161e-01
SMIXQ_c023_3_08 (mix_q_src_c023_3_08 mix_q_c023_3 win_3_08 0) relay vt1=-1m vt2=1m ropen=ropen_mix rclosed=rclosed_mix
EMIXI_c023_3_09 (mix_i_src_c023_3_09 0 bpf_c023_3 0) vcvs gain=-8.314696123025e-01
SMIXI_c023_3_09 (mix_i_src_c023_3_09 mix_i_c023_3 win_3_09 0) relay vt1=-1m vt2=1m ropen=ropen_mix rclosed=rclosed_mix
EMIXQ_c023_3_09 (mix_q_src_c023_3_09 0 bpf_c023_3 0) vcvs gain=-5.555702330196e-01
SMIXQ_c023_3_09 (mix_q_src_c023_3_09 mix_q_c023_3 win_3_09 0) relay vt1=-1m vt2=1m ropen=ropen_mix rclosed=rclosed_mix
EMIXI_c023_3_10 (mix_i_src_c023_3_10 0 bpf_c023_3 0) vcvs gain=-5.555702330196e-01
SMIXI_c023_3_10 (mix_i_src_c023_3_10 mix_i_c023_3 win_3_10 0) relay vt1=-1m vt2=1m ropen=ropen_mix rclosed=rclosed_mix
EMIXQ_c023_3_10 (mix_q_src_c023_3_10 0 bpf_c023_3 0) vcvs gain=-8.314696123025e-01
SMIXQ_c023_3_10 (mix_q_src_c023_3_10 mix_q_c023_3 win_3_10 0) relay vt1=-1m vt2=1m ropen=ropen_mix rclosed=rclosed_mix
EMIXI_c023_3_11 (mix_i_src_c023_3_11 0 bpf_c023_3 0) vcvs gain=-1.950903220161e-01
SMIXI_c023_3_11 (mix_i_src_c023_3_11 mix_i_c023_3 win_3_11 0) relay vt1=-1m vt2=1m ropen=ropen_mix rclosed=rclosed_mix
EMIXQ_c023_3_11 (mix_q_src_c023_3_11 0 bpf_c023_3 0) vcvs gain=-9.807852804032e-01
SMIXQ_c023_3_11 (mix_q_src_c023_3_11 mix_q_c023_3 win_3_11 0) relay vt1=-1m vt2=1m ropen=ropen_mix rclosed=rclosed_mix
EMIXI_c023_3_12 (mix_i_src_c023_3_12 0 bpf_c023_3 0) vcvs gain=1.950903220161e-01
SMIXI_c023_3_12 (mix_i_src_c023_3_12 mix_i_c023_3 win_3_12 0) relay vt1=-1m vt2=1m ropen=ropen_mix rclosed=rclosed_mix
EMIXQ_c023_3_12 (mix_q_src_c023_3_12 0 bpf_c023_3 0) vcvs gain=-9.807852804032e-01
SMIXQ_c023_3_12 (mix_q_src_c023_3_12 mix_q_c023_3 win_3_12 0) relay vt1=-1m vt2=1m ropen=ropen_mix rclosed=rclosed_mix
EMIXI_c023_3_13 (mix_i_src_c023_3_13 0 bpf_c023_3 0) vcvs gain=5.555702330196e-01
SMIXI_c023_3_13 (mix_i_src_c023_3_13 mix_i_c023_3 win_3_13 0) relay vt1=-1m vt2=1m ropen=ropen_mix rclosed=rclosed_mix
EMIXQ_c023_3_13 (mix_q_src_c023_3_13 0 bpf_c023_3 0) vcvs gain=-8.314696123025e-01
SMIXQ_c023_3_13 (mix_q_src_c023_3_13 mix_q_c023_3 win_3_13 0) relay vt1=-1m vt2=1m ropen=ropen_mix rclosed=rclosed_mix
EMIXI_c023_3_14 (mix_i_src_c023_3_14 0 bpf_c023_3 0) vcvs gain=8.314696123025e-01
SMIXI_c023_3_14 (mix_i_src_c023_3_14 mix_i_c023_3 win_3_14 0) relay vt1=-1m vt2=1m ropen=ropen_mix rclosed=rclosed_mix
EMIXQ_c023_3_14 (mix_q_src_c023_3_14 0 bpf_c023_3 0) vcvs gain=-5.555702330196e-01
SMIXQ_c023_3_14 (mix_q_src_c023_3_14 mix_q_c023_3 win_3_14 0) relay vt1=-1m vt2=1m ropen=ropen_mix rclosed=rclosed_mix
EMIXI_c023_3_15 (mix_i_src_c023_3_15 0 bpf_c023_3 0) vcvs gain=9.807852804032e-01
SMIXI_c023_3_15 (mix_i_src_c023_3_15 mix_i_c023_3 win_3_15 0) relay vt1=-1m vt2=1m ropen=ropen_mix rclosed=rclosed_mix
EMIXQ_c023_3_15 (mix_q_src_c023_3_15 0 bpf_c023_3 0) vcvs gain=-1.950903220161e-01
SMIXQ_c023_3_15 (mix_q_src_c023_3_15 mix_q_c023_3 win_3_15 0) relay vt1=-1m vt2=1m ropen=ropen_mix rclosed=rclosed_mix
RMIXI_c023_3 (mix_i_c023_3 0) resistor r=1G
RMIXQ_c023_3 (mix_q_c023_3 0) resistor r=1G
RINTI_c023_3 (mix_i_c023_3 Icar_c023_3) resistor r=1k
CINTI_c023_3 (Icar_c023_3 0) capacitor c=80p
RINTQ_c023_3 (mix_q_c023_3 Qcar_c023_3) resistor r=1k
CINTQ_c023_3 (Qcar_c023_3 0) capacitor c=80p
save bpf_c023_3 Icar_c023_3 Qcar_c023_3

// bl024, carrier_0: 250000000 Hz coherent I/Q phase-window verification-demod path
CBPF_c024_0 (bl024 n_cbpf_c024_0) capacitor c=4.052847345694e-13
LBPF_c024_0 (n_cbpf_c024_0 bpf_c024_0) inductor l=1.000000000000e-06
RBPF_c024_0 (bpf_c024_0 0) resistor r=7.853981633974e+01
EMIXI_c024_0_00 (mix_i_src_c024_0_00 0 bpf_c024_0 0) vcvs gain=9.807852804032e-01
SMIXI_c024_0_00 (mix_i_src_c024_0_00 mix_i_c024_0 win_0_00 0) relay vt1=-1m vt2=1m ropen=ropen_mix rclosed=rclosed_mix
EMIXQ_c024_0_00 (mix_q_src_c024_0_00 0 bpf_c024_0 0) vcvs gain=1.950903220161e-01
SMIXQ_c024_0_00 (mix_q_src_c024_0_00 mix_q_c024_0 win_0_00 0) relay vt1=-1m vt2=1m ropen=ropen_mix rclosed=rclosed_mix
EMIXI_c024_0_01 (mix_i_src_c024_0_01 0 bpf_c024_0 0) vcvs gain=8.314696123025e-01
SMIXI_c024_0_01 (mix_i_src_c024_0_01 mix_i_c024_0 win_0_01 0) relay vt1=-1m vt2=1m ropen=ropen_mix rclosed=rclosed_mix
EMIXQ_c024_0_01 (mix_q_src_c024_0_01 0 bpf_c024_0 0) vcvs gain=5.555702330196e-01
SMIXQ_c024_0_01 (mix_q_src_c024_0_01 mix_q_c024_0 win_0_01 0) relay vt1=-1m vt2=1m ropen=ropen_mix rclosed=rclosed_mix
EMIXI_c024_0_02 (mix_i_src_c024_0_02 0 bpf_c024_0 0) vcvs gain=5.555702330196e-01
SMIXI_c024_0_02 (mix_i_src_c024_0_02 mix_i_c024_0 win_0_02 0) relay vt1=-1m vt2=1m ropen=ropen_mix rclosed=rclosed_mix
EMIXQ_c024_0_02 (mix_q_src_c024_0_02 0 bpf_c024_0 0) vcvs gain=8.314696123025e-01
SMIXQ_c024_0_02 (mix_q_src_c024_0_02 mix_q_c024_0 win_0_02 0) relay vt1=-1m vt2=1m ropen=ropen_mix rclosed=rclosed_mix
EMIXI_c024_0_03 (mix_i_src_c024_0_03 0 bpf_c024_0 0) vcvs gain=1.950903220161e-01
SMIXI_c024_0_03 (mix_i_src_c024_0_03 mix_i_c024_0 win_0_03 0) relay vt1=-1m vt2=1m ropen=ropen_mix rclosed=rclosed_mix
EMIXQ_c024_0_03 (mix_q_src_c024_0_03 0 bpf_c024_0 0) vcvs gain=9.807852804032e-01
SMIXQ_c024_0_03 (mix_q_src_c024_0_03 mix_q_c024_0 win_0_03 0) relay vt1=-1m vt2=1m ropen=ropen_mix rclosed=rclosed_mix
EMIXI_c024_0_04 (mix_i_src_c024_0_04 0 bpf_c024_0 0) vcvs gain=-1.950903220161e-01
SMIXI_c024_0_04 (mix_i_src_c024_0_04 mix_i_c024_0 win_0_04 0) relay vt1=-1m vt2=1m ropen=ropen_mix rclosed=rclosed_mix
EMIXQ_c024_0_04 (mix_q_src_c024_0_04 0 bpf_c024_0 0) vcvs gain=9.807852804032e-01
SMIXQ_c024_0_04 (mix_q_src_c024_0_04 mix_q_c024_0 win_0_04 0) relay vt1=-1m vt2=1m ropen=ropen_mix rclosed=rclosed_mix
EMIXI_c024_0_05 (mix_i_src_c024_0_05 0 bpf_c024_0 0) vcvs gain=-5.555702330196e-01
SMIXI_c024_0_05 (mix_i_src_c024_0_05 mix_i_c024_0 win_0_05 0) relay vt1=-1m vt2=1m ropen=ropen_mix rclosed=rclosed_mix
EMIXQ_c024_0_05 (mix_q_src_c024_0_05 0 bpf_c024_0 0) vcvs gain=8.314696123025e-01
SMIXQ_c024_0_05 (mix_q_src_c024_0_05 mix_q_c024_0 win_0_05 0) relay vt1=-1m vt2=1m ropen=ropen_mix rclosed=rclosed_mix
EMIXI_c024_0_06 (mix_i_src_c024_0_06 0 bpf_c024_0 0) vcvs gain=-8.314696123025e-01
SMIXI_c024_0_06 (mix_i_src_c024_0_06 mix_i_c024_0 win_0_06 0) relay vt1=-1m vt2=1m ropen=ropen_mix rclosed=rclosed_mix
EMIXQ_c024_0_06 (mix_q_src_c024_0_06 0 bpf_c024_0 0) vcvs gain=5.555702330196e-01
SMIXQ_c024_0_06 (mix_q_src_c024_0_06 mix_q_c024_0 win_0_06 0) relay vt1=-1m vt2=1m ropen=ropen_mix rclosed=rclosed_mix
EMIXI_c024_0_07 (mix_i_src_c024_0_07 0 bpf_c024_0 0) vcvs gain=-9.807852804032e-01
SMIXI_c024_0_07 (mix_i_src_c024_0_07 mix_i_c024_0 win_0_07 0) relay vt1=-1m vt2=1m ropen=ropen_mix rclosed=rclosed_mix
EMIXQ_c024_0_07 (mix_q_src_c024_0_07 0 bpf_c024_0 0) vcvs gain=1.950903220161e-01
SMIXQ_c024_0_07 (mix_q_src_c024_0_07 mix_q_c024_0 win_0_07 0) relay vt1=-1m vt2=1m ropen=ropen_mix rclosed=rclosed_mix
EMIXI_c024_0_08 (mix_i_src_c024_0_08 0 bpf_c024_0 0) vcvs gain=-9.807852804032e-01
SMIXI_c024_0_08 (mix_i_src_c024_0_08 mix_i_c024_0 win_0_08 0) relay vt1=-1m vt2=1m ropen=ropen_mix rclosed=rclosed_mix
EMIXQ_c024_0_08 (mix_q_src_c024_0_08 0 bpf_c024_0 0) vcvs gain=-1.950903220161e-01
SMIXQ_c024_0_08 (mix_q_src_c024_0_08 mix_q_c024_0 win_0_08 0) relay vt1=-1m vt2=1m ropen=ropen_mix rclosed=rclosed_mix
EMIXI_c024_0_09 (mix_i_src_c024_0_09 0 bpf_c024_0 0) vcvs gain=-8.314696123025e-01
SMIXI_c024_0_09 (mix_i_src_c024_0_09 mix_i_c024_0 win_0_09 0) relay vt1=-1m vt2=1m ropen=ropen_mix rclosed=rclosed_mix
EMIXQ_c024_0_09 (mix_q_src_c024_0_09 0 bpf_c024_0 0) vcvs gain=-5.555702330196e-01
SMIXQ_c024_0_09 (mix_q_src_c024_0_09 mix_q_c024_0 win_0_09 0) relay vt1=-1m vt2=1m ropen=ropen_mix rclosed=rclosed_mix
EMIXI_c024_0_10 (mix_i_src_c024_0_10 0 bpf_c024_0 0) vcvs gain=-5.555702330196e-01
SMIXI_c024_0_10 (mix_i_src_c024_0_10 mix_i_c024_0 win_0_10 0) relay vt1=-1m vt2=1m ropen=ropen_mix rclosed=rclosed_mix
EMIXQ_c024_0_10 (mix_q_src_c024_0_10 0 bpf_c024_0 0) vcvs gain=-8.314696123025e-01
SMIXQ_c024_0_10 (mix_q_src_c024_0_10 mix_q_c024_0 win_0_10 0) relay vt1=-1m vt2=1m ropen=ropen_mix rclosed=rclosed_mix
EMIXI_c024_0_11 (mix_i_src_c024_0_11 0 bpf_c024_0 0) vcvs gain=-1.950903220161e-01
SMIXI_c024_0_11 (mix_i_src_c024_0_11 mix_i_c024_0 win_0_11 0) relay vt1=-1m vt2=1m ropen=ropen_mix rclosed=rclosed_mix
EMIXQ_c024_0_11 (mix_q_src_c024_0_11 0 bpf_c024_0 0) vcvs gain=-9.807852804032e-01
SMIXQ_c024_0_11 (mix_q_src_c024_0_11 mix_q_c024_0 win_0_11 0) relay vt1=-1m vt2=1m ropen=ropen_mix rclosed=rclosed_mix
EMIXI_c024_0_12 (mix_i_src_c024_0_12 0 bpf_c024_0 0) vcvs gain=1.950903220161e-01
SMIXI_c024_0_12 (mix_i_src_c024_0_12 mix_i_c024_0 win_0_12 0) relay vt1=-1m vt2=1m ropen=ropen_mix rclosed=rclosed_mix
EMIXQ_c024_0_12 (mix_q_src_c024_0_12 0 bpf_c024_0 0) vcvs gain=-9.807852804032e-01
SMIXQ_c024_0_12 (mix_q_src_c024_0_12 mix_q_c024_0 win_0_12 0) relay vt1=-1m vt2=1m ropen=ropen_mix rclosed=rclosed_mix
EMIXI_c024_0_13 (mix_i_src_c024_0_13 0 bpf_c024_0 0) vcvs gain=5.555702330196e-01
SMIXI_c024_0_13 (mix_i_src_c024_0_13 mix_i_c024_0 win_0_13 0) relay vt1=-1m vt2=1m ropen=ropen_mix rclosed=rclosed_mix
EMIXQ_c024_0_13 (mix_q_src_c024_0_13 0 bpf_c024_0 0) vcvs gain=-8.314696123025e-01
SMIXQ_c024_0_13 (mix_q_src_c024_0_13 mix_q_c024_0 win_0_13 0) relay vt1=-1m vt2=1m ropen=ropen_mix rclosed=rclosed_mix
EMIXI_c024_0_14 (mix_i_src_c024_0_14 0 bpf_c024_0 0) vcvs gain=8.314696123025e-01
SMIXI_c024_0_14 (mix_i_src_c024_0_14 mix_i_c024_0 win_0_14 0) relay vt1=-1m vt2=1m ropen=ropen_mix rclosed=rclosed_mix
EMIXQ_c024_0_14 (mix_q_src_c024_0_14 0 bpf_c024_0 0) vcvs gain=-5.555702330196e-01
SMIXQ_c024_0_14 (mix_q_src_c024_0_14 mix_q_c024_0 win_0_14 0) relay vt1=-1m vt2=1m ropen=ropen_mix rclosed=rclosed_mix
EMIXI_c024_0_15 (mix_i_src_c024_0_15 0 bpf_c024_0 0) vcvs gain=9.807852804032e-01
SMIXI_c024_0_15 (mix_i_src_c024_0_15 mix_i_c024_0 win_0_15 0) relay vt1=-1m vt2=1m ropen=ropen_mix rclosed=rclosed_mix
EMIXQ_c024_0_15 (mix_q_src_c024_0_15 0 bpf_c024_0 0) vcvs gain=-1.950903220161e-01
SMIXQ_c024_0_15 (mix_q_src_c024_0_15 mix_q_c024_0 win_0_15 0) relay vt1=-1m vt2=1m ropen=ropen_mix rclosed=rclosed_mix
RMIXI_c024_0 (mix_i_c024_0 0) resistor r=1G
RMIXQ_c024_0 (mix_q_c024_0 0) resistor r=1G
RINTI_c024_0 (mix_i_c024_0 Icar_c024_0) resistor r=1k
CINTI_c024_0 (Icar_c024_0 0) capacitor c=80p
RINTQ_c024_0 (mix_q_c024_0 Qcar_c024_0) resistor r=1k
CINTQ_c024_0 (Qcar_c024_0 0) capacitor c=80p
save bpf_c024_0 Icar_c024_0 Qcar_c024_0

// bl024, carrier_1: 500000000 Hz coherent I/Q phase-window verification-demod path
CBPF_c024_1 (bl024 n_cbpf_c024_1) capacitor c=1.013211836423e-13
LBPF_c024_1 (n_cbpf_c024_1 bpf_c024_1) inductor l=1.000000000000e-06
RBPF_c024_1 (bpf_c024_1 0) resistor r=1.570796326795e+02
EMIXI_c024_1_00 (mix_i_src_c024_1_00 0 bpf_c024_1 0) vcvs gain=9.807852804032e-01
SMIXI_c024_1_00 (mix_i_src_c024_1_00 mix_i_c024_1 win_1_00 0) relay vt1=-1m vt2=1m ropen=ropen_mix rclosed=rclosed_mix
EMIXQ_c024_1_00 (mix_q_src_c024_1_00 0 bpf_c024_1 0) vcvs gain=1.950903220161e-01
SMIXQ_c024_1_00 (mix_q_src_c024_1_00 mix_q_c024_1 win_1_00 0) relay vt1=-1m vt2=1m ropen=ropen_mix rclosed=rclosed_mix
EMIXI_c024_1_01 (mix_i_src_c024_1_01 0 bpf_c024_1 0) vcvs gain=8.314696123025e-01
SMIXI_c024_1_01 (mix_i_src_c024_1_01 mix_i_c024_1 win_1_01 0) relay vt1=-1m vt2=1m ropen=ropen_mix rclosed=rclosed_mix
EMIXQ_c024_1_01 (mix_q_src_c024_1_01 0 bpf_c024_1 0) vcvs gain=5.555702330196e-01
SMIXQ_c024_1_01 (mix_q_src_c024_1_01 mix_q_c024_1 win_1_01 0) relay vt1=-1m vt2=1m ropen=ropen_mix rclosed=rclosed_mix
EMIXI_c024_1_02 (mix_i_src_c024_1_02 0 bpf_c024_1 0) vcvs gain=5.555702330196e-01
SMIXI_c024_1_02 (mix_i_src_c024_1_02 mix_i_c024_1 win_1_02 0) relay vt1=-1m vt2=1m ropen=ropen_mix rclosed=rclosed_mix
EMIXQ_c024_1_02 (mix_q_src_c024_1_02 0 bpf_c024_1 0) vcvs gain=8.314696123025e-01
SMIXQ_c024_1_02 (mix_q_src_c024_1_02 mix_q_c024_1 win_1_02 0) relay vt1=-1m vt2=1m ropen=ropen_mix rclosed=rclosed_mix
EMIXI_c024_1_03 (mix_i_src_c024_1_03 0 bpf_c024_1 0) vcvs gain=1.950903220161e-01
SMIXI_c024_1_03 (mix_i_src_c024_1_03 mix_i_c024_1 win_1_03 0) relay vt1=-1m vt2=1m ropen=ropen_mix rclosed=rclosed_mix
EMIXQ_c024_1_03 (mix_q_src_c024_1_03 0 bpf_c024_1 0) vcvs gain=9.807852804032e-01
SMIXQ_c024_1_03 (mix_q_src_c024_1_03 mix_q_c024_1 win_1_03 0) relay vt1=-1m vt2=1m ropen=ropen_mix rclosed=rclosed_mix
EMIXI_c024_1_04 (mix_i_src_c024_1_04 0 bpf_c024_1 0) vcvs gain=-1.950903220161e-01
SMIXI_c024_1_04 (mix_i_src_c024_1_04 mix_i_c024_1 win_1_04 0) relay vt1=-1m vt2=1m ropen=ropen_mix rclosed=rclosed_mix
EMIXQ_c024_1_04 (mix_q_src_c024_1_04 0 bpf_c024_1 0) vcvs gain=9.807852804032e-01
SMIXQ_c024_1_04 (mix_q_src_c024_1_04 mix_q_c024_1 win_1_04 0) relay vt1=-1m vt2=1m ropen=ropen_mix rclosed=rclosed_mix
EMIXI_c024_1_05 (mix_i_src_c024_1_05 0 bpf_c024_1 0) vcvs gain=-5.555702330196e-01
SMIXI_c024_1_05 (mix_i_src_c024_1_05 mix_i_c024_1 win_1_05 0) relay vt1=-1m vt2=1m ropen=ropen_mix rclosed=rclosed_mix
EMIXQ_c024_1_05 (mix_q_src_c024_1_05 0 bpf_c024_1 0) vcvs gain=8.314696123025e-01
SMIXQ_c024_1_05 (mix_q_src_c024_1_05 mix_q_c024_1 win_1_05 0) relay vt1=-1m vt2=1m ropen=ropen_mix rclosed=rclosed_mix
EMIXI_c024_1_06 (mix_i_src_c024_1_06 0 bpf_c024_1 0) vcvs gain=-8.314696123025e-01
SMIXI_c024_1_06 (mix_i_src_c024_1_06 mix_i_c024_1 win_1_06 0) relay vt1=-1m vt2=1m ropen=ropen_mix rclosed=rclosed_mix
EMIXQ_c024_1_06 (mix_q_src_c024_1_06 0 bpf_c024_1 0) vcvs gain=5.555702330196e-01
SMIXQ_c024_1_06 (mix_q_src_c024_1_06 mix_q_c024_1 win_1_06 0) relay vt1=-1m vt2=1m ropen=ropen_mix rclosed=rclosed_mix
EMIXI_c024_1_07 (mix_i_src_c024_1_07 0 bpf_c024_1 0) vcvs gain=-9.807852804032e-01
SMIXI_c024_1_07 (mix_i_src_c024_1_07 mix_i_c024_1 win_1_07 0) relay vt1=-1m vt2=1m ropen=ropen_mix rclosed=rclosed_mix
EMIXQ_c024_1_07 (mix_q_src_c024_1_07 0 bpf_c024_1 0) vcvs gain=1.950903220161e-01
SMIXQ_c024_1_07 (mix_q_src_c024_1_07 mix_q_c024_1 win_1_07 0) relay vt1=-1m vt2=1m ropen=ropen_mix rclosed=rclosed_mix
EMIXI_c024_1_08 (mix_i_src_c024_1_08 0 bpf_c024_1 0) vcvs gain=-9.807852804032e-01
SMIXI_c024_1_08 (mix_i_src_c024_1_08 mix_i_c024_1 win_1_08 0) relay vt1=-1m vt2=1m ropen=ropen_mix rclosed=rclosed_mix
EMIXQ_c024_1_08 (mix_q_src_c024_1_08 0 bpf_c024_1 0) vcvs gain=-1.950903220161e-01
SMIXQ_c024_1_08 (mix_q_src_c024_1_08 mix_q_c024_1 win_1_08 0) relay vt1=-1m vt2=1m ropen=ropen_mix rclosed=rclosed_mix
EMIXI_c024_1_09 (mix_i_src_c024_1_09 0 bpf_c024_1 0) vcvs gain=-8.314696123025e-01
SMIXI_c024_1_09 (mix_i_src_c024_1_09 mix_i_c024_1 win_1_09 0) relay vt1=-1m vt2=1m ropen=ropen_mix rclosed=rclosed_mix
EMIXQ_c024_1_09 (mix_q_src_c024_1_09 0 bpf_c024_1 0) vcvs gain=-5.555702330196e-01
SMIXQ_c024_1_09 (mix_q_src_c024_1_09 mix_q_c024_1 win_1_09 0) relay vt1=-1m vt2=1m ropen=ropen_mix rclosed=rclosed_mix
EMIXI_c024_1_10 (mix_i_src_c024_1_10 0 bpf_c024_1 0) vcvs gain=-5.555702330196e-01
SMIXI_c024_1_10 (mix_i_src_c024_1_10 mix_i_c024_1 win_1_10 0) relay vt1=-1m vt2=1m ropen=ropen_mix rclosed=rclosed_mix
EMIXQ_c024_1_10 (mix_q_src_c024_1_10 0 bpf_c024_1 0) vcvs gain=-8.314696123025e-01
SMIXQ_c024_1_10 (mix_q_src_c024_1_10 mix_q_c024_1 win_1_10 0) relay vt1=-1m vt2=1m ropen=ropen_mix rclosed=rclosed_mix
EMIXI_c024_1_11 (mix_i_src_c024_1_11 0 bpf_c024_1 0) vcvs gain=-1.950903220161e-01
SMIXI_c024_1_11 (mix_i_src_c024_1_11 mix_i_c024_1 win_1_11 0) relay vt1=-1m vt2=1m ropen=ropen_mix rclosed=rclosed_mix
EMIXQ_c024_1_11 (mix_q_src_c024_1_11 0 bpf_c024_1 0) vcvs gain=-9.807852804032e-01
SMIXQ_c024_1_11 (mix_q_src_c024_1_11 mix_q_c024_1 win_1_11 0) relay vt1=-1m vt2=1m ropen=ropen_mix rclosed=rclosed_mix
EMIXI_c024_1_12 (mix_i_src_c024_1_12 0 bpf_c024_1 0) vcvs gain=1.950903220161e-01
SMIXI_c024_1_12 (mix_i_src_c024_1_12 mix_i_c024_1 win_1_12 0) relay vt1=-1m vt2=1m ropen=ropen_mix rclosed=rclosed_mix
EMIXQ_c024_1_12 (mix_q_src_c024_1_12 0 bpf_c024_1 0) vcvs gain=-9.807852804032e-01
SMIXQ_c024_1_12 (mix_q_src_c024_1_12 mix_q_c024_1 win_1_12 0) relay vt1=-1m vt2=1m ropen=ropen_mix rclosed=rclosed_mix
EMIXI_c024_1_13 (mix_i_src_c024_1_13 0 bpf_c024_1 0) vcvs gain=5.555702330196e-01
SMIXI_c024_1_13 (mix_i_src_c024_1_13 mix_i_c024_1 win_1_13 0) relay vt1=-1m vt2=1m ropen=ropen_mix rclosed=rclosed_mix
EMIXQ_c024_1_13 (mix_q_src_c024_1_13 0 bpf_c024_1 0) vcvs gain=-8.314696123025e-01
SMIXQ_c024_1_13 (mix_q_src_c024_1_13 mix_q_c024_1 win_1_13 0) relay vt1=-1m vt2=1m ropen=ropen_mix rclosed=rclosed_mix
EMIXI_c024_1_14 (mix_i_src_c024_1_14 0 bpf_c024_1 0) vcvs gain=8.314696123025e-01
SMIXI_c024_1_14 (mix_i_src_c024_1_14 mix_i_c024_1 win_1_14 0) relay vt1=-1m vt2=1m ropen=ropen_mix rclosed=rclosed_mix
EMIXQ_c024_1_14 (mix_q_src_c024_1_14 0 bpf_c024_1 0) vcvs gain=-5.555702330196e-01
SMIXQ_c024_1_14 (mix_q_src_c024_1_14 mix_q_c024_1 win_1_14 0) relay vt1=-1m vt2=1m ropen=ropen_mix rclosed=rclosed_mix
EMIXI_c024_1_15 (mix_i_src_c024_1_15 0 bpf_c024_1 0) vcvs gain=9.807852804032e-01
SMIXI_c024_1_15 (mix_i_src_c024_1_15 mix_i_c024_1 win_1_15 0) relay vt1=-1m vt2=1m ropen=ropen_mix rclosed=rclosed_mix
EMIXQ_c024_1_15 (mix_q_src_c024_1_15 0 bpf_c024_1 0) vcvs gain=-1.950903220161e-01
SMIXQ_c024_1_15 (mix_q_src_c024_1_15 mix_q_c024_1 win_1_15 0) relay vt1=-1m vt2=1m ropen=ropen_mix rclosed=rclosed_mix
RMIXI_c024_1 (mix_i_c024_1 0) resistor r=1G
RMIXQ_c024_1 (mix_q_c024_1 0) resistor r=1G
RINTI_c024_1 (mix_i_c024_1 Icar_c024_1) resistor r=1k
CINTI_c024_1 (Icar_c024_1 0) capacitor c=80p
RINTQ_c024_1 (mix_q_c024_1 Qcar_c024_1) resistor r=1k
CINTQ_c024_1 (Qcar_c024_1 0) capacitor c=80p
save bpf_c024_1 Icar_c024_1 Qcar_c024_1

// bl024, carrier_2: 750000000 Hz coherent I/Q phase-window verification-demod path
CBPF_c024_2 (bl024 n_cbpf_c024_2) capacitor c=4.503163717437e-14
LBPF_c024_2 (n_cbpf_c024_2 bpf_c024_2) inductor l=1.000000000000e-06
RBPF_c024_2 (bpf_c024_2 0) resistor r=2.356194490192e+02
EMIXI_c024_2_00 (mix_i_src_c024_2_00 0 bpf_c024_2 0) vcvs gain=9.807852804032e-01
SMIXI_c024_2_00 (mix_i_src_c024_2_00 mix_i_c024_2 win_2_00 0) relay vt1=-1m vt2=1m ropen=ropen_mix rclosed=rclosed_mix
EMIXQ_c024_2_00 (mix_q_src_c024_2_00 0 bpf_c024_2 0) vcvs gain=1.950903220161e-01
SMIXQ_c024_2_00 (mix_q_src_c024_2_00 mix_q_c024_2 win_2_00 0) relay vt1=-1m vt2=1m ropen=ropen_mix rclosed=rclosed_mix
EMIXI_c024_2_01 (mix_i_src_c024_2_01 0 bpf_c024_2 0) vcvs gain=8.314696123025e-01
SMIXI_c024_2_01 (mix_i_src_c024_2_01 mix_i_c024_2 win_2_01 0) relay vt1=-1m vt2=1m ropen=ropen_mix rclosed=rclosed_mix
EMIXQ_c024_2_01 (mix_q_src_c024_2_01 0 bpf_c024_2 0) vcvs gain=5.555702330196e-01
SMIXQ_c024_2_01 (mix_q_src_c024_2_01 mix_q_c024_2 win_2_01 0) relay vt1=-1m vt2=1m ropen=ropen_mix rclosed=rclosed_mix
EMIXI_c024_2_02 (mix_i_src_c024_2_02 0 bpf_c024_2 0) vcvs gain=5.555702330196e-01
SMIXI_c024_2_02 (mix_i_src_c024_2_02 mix_i_c024_2 win_2_02 0) relay vt1=-1m vt2=1m ropen=ropen_mix rclosed=rclosed_mix
EMIXQ_c024_2_02 (mix_q_src_c024_2_02 0 bpf_c024_2 0) vcvs gain=8.314696123025e-01
SMIXQ_c024_2_02 (mix_q_src_c024_2_02 mix_q_c024_2 win_2_02 0) relay vt1=-1m vt2=1m ropen=ropen_mix rclosed=rclosed_mix
EMIXI_c024_2_03 (mix_i_src_c024_2_03 0 bpf_c024_2 0) vcvs gain=1.950903220161e-01
SMIXI_c024_2_03 (mix_i_src_c024_2_03 mix_i_c024_2 win_2_03 0) relay vt1=-1m vt2=1m ropen=ropen_mix rclosed=rclosed_mix
EMIXQ_c024_2_03 (mix_q_src_c024_2_03 0 bpf_c024_2 0) vcvs gain=9.807852804032e-01
SMIXQ_c024_2_03 (mix_q_src_c024_2_03 mix_q_c024_2 win_2_03 0) relay vt1=-1m vt2=1m ropen=ropen_mix rclosed=rclosed_mix
EMIXI_c024_2_04 (mix_i_src_c024_2_04 0 bpf_c024_2 0) vcvs gain=-1.950903220161e-01
SMIXI_c024_2_04 (mix_i_src_c024_2_04 mix_i_c024_2 win_2_04 0) relay vt1=-1m vt2=1m ropen=ropen_mix rclosed=rclosed_mix
EMIXQ_c024_2_04 (mix_q_src_c024_2_04 0 bpf_c024_2 0) vcvs gain=9.807852804032e-01
SMIXQ_c024_2_04 (mix_q_src_c024_2_04 mix_q_c024_2 win_2_04 0) relay vt1=-1m vt2=1m ropen=ropen_mix rclosed=rclosed_mix
EMIXI_c024_2_05 (mix_i_src_c024_2_05 0 bpf_c024_2 0) vcvs gain=-5.555702330196e-01
SMIXI_c024_2_05 (mix_i_src_c024_2_05 mix_i_c024_2 win_2_05 0) relay vt1=-1m vt2=1m ropen=ropen_mix rclosed=rclosed_mix
EMIXQ_c024_2_05 (mix_q_src_c024_2_05 0 bpf_c024_2 0) vcvs gain=8.314696123025e-01
SMIXQ_c024_2_05 (mix_q_src_c024_2_05 mix_q_c024_2 win_2_05 0) relay vt1=-1m vt2=1m ropen=ropen_mix rclosed=rclosed_mix
EMIXI_c024_2_06 (mix_i_src_c024_2_06 0 bpf_c024_2 0) vcvs gain=-8.314696123025e-01
SMIXI_c024_2_06 (mix_i_src_c024_2_06 mix_i_c024_2 win_2_06 0) relay vt1=-1m vt2=1m ropen=ropen_mix rclosed=rclosed_mix
EMIXQ_c024_2_06 (mix_q_src_c024_2_06 0 bpf_c024_2 0) vcvs gain=5.555702330196e-01
SMIXQ_c024_2_06 (mix_q_src_c024_2_06 mix_q_c024_2 win_2_06 0) relay vt1=-1m vt2=1m ropen=ropen_mix rclosed=rclosed_mix
EMIXI_c024_2_07 (mix_i_src_c024_2_07 0 bpf_c024_2 0) vcvs gain=-9.807852804032e-01
SMIXI_c024_2_07 (mix_i_src_c024_2_07 mix_i_c024_2 win_2_07 0) relay vt1=-1m vt2=1m ropen=ropen_mix rclosed=rclosed_mix
EMIXQ_c024_2_07 (mix_q_src_c024_2_07 0 bpf_c024_2 0) vcvs gain=1.950903220161e-01
SMIXQ_c024_2_07 (mix_q_src_c024_2_07 mix_q_c024_2 win_2_07 0) relay vt1=-1m vt2=1m ropen=ropen_mix rclosed=rclosed_mix
EMIXI_c024_2_08 (mix_i_src_c024_2_08 0 bpf_c024_2 0) vcvs gain=-9.807852804032e-01
SMIXI_c024_2_08 (mix_i_src_c024_2_08 mix_i_c024_2 win_2_08 0) relay vt1=-1m vt2=1m ropen=ropen_mix rclosed=rclosed_mix
EMIXQ_c024_2_08 (mix_q_src_c024_2_08 0 bpf_c024_2 0) vcvs gain=-1.950903220161e-01
SMIXQ_c024_2_08 (mix_q_src_c024_2_08 mix_q_c024_2 win_2_08 0) relay vt1=-1m vt2=1m ropen=ropen_mix rclosed=rclosed_mix
EMIXI_c024_2_09 (mix_i_src_c024_2_09 0 bpf_c024_2 0) vcvs gain=-8.314696123025e-01
SMIXI_c024_2_09 (mix_i_src_c024_2_09 mix_i_c024_2 win_2_09 0) relay vt1=-1m vt2=1m ropen=ropen_mix rclosed=rclosed_mix
EMIXQ_c024_2_09 (mix_q_src_c024_2_09 0 bpf_c024_2 0) vcvs gain=-5.555702330196e-01
SMIXQ_c024_2_09 (mix_q_src_c024_2_09 mix_q_c024_2 win_2_09 0) relay vt1=-1m vt2=1m ropen=ropen_mix rclosed=rclosed_mix
EMIXI_c024_2_10 (mix_i_src_c024_2_10 0 bpf_c024_2 0) vcvs gain=-5.555702330196e-01
SMIXI_c024_2_10 (mix_i_src_c024_2_10 mix_i_c024_2 win_2_10 0) relay vt1=-1m vt2=1m ropen=ropen_mix rclosed=rclosed_mix
EMIXQ_c024_2_10 (mix_q_src_c024_2_10 0 bpf_c024_2 0) vcvs gain=-8.314696123025e-01
SMIXQ_c024_2_10 (mix_q_src_c024_2_10 mix_q_c024_2 win_2_10 0) relay vt1=-1m vt2=1m ropen=ropen_mix rclosed=rclosed_mix
EMIXI_c024_2_11 (mix_i_src_c024_2_11 0 bpf_c024_2 0) vcvs gain=-1.950903220161e-01
SMIXI_c024_2_11 (mix_i_src_c024_2_11 mix_i_c024_2 win_2_11 0) relay vt1=-1m vt2=1m ropen=ropen_mix rclosed=rclosed_mix
EMIXQ_c024_2_11 (mix_q_src_c024_2_11 0 bpf_c024_2 0) vcvs gain=-9.807852804032e-01
SMIXQ_c024_2_11 (mix_q_src_c024_2_11 mix_q_c024_2 win_2_11 0) relay vt1=-1m vt2=1m ropen=ropen_mix rclosed=rclosed_mix
EMIXI_c024_2_12 (mix_i_src_c024_2_12 0 bpf_c024_2 0) vcvs gain=1.950903220161e-01
SMIXI_c024_2_12 (mix_i_src_c024_2_12 mix_i_c024_2 win_2_12 0) relay vt1=-1m vt2=1m ropen=ropen_mix rclosed=rclosed_mix
EMIXQ_c024_2_12 (mix_q_src_c024_2_12 0 bpf_c024_2 0) vcvs gain=-9.807852804032e-01
SMIXQ_c024_2_12 (mix_q_src_c024_2_12 mix_q_c024_2 win_2_12 0) relay vt1=-1m vt2=1m ropen=ropen_mix rclosed=rclosed_mix
EMIXI_c024_2_13 (mix_i_src_c024_2_13 0 bpf_c024_2 0) vcvs gain=5.555702330196e-01
SMIXI_c024_2_13 (mix_i_src_c024_2_13 mix_i_c024_2 win_2_13 0) relay vt1=-1m vt2=1m ropen=ropen_mix rclosed=rclosed_mix
EMIXQ_c024_2_13 (mix_q_src_c024_2_13 0 bpf_c024_2 0) vcvs gain=-8.314696123025e-01
SMIXQ_c024_2_13 (mix_q_src_c024_2_13 mix_q_c024_2 win_2_13 0) relay vt1=-1m vt2=1m ropen=ropen_mix rclosed=rclosed_mix
EMIXI_c024_2_14 (mix_i_src_c024_2_14 0 bpf_c024_2 0) vcvs gain=8.314696123025e-01
SMIXI_c024_2_14 (mix_i_src_c024_2_14 mix_i_c024_2 win_2_14 0) relay vt1=-1m vt2=1m ropen=ropen_mix rclosed=rclosed_mix
EMIXQ_c024_2_14 (mix_q_src_c024_2_14 0 bpf_c024_2 0) vcvs gain=-5.555702330196e-01
SMIXQ_c024_2_14 (mix_q_src_c024_2_14 mix_q_c024_2 win_2_14 0) relay vt1=-1m vt2=1m ropen=ropen_mix rclosed=rclosed_mix
EMIXI_c024_2_15 (mix_i_src_c024_2_15 0 bpf_c024_2 0) vcvs gain=9.807852804032e-01
SMIXI_c024_2_15 (mix_i_src_c024_2_15 mix_i_c024_2 win_2_15 0) relay vt1=-1m vt2=1m ropen=ropen_mix rclosed=rclosed_mix
EMIXQ_c024_2_15 (mix_q_src_c024_2_15 0 bpf_c024_2 0) vcvs gain=-1.950903220161e-01
SMIXQ_c024_2_15 (mix_q_src_c024_2_15 mix_q_c024_2 win_2_15 0) relay vt1=-1m vt2=1m ropen=ropen_mix rclosed=rclosed_mix
RMIXI_c024_2 (mix_i_c024_2 0) resistor r=1G
RMIXQ_c024_2 (mix_q_c024_2 0) resistor r=1G
RINTI_c024_2 (mix_i_c024_2 Icar_c024_2) resistor r=1k
CINTI_c024_2 (Icar_c024_2 0) capacitor c=80p
RINTQ_c024_2 (mix_q_c024_2 Qcar_c024_2) resistor r=1k
CINTQ_c024_2 (Qcar_c024_2 0) capacitor c=80p
save bpf_c024_2 Icar_c024_2 Qcar_c024_2

// bl024, carrier_3: 1000000000 Hz coherent I/Q phase-window verification-demod path
CBPF_c024_3 (bl024 n_cbpf_c024_3) capacitor c=2.533029591058e-14
LBPF_c024_3 (n_cbpf_c024_3 bpf_c024_3) inductor l=1.000000000000e-06
RBPF_c024_3 (bpf_c024_3 0) resistor r=3.141592653590e+02
EMIXI_c024_3_00 (mix_i_src_c024_3_00 0 bpf_c024_3 0) vcvs gain=9.807852804032e-01
SMIXI_c024_3_00 (mix_i_src_c024_3_00 mix_i_c024_3 win_3_00 0) relay vt1=-1m vt2=1m ropen=ropen_mix rclosed=rclosed_mix
EMIXQ_c024_3_00 (mix_q_src_c024_3_00 0 bpf_c024_3 0) vcvs gain=1.950903220161e-01
SMIXQ_c024_3_00 (mix_q_src_c024_3_00 mix_q_c024_3 win_3_00 0) relay vt1=-1m vt2=1m ropen=ropen_mix rclosed=rclosed_mix
EMIXI_c024_3_01 (mix_i_src_c024_3_01 0 bpf_c024_3 0) vcvs gain=8.314696123025e-01
SMIXI_c024_3_01 (mix_i_src_c024_3_01 mix_i_c024_3 win_3_01 0) relay vt1=-1m vt2=1m ropen=ropen_mix rclosed=rclosed_mix
EMIXQ_c024_3_01 (mix_q_src_c024_3_01 0 bpf_c024_3 0) vcvs gain=5.555702330196e-01
SMIXQ_c024_3_01 (mix_q_src_c024_3_01 mix_q_c024_3 win_3_01 0) relay vt1=-1m vt2=1m ropen=ropen_mix rclosed=rclosed_mix
EMIXI_c024_3_02 (mix_i_src_c024_3_02 0 bpf_c024_3 0) vcvs gain=5.555702330196e-01
SMIXI_c024_3_02 (mix_i_src_c024_3_02 mix_i_c024_3 win_3_02 0) relay vt1=-1m vt2=1m ropen=ropen_mix rclosed=rclosed_mix
EMIXQ_c024_3_02 (mix_q_src_c024_3_02 0 bpf_c024_3 0) vcvs gain=8.314696123025e-01
SMIXQ_c024_3_02 (mix_q_src_c024_3_02 mix_q_c024_3 win_3_02 0) relay vt1=-1m vt2=1m ropen=ropen_mix rclosed=rclosed_mix
EMIXI_c024_3_03 (mix_i_src_c024_3_03 0 bpf_c024_3 0) vcvs gain=1.950903220161e-01
SMIXI_c024_3_03 (mix_i_src_c024_3_03 mix_i_c024_3 win_3_03 0) relay vt1=-1m vt2=1m ropen=ropen_mix rclosed=rclosed_mix
EMIXQ_c024_3_03 (mix_q_src_c024_3_03 0 bpf_c024_3 0) vcvs gain=9.807852804032e-01
SMIXQ_c024_3_03 (mix_q_src_c024_3_03 mix_q_c024_3 win_3_03 0) relay vt1=-1m vt2=1m ropen=ropen_mix rclosed=rclosed_mix
EMIXI_c024_3_04 (mix_i_src_c024_3_04 0 bpf_c024_3 0) vcvs gain=-1.950903220161e-01
SMIXI_c024_3_04 (mix_i_src_c024_3_04 mix_i_c024_3 win_3_04 0) relay vt1=-1m vt2=1m ropen=ropen_mix rclosed=rclosed_mix
EMIXQ_c024_3_04 (mix_q_src_c024_3_04 0 bpf_c024_3 0) vcvs gain=9.807852804032e-01
SMIXQ_c024_3_04 (mix_q_src_c024_3_04 mix_q_c024_3 win_3_04 0) relay vt1=-1m vt2=1m ropen=ropen_mix rclosed=rclosed_mix
EMIXI_c024_3_05 (mix_i_src_c024_3_05 0 bpf_c024_3 0) vcvs gain=-5.555702330196e-01
SMIXI_c024_3_05 (mix_i_src_c024_3_05 mix_i_c024_3 win_3_05 0) relay vt1=-1m vt2=1m ropen=ropen_mix rclosed=rclosed_mix
EMIXQ_c024_3_05 (mix_q_src_c024_3_05 0 bpf_c024_3 0) vcvs gain=8.314696123025e-01
SMIXQ_c024_3_05 (mix_q_src_c024_3_05 mix_q_c024_3 win_3_05 0) relay vt1=-1m vt2=1m ropen=ropen_mix rclosed=rclosed_mix
EMIXI_c024_3_06 (mix_i_src_c024_3_06 0 bpf_c024_3 0) vcvs gain=-8.314696123025e-01
SMIXI_c024_3_06 (mix_i_src_c024_3_06 mix_i_c024_3 win_3_06 0) relay vt1=-1m vt2=1m ropen=ropen_mix rclosed=rclosed_mix
EMIXQ_c024_3_06 (mix_q_src_c024_3_06 0 bpf_c024_3 0) vcvs gain=5.555702330196e-01
SMIXQ_c024_3_06 (mix_q_src_c024_3_06 mix_q_c024_3 win_3_06 0) relay vt1=-1m vt2=1m ropen=ropen_mix rclosed=rclosed_mix
EMIXI_c024_3_07 (mix_i_src_c024_3_07 0 bpf_c024_3 0) vcvs gain=-9.807852804032e-01
SMIXI_c024_3_07 (mix_i_src_c024_3_07 mix_i_c024_3 win_3_07 0) relay vt1=-1m vt2=1m ropen=ropen_mix rclosed=rclosed_mix
EMIXQ_c024_3_07 (mix_q_src_c024_3_07 0 bpf_c024_3 0) vcvs gain=1.950903220161e-01
SMIXQ_c024_3_07 (mix_q_src_c024_3_07 mix_q_c024_3 win_3_07 0) relay vt1=-1m vt2=1m ropen=ropen_mix rclosed=rclosed_mix
EMIXI_c024_3_08 (mix_i_src_c024_3_08 0 bpf_c024_3 0) vcvs gain=-9.807852804032e-01
SMIXI_c024_3_08 (mix_i_src_c024_3_08 mix_i_c024_3 win_3_08 0) relay vt1=-1m vt2=1m ropen=ropen_mix rclosed=rclosed_mix
EMIXQ_c024_3_08 (mix_q_src_c024_3_08 0 bpf_c024_3 0) vcvs gain=-1.950903220161e-01
SMIXQ_c024_3_08 (mix_q_src_c024_3_08 mix_q_c024_3 win_3_08 0) relay vt1=-1m vt2=1m ropen=ropen_mix rclosed=rclosed_mix
EMIXI_c024_3_09 (mix_i_src_c024_3_09 0 bpf_c024_3 0) vcvs gain=-8.314696123025e-01
SMIXI_c024_3_09 (mix_i_src_c024_3_09 mix_i_c024_3 win_3_09 0) relay vt1=-1m vt2=1m ropen=ropen_mix rclosed=rclosed_mix
EMIXQ_c024_3_09 (mix_q_src_c024_3_09 0 bpf_c024_3 0) vcvs gain=-5.555702330196e-01
SMIXQ_c024_3_09 (mix_q_src_c024_3_09 mix_q_c024_3 win_3_09 0) relay vt1=-1m vt2=1m ropen=ropen_mix rclosed=rclosed_mix
EMIXI_c024_3_10 (mix_i_src_c024_3_10 0 bpf_c024_3 0) vcvs gain=-5.555702330196e-01
SMIXI_c024_3_10 (mix_i_src_c024_3_10 mix_i_c024_3 win_3_10 0) relay vt1=-1m vt2=1m ropen=ropen_mix rclosed=rclosed_mix
EMIXQ_c024_3_10 (mix_q_src_c024_3_10 0 bpf_c024_3 0) vcvs gain=-8.314696123025e-01
SMIXQ_c024_3_10 (mix_q_src_c024_3_10 mix_q_c024_3 win_3_10 0) relay vt1=-1m vt2=1m ropen=ropen_mix rclosed=rclosed_mix
EMIXI_c024_3_11 (mix_i_src_c024_3_11 0 bpf_c024_3 0) vcvs gain=-1.950903220161e-01
SMIXI_c024_3_11 (mix_i_src_c024_3_11 mix_i_c024_3 win_3_11 0) relay vt1=-1m vt2=1m ropen=ropen_mix rclosed=rclosed_mix
EMIXQ_c024_3_11 (mix_q_src_c024_3_11 0 bpf_c024_3 0) vcvs gain=-9.807852804032e-01
SMIXQ_c024_3_11 (mix_q_src_c024_3_11 mix_q_c024_3 win_3_11 0) relay vt1=-1m vt2=1m ropen=ropen_mix rclosed=rclosed_mix
EMIXI_c024_3_12 (mix_i_src_c024_3_12 0 bpf_c024_3 0) vcvs gain=1.950903220161e-01
SMIXI_c024_3_12 (mix_i_src_c024_3_12 mix_i_c024_3 win_3_12 0) relay vt1=-1m vt2=1m ropen=ropen_mix rclosed=rclosed_mix
EMIXQ_c024_3_12 (mix_q_src_c024_3_12 0 bpf_c024_3 0) vcvs gain=-9.807852804032e-01
SMIXQ_c024_3_12 (mix_q_src_c024_3_12 mix_q_c024_3 win_3_12 0) relay vt1=-1m vt2=1m ropen=ropen_mix rclosed=rclosed_mix
EMIXI_c024_3_13 (mix_i_src_c024_3_13 0 bpf_c024_3 0) vcvs gain=5.555702330196e-01
SMIXI_c024_3_13 (mix_i_src_c024_3_13 mix_i_c024_3 win_3_13 0) relay vt1=-1m vt2=1m ropen=ropen_mix rclosed=rclosed_mix
EMIXQ_c024_3_13 (mix_q_src_c024_3_13 0 bpf_c024_3 0) vcvs gain=-8.314696123025e-01
SMIXQ_c024_3_13 (mix_q_src_c024_3_13 mix_q_c024_3 win_3_13 0) relay vt1=-1m vt2=1m ropen=ropen_mix rclosed=rclosed_mix
EMIXI_c024_3_14 (mix_i_src_c024_3_14 0 bpf_c024_3 0) vcvs gain=8.314696123025e-01
SMIXI_c024_3_14 (mix_i_src_c024_3_14 mix_i_c024_3 win_3_14 0) relay vt1=-1m vt2=1m ropen=ropen_mix rclosed=rclosed_mix
EMIXQ_c024_3_14 (mix_q_src_c024_3_14 0 bpf_c024_3 0) vcvs gain=-5.555702330196e-01
SMIXQ_c024_3_14 (mix_q_src_c024_3_14 mix_q_c024_3 win_3_14 0) relay vt1=-1m vt2=1m ropen=ropen_mix rclosed=rclosed_mix
EMIXI_c024_3_15 (mix_i_src_c024_3_15 0 bpf_c024_3 0) vcvs gain=9.807852804032e-01
SMIXI_c024_3_15 (mix_i_src_c024_3_15 mix_i_c024_3 win_3_15 0) relay vt1=-1m vt2=1m ropen=ropen_mix rclosed=rclosed_mix
EMIXQ_c024_3_15 (mix_q_src_c024_3_15 0 bpf_c024_3 0) vcvs gain=-1.950903220161e-01
SMIXQ_c024_3_15 (mix_q_src_c024_3_15 mix_q_c024_3 win_3_15 0) relay vt1=-1m vt2=1m ropen=ropen_mix rclosed=rclosed_mix
RMIXI_c024_3 (mix_i_c024_3 0) resistor r=1G
RMIXQ_c024_3 (mix_q_c024_3 0) resistor r=1G
RINTI_c024_3 (mix_i_c024_3 Icar_c024_3) resistor r=1k
CINTI_c024_3 (Icar_c024_3 0) capacitor c=80p
RINTQ_c024_3 (mix_q_c024_3 Qcar_c024_3) resistor r=1k
CINTQ_c024_3 (Qcar_c024_3 0) capacitor c=80p
save bpf_c024_3 Icar_c024_3 Qcar_c024_3

// bl025, carrier_0: 250000000 Hz coherent I/Q phase-window verification-demod path
CBPF_c025_0 (bl025 n_cbpf_c025_0) capacitor c=4.052847345694e-13
LBPF_c025_0 (n_cbpf_c025_0 bpf_c025_0) inductor l=1.000000000000e-06
RBPF_c025_0 (bpf_c025_0 0) resistor r=7.853981633974e+01
EMIXI_c025_0_00 (mix_i_src_c025_0_00 0 bpf_c025_0 0) vcvs gain=9.807852804032e-01
SMIXI_c025_0_00 (mix_i_src_c025_0_00 mix_i_c025_0 win_0_00 0) relay vt1=-1m vt2=1m ropen=ropen_mix rclosed=rclosed_mix
EMIXQ_c025_0_00 (mix_q_src_c025_0_00 0 bpf_c025_0 0) vcvs gain=1.950903220161e-01
SMIXQ_c025_0_00 (mix_q_src_c025_0_00 mix_q_c025_0 win_0_00 0) relay vt1=-1m vt2=1m ropen=ropen_mix rclosed=rclosed_mix
EMIXI_c025_0_01 (mix_i_src_c025_0_01 0 bpf_c025_0 0) vcvs gain=8.314696123025e-01
SMIXI_c025_0_01 (mix_i_src_c025_0_01 mix_i_c025_0 win_0_01 0) relay vt1=-1m vt2=1m ropen=ropen_mix rclosed=rclosed_mix
EMIXQ_c025_0_01 (mix_q_src_c025_0_01 0 bpf_c025_0 0) vcvs gain=5.555702330196e-01
SMIXQ_c025_0_01 (mix_q_src_c025_0_01 mix_q_c025_0 win_0_01 0) relay vt1=-1m vt2=1m ropen=ropen_mix rclosed=rclosed_mix
EMIXI_c025_0_02 (mix_i_src_c025_0_02 0 bpf_c025_0 0) vcvs gain=5.555702330196e-01
SMIXI_c025_0_02 (mix_i_src_c025_0_02 mix_i_c025_0 win_0_02 0) relay vt1=-1m vt2=1m ropen=ropen_mix rclosed=rclosed_mix
EMIXQ_c025_0_02 (mix_q_src_c025_0_02 0 bpf_c025_0 0) vcvs gain=8.314696123025e-01
SMIXQ_c025_0_02 (mix_q_src_c025_0_02 mix_q_c025_0 win_0_02 0) relay vt1=-1m vt2=1m ropen=ropen_mix rclosed=rclosed_mix
EMIXI_c025_0_03 (mix_i_src_c025_0_03 0 bpf_c025_0 0) vcvs gain=1.950903220161e-01
SMIXI_c025_0_03 (mix_i_src_c025_0_03 mix_i_c025_0 win_0_03 0) relay vt1=-1m vt2=1m ropen=ropen_mix rclosed=rclosed_mix
EMIXQ_c025_0_03 (mix_q_src_c025_0_03 0 bpf_c025_0 0) vcvs gain=9.807852804032e-01
SMIXQ_c025_0_03 (mix_q_src_c025_0_03 mix_q_c025_0 win_0_03 0) relay vt1=-1m vt2=1m ropen=ropen_mix rclosed=rclosed_mix
EMIXI_c025_0_04 (mix_i_src_c025_0_04 0 bpf_c025_0 0) vcvs gain=-1.950903220161e-01
SMIXI_c025_0_04 (mix_i_src_c025_0_04 mix_i_c025_0 win_0_04 0) relay vt1=-1m vt2=1m ropen=ropen_mix rclosed=rclosed_mix
EMIXQ_c025_0_04 (mix_q_src_c025_0_04 0 bpf_c025_0 0) vcvs gain=9.807852804032e-01
SMIXQ_c025_0_04 (mix_q_src_c025_0_04 mix_q_c025_0 win_0_04 0) relay vt1=-1m vt2=1m ropen=ropen_mix rclosed=rclosed_mix
EMIXI_c025_0_05 (mix_i_src_c025_0_05 0 bpf_c025_0 0) vcvs gain=-5.555702330196e-01
SMIXI_c025_0_05 (mix_i_src_c025_0_05 mix_i_c025_0 win_0_05 0) relay vt1=-1m vt2=1m ropen=ropen_mix rclosed=rclosed_mix
EMIXQ_c025_0_05 (mix_q_src_c025_0_05 0 bpf_c025_0 0) vcvs gain=8.314696123025e-01
SMIXQ_c025_0_05 (mix_q_src_c025_0_05 mix_q_c025_0 win_0_05 0) relay vt1=-1m vt2=1m ropen=ropen_mix rclosed=rclosed_mix
EMIXI_c025_0_06 (mix_i_src_c025_0_06 0 bpf_c025_0 0) vcvs gain=-8.314696123025e-01
SMIXI_c025_0_06 (mix_i_src_c025_0_06 mix_i_c025_0 win_0_06 0) relay vt1=-1m vt2=1m ropen=ropen_mix rclosed=rclosed_mix
EMIXQ_c025_0_06 (mix_q_src_c025_0_06 0 bpf_c025_0 0) vcvs gain=5.555702330196e-01
SMIXQ_c025_0_06 (mix_q_src_c025_0_06 mix_q_c025_0 win_0_06 0) relay vt1=-1m vt2=1m ropen=ropen_mix rclosed=rclosed_mix
EMIXI_c025_0_07 (mix_i_src_c025_0_07 0 bpf_c025_0 0) vcvs gain=-9.807852804032e-01
SMIXI_c025_0_07 (mix_i_src_c025_0_07 mix_i_c025_0 win_0_07 0) relay vt1=-1m vt2=1m ropen=ropen_mix rclosed=rclosed_mix
EMIXQ_c025_0_07 (mix_q_src_c025_0_07 0 bpf_c025_0 0) vcvs gain=1.950903220161e-01
SMIXQ_c025_0_07 (mix_q_src_c025_0_07 mix_q_c025_0 win_0_07 0) relay vt1=-1m vt2=1m ropen=ropen_mix rclosed=rclosed_mix
EMIXI_c025_0_08 (mix_i_src_c025_0_08 0 bpf_c025_0 0) vcvs gain=-9.807852804032e-01
SMIXI_c025_0_08 (mix_i_src_c025_0_08 mix_i_c025_0 win_0_08 0) relay vt1=-1m vt2=1m ropen=ropen_mix rclosed=rclosed_mix
EMIXQ_c025_0_08 (mix_q_src_c025_0_08 0 bpf_c025_0 0) vcvs gain=-1.950903220161e-01
SMIXQ_c025_0_08 (mix_q_src_c025_0_08 mix_q_c025_0 win_0_08 0) relay vt1=-1m vt2=1m ropen=ropen_mix rclosed=rclosed_mix
EMIXI_c025_0_09 (mix_i_src_c025_0_09 0 bpf_c025_0 0) vcvs gain=-8.314696123025e-01
SMIXI_c025_0_09 (mix_i_src_c025_0_09 mix_i_c025_0 win_0_09 0) relay vt1=-1m vt2=1m ropen=ropen_mix rclosed=rclosed_mix
EMIXQ_c025_0_09 (mix_q_src_c025_0_09 0 bpf_c025_0 0) vcvs gain=-5.555702330196e-01
SMIXQ_c025_0_09 (mix_q_src_c025_0_09 mix_q_c025_0 win_0_09 0) relay vt1=-1m vt2=1m ropen=ropen_mix rclosed=rclosed_mix
EMIXI_c025_0_10 (mix_i_src_c025_0_10 0 bpf_c025_0 0) vcvs gain=-5.555702330196e-01
SMIXI_c025_0_10 (mix_i_src_c025_0_10 mix_i_c025_0 win_0_10 0) relay vt1=-1m vt2=1m ropen=ropen_mix rclosed=rclosed_mix
EMIXQ_c025_0_10 (mix_q_src_c025_0_10 0 bpf_c025_0 0) vcvs gain=-8.314696123025e-01
SMIXQ_c025_0_10 (mix_q_src_c025_0_10 mix_q_c025_0 win_0_10 0) relay vt1=-1m vt2=1m ropen=ropen_mix rclosed=rclosed_mix
EMIXI_c025_0_11 (mix_i_src_c025_0_11 0 bpf_c025_0 0) vcvs gain=-1.950903220161e-01
SMIXI_c025_0_11 (mix_i_src_c025_0_11 mix_i_c025_0 win_0_11 0) relay vt1=-1m vt2=1m ropen=ropen_mix rclosed=rclosed_mix
EMIXQ_c025_0_11 (mix_q_src_c025_0_11 0 bpf_c025_0 0) vcvs gain=-9.807852804032e-01
SMIXQ_c025_0_11 (mix_q_src_c025_0_11 mix_q_c025_0 win_0_11 0) relay vt1=-1m vt2=1m ropen=ropen_mix rclosed=rclosed_mix
EMIXI_c025_0_12 (mix_i_src_c025_0_12 0 bpf_c025_0 0) vcvs gain=1.950903220161e-01
SMIXI_c025_0_12 (mix_i_src_c025_0_12 mix_i_c025_0 win_0_12 0) relay vt1=-1m vt2=1m ropen=ropen_mix rclosed=rclosed_mix
EMIXQ_c025_0_12 (mix_q_src_c025_0_12 0 bpf_c025_0 0) vcvs gain=-9.807852804032e-01
SMIXQ_c025_0_12 (mix_q_src_c025_0_12 mix_q_c025_0 win_0_12 0) relay vt1=-1m vt2=1m ropen=ropen_mix rclosed=rclosed_mix
EMIXI_c025_0_13 (mix_i_src_c025_0_13 0 bpf_c025_0 0) vcvs gain=5.555702330196e-01
SMIXI_c025_0_13 (mix_i_src_c025_0_13 mix_i_c025_0 win_0_13 0) relay vt1=-1m vt2=1m ropen=ropen_mix rclosed=rclosed_mix
EMIXQ_c025_0_13 (mix_q_src_c025_0_13 0 bpf_c025_0 0) vcvs gain=-8.314696123025e-01
SMIXQ_c025_0_13 (mix_q_src_c025_0_13 mix_q_c025_0 win_0_13 0) relay vt1=-1m vt2=1m ropen=ropen_mix rclosed=rclosed_mix
EMIXI_c025_0_14 (mix_i_src_c025_0_14 0 bpf_c025_0 0) vcvs gain=8.314696123025e-01
SMIXI_c025_0_14 (mix_i_src_c025_0_14 mix_i_c025_0 win_0_14 0) relay vt1=-1m vt2=1m ropen=ropen_mix rclosed=rclosed_mix
EMIXQ_c025_0_14 (mix_q_src_c025_0_14 0 bpf_c025_0 0) vcvs gain=-5.555702330196e-01
SMIXQ_c025_0_14 (mix_q_src_c025_0_14 mix_q_c025_0 win_0_14 0) relay vt1=-1m vt2=1m ropen=ropen_mix rclosed=rclosed_mix
EMIXI_c025_0_15 (mix_i_src_c025_0_15 0 bpf_c025_0 0) vcvs gain=9.807852804032e-01
SMIXI_c025_0_15 (mix_i_src_c025_0_15 mix_i_c025_0 win_0_15 0) relay vt1=-1m vt2=1m ropen=ropen_mix rclosed=rclosed_mix
EMIXQ_c025_0_15 (mix_q_src_c025_0_15 0 bpf_c025_0 0) vcvs gain=-1.950903220161e-01
SMIXQ_c025_0_15 (mix_q_src_c025_0_15 mix_q_c025_0 win_0_15 0) relay vt1=-1m vt2=1m ropen=ropen_mix rclosed=rclosed_mix
RMIXI_c025_0 (mix_i_c025_0 0) resistor r=1G
RMIXQ_c025_0 (mix_q_c025_0 0) resistor r=1G
RINTI_c025_0 (mix_i_c025_0 Icar_c025_0) resistor r=1k
CINTI_c025_0 (Icar_c025_0 0) capacitor c=80p
RINTQ_c025_0 (mix_q_c025_0 Qcar_c025_0) resistor r=1k
CINTQ_c025_0 (Qcar_c025_0 0) capacitor c=80p
save bpf_c025_0 Icar_c025_0 Qcar_c025_0

// bl025, carrier_1: 500000000 Hz coherent I/Q phase-window verification-demod path
CBPF_c025_1 (bl025 n_cbpf_c025_1) capacitor c=1.013211836423e-13
LBPF_c025_1 (n_cbpf_c025_1 bpf_c025_1) inductor l=1.000000000000e-06
RBPF_c025_1 (bpf_c025_1 0) resistor r=1.570796326795e+02
EMIXI_c025_1_00 (mix_i_src_c025_1_00 0 bpf_c025_1 0) vcvs gain=9.807852804032e-01
SMIXI_c025_1_00 (mix_i_src_c025_1_00 mix_i_c025_1 win_1_00 0) relay vt1=-1m vt2=1m ropen=ropen_mix rclosed=rclosed_mix
EMIXQ_c025_1_00 (mix_q_src_c025_1_00 0 bpf_c025_1 0) vcvs gain=1.950903220161e-01
SMIXQ_c025_1_00 (mix_q_src_c025_1_00 mix_q_c025_1 win_1_00 0) relay vt1=-1m vt2=1m ropen=ropen_mix rclosed=rclosed_mix
EMIXI_c025_1_01 (mix_i_src_c025_1_01 0 bpf_c025_1 0) vcvs gain=8.314696123025e-01
SMIXI_c025_1_01 (mix_i_src_c025_1_01 mix_i_c025_1 win_1_01 0) relay vt1=-1m vt2=1m ropen=ropen_mix rclosed=rclosed_mix
EMIXQ_c025_1_01 (mix_q_src_c025_1_01 0 bpf_c025_1 0) vcvs gain=5.555702330196e-01
SMIXQ_c025_1_01 (mix_q_src_c025_1_01 mix_q_c025_1 win_1_01 0) relay vt1=-1m vt2=1m ropen=ropen_mix rclosed=rclosed_mix
EMIXI_c025_1_02 (mix_i_src_c025_1_02 0 bpf_c025_1 0) vcvs gain=5.555702330196e-01
SMIXI_c025_1_02 (mix_i_src_c025_1_02 mix_i_c025_1 win_1_02 0) relay vt1=-1m vt2=1m ropen=ropen_mix rclosed=rclosed_mix
EMIXQ_c025_1_02 (mix_q_src_c025_1_02 0 bpf_c025_1 0) vcvs gain=8.314696123025e-01
SMIXQ_c025_1_02 (mix_q_src_c025_1_02 mix_q_c025_1 win_1_02 0) relay vt1=-1m vt2=1m ropen=ropen_mix rclosed=rclosed_mix
EMIXI_c025_1_03 (mix_i_src_c025_1_03 0 bpf_c025_1 0) vcvs gain=1.950903220161e-01
SMIXI_c025_1_03 (mix_i_src_c025_1_03 mix_i_c025_1 win_1_03 0) relay vt1=-1m vt2=1m ropen=ropen_mix rclosed=rclosed_mix
EMIXQ_c025_1_03 (mix_q_src_c025_1_03 0 bpf_c025_1 0) vcvs gain=9.807852804032e-01
SMIXQ_c025_1_03 (mix_q_src_c025_1_03 mix_q_c025_1 win_1_03 0) relay vt1=-1m vt2=1m ropen=ropen_mix rclosed=rclosed_mix
EMIXI_c025_1_04 (mix_i_src_c025_1_04 0 bpf_c025_1 0) vcvs gain=-1.950903220161e-01
SMIXI_c025_1_04 (mix_i_src_c025_1_04 mix_i_c025_1 win_1_04 0) relay vt1=-1m vt2=1m ropen=ropen_mix rclosed=rclosed_mix
EMIXQ_c025_1_04 (mix_q_src_c025_1_04 0 bpf_c025_1 0) vcvs gain=9.807852804032e-01
SMIXQ_c025_1_04 (mix_q_src_c025_1_04 mix_q_c025_1 win_1_04 0) relay vt1=-1m vt2=1m ropen=ropen_mix rclosed=rclosed_mix
EMIXI_c025_1_05 (mix_i_src_c025_1_05 0 bpf_c025_1 0) vcvs gain=-5.555702330196e-01
SMIXI_c025_1_05 (mix_i_src_c025_1_05 mix_i_c025_1 win_1_05 0) relay vt1=-1m vt2=1m ropen=ropen_mix rclosed=rclosed_mix
EMIXQ_c025_1_05 (mix_q_src_c025_1_05 0 bpf_c025_1 0) vcvs gain=8.314696123025e-01
SMIXQ_c025_1_05 (mix_q_src_c025_1_05 mix_q_c025_1 win_1_05 0) relay vt1=-1m vt2=1m ropen=ropen_mix rclosed=rclosed_mix
EMIXI_c025_1_06 (mix_i_src_c025_1_06 0 bpf_c025_1 0) vcvs gain=-8.314696123025e-01
SMIXI_c025_1_06 (mix_i_src_c025_1_06 mix_i_c025_1 win_1_06 0) relay vt1=-1m vt2=1m ropen=ropen_mix rclosed=rclosed_mix
EMIXQ_c025_1_06 (mix_q_src_c025_1_06 0 bpf_c025_1 0) vcvs gain=5.555702330196e-01
SMIXQ_c025_1_06 (mix_q_src_c025_1_06 mix_q_c025_1 win_1_06 0) relay vt1=-1m vt2=1m ropen=ropen_mix rclosed=rclosed_mix
EMIXI_c025_1_07 (mix_i_src_c025_1_07 0 bpf_c025_1 0) vcvs gain=-9.807852804032e-01
SMIXI_c025_1_07 (mix_i_src_c025_1_07 mix_i_c025_1 win_1_07 0) relay vt1=-1m vt2=1m ropen=ropen_mix rclosed=rclosed_mix
EMIXQ_c025_1_07 (mix_q_src_c025_1_07 0 bpf_c025_1 0) vcvs gain=1.950903220161e-01
SMIXQ_c025_1_07 (mix_q_src_c025_1_07 mix_q_c025_1 win_1_07 0) relay vt1=-1m vt2=1m ropen=ropen_mix rclosed=rclosed_mix
EMIXI_c025_1_08 (mix_i_src_c025_1_08 0 bpf_c025_1 0) vcvs gain=-9.807852804032e-01
SMIXI_c025_1_08 (mix_i_src_c025_1_08 mix_i_c025_1 win_1_08 0) relay vt1=-1m vt2=1m ropen=ropen_mix rclosed=rclosed_mix
EMIXQ_c025_1_08 (mix_q_src_c025_1_08 0 bpf_c025_1 0) vcvs gain=-1.950903220161e-01
SMIXQ_c025_1_08 (mix_q_src_c025_1_08 mix_q_c025_1 win_1_08 0) relay vt1=-1m vt2=1m ropen=ropen_mix rclosed=rclosed_mix
EMIXI_c025_1_09 (mix_i_src_c025_1_09 0 bpf_c025_1 0) vcvs gain=-8.314696123025e-01
SMIXI_c025_1_09 (mix_i_src_c025_1_09 mix_i_c025_1 win_1_09 0) relay vt1=-1m vt2=1m ropen=ropen_mix rclosed=rclosed_mix
EMIXQ_c025_1_09 (mix_q_src_c025_1_09 0 bpf_c025_1 0) vcvs gain=-5.555702330196e-01
SMIXQ_c025_1_09 (mix_q_src_c025_1_09 mix_q_c025_1 win_1_09 0) relay vt1=-1m vt2=1m ropen=ropen_mix rclosed=rclosed_mix
EMIXI_c025_1_10 (mix_i_src_c025_1_10 0 bpf_c025_1 0) vcvs gain=-5.555702330196e-01
SMIXI_c025_1_10 (mix_i_src_c025_1_10 mix_i_c025_1 win_1_10 0) relay vt1=-1m vt2=1m ropen=ropen_mix rclosed=rclosed_mix
EMIXQ_c025_1_10 (mix_q_src_c025_1_10 0 bpf_c025_1 0) vcvs gain=-8.314696123025e-01
SMIXQ_c025_1_10 (mix_q_src_c025_1_10 mix_q_c025_1 win_1_10 0) relay vt1=-1m vt2=1m ropen=ropen_mix rclosed=rclosed_mix
EMIXI_c025_1_11 (mix_i_src_c025_1_11 0 bpf_c025_1 0) vcvs gain=-1.950903220161e-01
SMIXI_c025_1_11 (mix_i_src_c025_1_11 mix_i_c025_1 win_1_11 0) relay vt1=-1m vt2=1m ropen=ropen_mix rclosed=rclosed_mix
EMIXQ_c025_1_11 (mix_q_src_c025_1_11 0 bpf_c025_1 0) vcvs gain=-9.807852804032e-01
SMIXQ_c025_1_11 (mix_q_src_c025_1_11 mix_q_c025_1 win_1_11 0) relay vt1=-1m vt2=1m ropen=ropen_mix rclosed=rclosed_mix
EMIXI_c025_1_12 (mix_i_src_c025_1_12 0 bpf_c025_1 0) vcvs gain=1.950903220161e-01
SMIXI_c025_1_12 (mix_i_src_c025_1_12 mix_i_c025_1 win_1_12 0) relay vt1=-1m vt2=1m ropen=ropen_mix rclosed=rclosed_mix
EMIXQ_c025_1_12 (mix_q_src_c025_1_12 0 bpf_c025_1 0) vcvs gain=-9.807852804032e-01
SMIXQ_c025_1_12 (mix_q_src_c025_1_12 mix_q_c025_1 win_1_12 0) relay vt1=-1m vt2=1m ropen=ropen_mix rclosed=rclosed_mix
EMIXI_c025_1_13 (mix_i_src_c025_1_13 0 bpf_c025_1 0) vcvs gain=5.555702330196e-01
SMIXI_c025_1_13 (mix_i_src_c025_1_13 mix_i_c025_1 win_1_13 0) relay vt1=-1m vt2=1m ropen=ropen_mix rclosed=rclosed_mix
EMIXQ_c025_1_13 (mix_q_src_c025_1_13 0 bpf_c025_1 0) vcvs gain=-8.314696123025e-01
SMIXQ_c025_1_13 (mix_q_src_c025_1_13 mix_q_c025_1 win_1_13 0) relay vt1=-1m vt2=1m ropen=ropen_mix rclosed=rclosed_mix
EMIXI_c025_1_14 (mix_i_src_c025_1_14 0 bpf_c025_1 0) vcvs gain=8.314696123025e-01
SMIXI_c025_1_14 (mix_i_src_c025_1_14 mix_i_c025_1 win_1_14 0) relay vt1=-1m vt2=1m ropen=ropen_mix rclosed=rclosed_mix
EMIXQ_c025_1_14 (mix_q_src_c025_1_14 0 bpf_c025_1 0) vcvs gain=-5.555702330196e-01
SMIXQ_c025_1_14 (mix_q_src_c025_1_14 mix_q_c025_1 win_1_14 0) relay vt1=-1m vt2=1m ropen=ropen_mix rclosed=rclosed_mix
EMIXI_c025_1_15 (mix_i_src_c025_1_15 0 bpf_c025_1 0) vcvs gain=9.807852804032e-01
SMIXI_c025_1_15 (mix_i_src_c025_1_15 mix_i_c025_1 win_1_15 0) relay vt1=-1m vt2=1m ropen=ropen_mix rclosed=rclosed_mix
EMIXQ_c025_1_15 (mix_q_src_c025_1_15 0 bpf_c025_1 0) vcvs gain=-1.950903220161e-01
SMIXQ_c025_1_15 (mix_q_src_c025_1_15 mix_q_c025_1 win_1_15 0) relay vt1=-1m vt2=1m ropen=ropen_mix rclosed=rclosed_mix
RMIXI_c025_1 (mix_i_c025_1 0) resistor r=1G
RMIXQ_c025_1 (mix_q_c025_1 0) resistor r=1G
RINTI_c025_1 (mix_i_c025_1 Icar_c025_1) resistor r=1k
CINTI_c025_1 (Icar_c025_1 0) capacitor c=80p
RINTQ_c025_1 (mix_q_c025_1 Qcar_c025_1) resistor r=1k
CINTQ_c025_1 (Qcar_c025_1 0) capacitor c=80p
save bpf_c025_1 Icar_c025_1 Qcar_c025_1

// bl025, carrier_2: 750000000 Hz coherent I/Q phase-window verification-demod path
CBPF_c025_2 (bl025 n_cbpf_c025_2) capacitor c=4.503163717437e-14
LBPF_c025_2 (n_cbpf_c025_2 bpf_c025_2) inductor l=1.000000000000e-06
RBPF_c025_2 (bpf_c025_2 0) resistor r=2.356194490192e+02
EMIXI_c025_2_00 (mix_i_src_c025_2_00 0 bpf_c025_2 0) vcvs gain=9.807852804032e-01
SMIXI_c025_2_00 (mix_i_src_c025_2_00 mix_i_c025_2 win_2_00 0) relay vt1=-1m vt2=1m ropen=ropen_mix rclosed=rclosed_mix
EMIXQ_c025_2_00 (mix_q_src_c025_2_00 0 bpf_c025_2 0) vcvs gain=1.950903220161e-01
SMIXQ_c025_2_00 (mix_q_src_c025_2_00 mix_q_c025_2 win_2_00 0) relay vt1=-1m vt2=1m ropen=ropen_mix rclosed=rclosed_mix
EMIXI_c025_2_01 (mix_i_src_c025_2_01 0 bpf_c025_2 0) vcvs gain=8.314696123025e-01
SMIXI_c025_2_01 (mix_i_src_c025_2_01 mix_i_c025_2 win_2_01 0) relay vt1=-1m vt2=1m ropen=ropen_mix rclosed=rclosed_mix
EMIXQ_c025_2_01 (mix_q_src_c025_2_01 0 bpf_c025_2 0) vcvs gain=5.555702330196e-01
SMIXQ_c025_2_01 (mix_q_src_c025_2_01 mix_q_c025_2 win_2_01 0) relay vt1=-1m vt2=1m ropen=ropen_mix rclosed=rclosed_mix
EMIXI_c025_2_02 (mix_i_src_c025_2_02 0 bpf_c025_2 0) vcvs gain=5.555702330196e-01
SMIXI_c025_2_02 (mix_i_src_c025_2_02 mix_i_c025_2 win_2_02 0) relay vt1=-1m vt2=1m ropen=ropen_mix rclosed=rclosed_mix
EMIXQ_c025_2_02 (mix_q_src_c025_2_02 0 bpf_c025_2 0) vcvs gain=8.314696123025e-01
SMIXQ_c025_2_02 (mix_q_src_c025_2_02 mix_q_c025_2 win_2_02 0) relay vt1=-1m vt2=1m ropen=ropen_mix rclosed=rclosed_mix
EMIXI_c025_2_03 (mix_i_src_c025_2_03 0 bpf_c025_2 0) vcvs gain=1.950903220161e-01
SMIXI_c025_2_03 (mix_i_src_c025_2_03 mix_i_c025_2 win_2_03 0) relay vt1=-1m vt2=1m ropen=ropen_mix rclosed=rclosed_mix
EMIXQ_c025_2_03 (mix_q_src_c025_2_03 0 bpf_c025_2 0) vcvs gain=9.807852804032e-01
SMIXQ_c025_2_03 (mix_q_src_c025_2_03 mix_q_c025_2 win_2_03 0) relay vt1=-1m vt2=1m ropen=ropen_mix rclosed=rclosed_mix
EMIXI_c025_2_04 (mix_i_src_c025_2_04 0 bpf_c025_2 0) vcvs gain=-1.950903220161e-01
SMIXI_c025_2_04 (mix_i_src_c025_2_04 mix_i_c025_2 win_2_04 0) relay vt1=-1m vt2=1m ropen=ropen_mix rclosed=rclosed_mix
EMIXQ_c025_2_04 (mix_q_src_c025_2_04 0 bpf_c025_2 0) vcvs gain=9.807852804032e-01
SMIXQ_c025_2_04 (mix_q_src_c025_2_04 mix_q_c025_2 win_2_04 0) relay vt1=-1m vt2=1m ropen=ropen_mix rclosed=rclosed_mix
EMIXI_c025_2_05 (mix_i_src_c025_2_05 0 bpf_c025_2 0) vcvs gain=-5.555702330196e-01
SMIXI_c025_2_05 (mix_i_src_c025_2_05 mix_i_c025_2 win_2_05 0) relay vt1=-1m vt2=1m ropen=ropen_mix rclosed=rclosed_mix
EMIXQ_c025_2_05 (mix_q_src_c025_2_05 0 bpf_c025_2 0) vcvs gain=8.314696123025e-01
SMIXQ_c025_2_05 (mix_q_src_c025_2_05 mix_q_c025_2 win_2_05 0) relay vt1=-1m vt2=1m ropen=ropen_mix rclosed=rclosed_mix
EMIXI_c025_2_06 (mix_i_src_c025_2_06 0 bpf_c025_2 0) vcvs gain=-8.314696123025e-01
SMIXI_c025_2_06 (mix_i_src_c025_2_06 mix_i_c025_2 win_2_06 0) relay vt1=-1m vt2=1m ropen=ropen_mix rclosed=rclosed_mix
EMIXQ_c025_2_06 (mix_q_src_c025_2_06 0 bpf_c025_2 0) vcvs gain=5.555702330196e-01
SMIXQ_c025_2_06 (mix_q_src_c025_2_06 mix_q_c025_2 win_2_06 0) relay vt1=-1m vt2=1m ropen=ropen_mix rclosed=rclosed_mix
EMIXI_c025_2_07 (mix_i_src_c025_2_07 0 bpf_c025_2 0) vcvs gain=-9.807852804032e-01
SMIXI_c025_2_07 (mix_i_src_c025_2_07 mix_i_c025_2 win_2_07 0) relay vt1=-1m vt2=1m ropen=ropen_mix rclosed=rclosed_mix
EMIXQ_c025_2_07 (mix_q_src_c025_2_07 0 bpf_c025_2 0) vcvs gain=1.950903220161e-01
SMIXQ_c025_2_07 (mix_q_src_c025_2_07 mix_q_c025_2 win_2_07 0) relay vt1=-1m vt2=1m ropen=ropen_mix rclosed=rclosed_mix
EMIXI_c025_2_08 (mix_i_src_c025_2_08 0 bpf_c025_2 0) vcvs gain=-9.807852804032e-01
SMIXI_c025_2_08 (mix_i_src_c025_2_08 mix_i_c025_2 win_2_08 0) relay vt1=-1m vt2=1m ropen=ropen_mix rclosed=rclosed_mix
EMIXQ_c025_2_08 (mix_q_src_c025_2_08 0 bpf_c025_2 0) vcvs gain=-1.950903220161e-01
SMIXQ_c025_2_08 (mix_q_src_c025_2_08 mix_q_c025_2 win_2_08 0) relay vt1=-1m vt2=1m ropen=ropen_mix rclosed=rclosed_mix
EMIXI_c025_2_09 (mix_i_src_c025_2_09 0 bpf_c025_2 0) vcvs gain=-8.314696123025e-01
SMIXI_c025_2_09 (mix_i_src_c025_2_09 mix_i_c025_2 win_2_09 0) relay vt1=-1m vt2=1m ropen=ropen_mix rclosed=rclosed_mix
EMIXQ_c025_2_09 (mix_q_src_c025_2_09 0 bpf_c025_2 0) vcvs gain=-5.555702330196e-01
SMIXQ_c025_2_09 (mix_q_src_c025_2_09 mix_q_c025_2 win_2_09 0) relay vt1=-1m vt2=1m ropen=ropen_mix rclosed=rclosed_mix
EMIXI_c025_2_10 (mix_i_src_c025_2_10 0 bpf_c025_2 0) vcvs gain=-5.555702330196e-01
SMIXI_c025_2_10 (mix_i_src_c025_2_10 mix_i_c025_2 win_2_10 0) relay vt1=-1m vt2=1m ropen=ropen_mix rclosed=rclosed_mix
EMIXQ_c025_2_10 (mix_q_src_c025_2_10 0 bpf_c025_2 0) vcvs gain=-8.314696123025e-01
SMIXQ_c025_2_10 (mix_q_src_c025_2_10 mix_q_c025_2 win_2_10 0) relay vt1=-1m vt2=1m ropen=ropen_mix rclosed=rclosed_mix
EMIXI_c025_2_11 (mix_i_src_c025_2_11 0 bpf_c025_2 0) vcvs gain=-1.950903220161e-01
SMIXI_c025_2_11 (mix_i_src_c025_2_11 mix_i_c025_2 win_2_11 0) relay vt1=-1m vt2=1m ropen=ropen_mix rclosed=rclosed_mix
EMIXQ_c025_2_11 (mix_q_src_c025_2_11 0 bpf_c025_2 0) vcvs gain=-9.807852804032e-01
SMIXQ_c025_2_11 (mix_q_src_c025_2_11 mix_q_c025_2 win_2_11 0) relay vt1=-1m vt2=1m ropen=ropen_mix rclosed=rclosed_mix
EMIXI_c025_2_12 (mix_i_src_c025_2_12 0 bpf_c025_2 0) vcvs gain=1.950903220161e-01
SMIXI_c025_2_12 (mix_i_src_c025_2_12 mix_i_c025_2 win_2_12 0) relay vt1=-1m vt2=1m ropen=ropen_mix rclosed=rclosed_mix
EMIXQ_c025_2_12 (mix_q_src_c025_2_12 0 bpf_c025_2 0) vcvs gain=-9.807852804032e-01
SMIXQ_c025_2_12 (mix_q_src_c025_2_12 mix_q_c025_2 win_2_12 0) relay vt1=-1m vt2=1m ropen=ropen_mix rclosed=rclosed_mix
EMIXI_c025_2_13 (mix_i_src_c025_2_13 0 bpf_c025_2 0) vcvs gain=5.555702330196e-01
SMIXI_c025_2_13 (mix_i_src_c025_2_13 mix_i_c025_2 win_2_13 0) relay vt1=-1m vt2=1m ropen=ropen_mix rclosed=rclosed_mix
EMIXQ_c025_2_13 (mix_q_src_c025_2_13 0 bpf_c025_2 0) vcvs gain=-8.314696123025e-01
SMIXQ_c025_2_13 (mix_q_src_c025_2_13 mix_q_c025_2 win_2_13 0) relay vt1=-1m vt2=1m ropen=ropen_mix rclosed=rclosed_mix
EMIXI_c025_2_14 (mix_i_src_c025_2_14 0 bpf_c025_2 0) vcvs gain=8.314696123025e-01
SMIXI_c025_2_14 (mix_i_src_c025_2_14 mix_i_c025_2 win_2_14 0) relay vt1=-1m vt2=1m ropen=ropen_mix rclosed=rclosed_mix
EMIXQ_c025_2_14 (mix_q_src_c025_2_14 0 bpf_c025_2 0) vcvs gain=-5.555702330196e-01
SMIXQ_c025_2_14 (mix_q_src_c025_2_14 mix_q_c025_2 win_2_14 0) relay vt1=-1m vt2=1m ropen=ropen_mix rclosed=rclosed_mix
EMIXI_c025_2_15 (mix_i_src_c025_2_15 0 bpf_c025_2 0) vcvs gain=9.807852804032e-01
SMIXI_c025_2_15 (mix_i_src_c025_2_15 mix_i_c025_2 win_2_15 0) relay vt1=-1m vt2=1m ropen=ropen_mix rclosed=rclosed_mix
EMIXQ_c025_2_15 (mix_q_src_c025_2_15 0 bpf_c025_2 0) vcvs gain=-1.950903220161e-01
SMIXQ_c025_2_15 (mix_q_src_c025_2_15 mix_q_c025_2 win_2_15 0) relay vt1=-1m vt2=1m ropen=ropen_mix rclosed=rclosed_mix
RMIXI_c025_2 (mix_i_c025_2 0) resistor r=1G
RMIXQ_c025_2 (mix_q_c025_2 0) resistor r=1G
RINTI_c025_2 (mix_i_c025_2 Icar_c025_2) resistor r=1k
CINTI_c025_2 (Icar_c025_2 0) capacitor c=80p
RINTQ_c025_2 (mix_q_c025_2 Qcar_c025_2) resistor r=1k
CINTQ_c025_2 (Qcar_c025_2 0) capacitor c=80p
save bpf_c025_2 Icar_c025_2 Qcar_c025_2

// bl025, carrier_3: 1000000000 Hz coherent I/Q phase-window verification-demod path
CBPF_c025_3 (bl025 n_cbpf_c025_3) capacitor c=2.533029591058e-14
LBPF_c025_3 (n_cbpf_c025_3 bpf_c025_3) inductor l=1.000000000000e-06
RBPF_c025_3 (bpf_c025_3 0) resistor r=3.141592653590e+02
EMIXI_c025_3_00 (mix_i_src_c025_3_00 0 bpf_c025_3 0) vcvs gain=9.807852804032e-01
SMIXI_c025_3_00 (mix_i_src_c025_3_00 mix_i_c025_3 win_3_00 0) relay vt1=-1m vt2=1m ropen=ropen_mix rclosed=rclosed_mix
EMIXQ_c025_3_00 (mix_q_src_c025_3_00 0 bpf_c025_3 0) vcvs gain=1.950903220161e-01
SMIXQ_c025_3_00 (mix_q_src_c025_3_00 mix_q_c025_3 win_3_00 0) relay vt1=-1m vt2=1m ropen=ropen_mix rclosed=rclosed_mix
EMIXI_c025_3_01 (mix_i_src_c025_3_01 0 bpf_c025_3 0) vcvs gain=8.314696123025e-01
SMIXI_c025_3_01 (mix_i_src_c025_3_01 mix_i_c025_3 win_3_01 0) relay vt1=-1m vt2=1m ropen=ropen_mix rclosed=rclosed_mix
EMIXQ_c025_3_01 (mix_q_src_c025_3_01 0 bpf_c025_3 0) vcvs gain=5.555702330196e-01
SMIXQ_c025_3_01 (mix_q_src_c025_3_01 mix_q_c025_3 win_3_01 0) relay vt1=-1m vt2=1m ropen=ropen_mix rclosed=rclosed_mix
EMIXI_c025_3_02 (mix_i_src_c025_3_02 0 bpf_c025_3 0) vcvs gain=5.555702330196e-01
SMIXI_c025_3_02 (mix_i_src_c025_3_02 mix_i_c025_3 win_3_02 0) relay vt1=-1m vt2=1m ropen=ropen_mix rclosed=rclosed_mix
EMIXQ_c025_3_02 (mix_q_src_c025_3_02 0 bpf_c025_3 0) vcvs gain=8.314696123025e-01
SMIXQ_c025_3_02 (mix_q_src_c025_3_02 mix_q_c025_3 win_3_02 0) relay vt1=-1m vt2=1m ropen=ropen_mix rclosed=rclosed_mix
EMIXI_c025_3_03 (mix_i_src_c025_3_03 0 bpf_c025_3 0) vcvs gain=1.950903220161e-01
SMIXI_c025_3_03 (mix_i_src_c025_3_03 mix_i_c025_3 win_3_03 0) relay vt1=-1m vt2=1m ropen=ropen_mix rclosed=rclosed_mix
EMIXQ_c025_3_03 (mix_q_src_c025_3_03 0 bpf_c025_3 0) vcvs gain=9.807852804032e-01
SMIXQ_c025_3_03 (mix_q_src_c025_3_03 mix_q_c025_3 win_3_03 0) relay vt1=-1m vt2=1m ropen=ropen_mix rclosed=rclosed_mix
EMIXI_c025_3_04 (mix_i_src_c025_3_04 0 bpf_c025_3 0) vcvs gain=-1.950903220161e-01
SMIXI_c025_3_04 (mix_i_src_c025_3_04 mix_i_c025_3 win_3_04 0) relay vt1=-1m vt2=1m ropen=ropen_mix rclosed=rclosed_mix
EMIXQ_c025_3_04 (mix_q_src_c025_3_04 0 bpf_c025_3 0) vcvs gain=9.807852804032e-01
SMIXQ_c025_3_04 (mix_q_src_c025_3_04 mix_q_c025_3 win_3_04 0) relay vt1=-1m vt2=1m ropen=ropen_mix rclosed=rclosed_mix
EMIXI_c025_3_05 (mix_i_src_c025_3_05 0 bpf_c025_3 0) vcvs gain=-5.555702330196e-01
SMIXI_c025_3_05 (mix_i_src_c025_3_05 mix_i_c025_3 win_3_05 0) relay vt1=-1m vt2=1m ropen=ropen_mix rclosed=rclosed_mix
EMIXQ_c025_3_05 (mix_q_src_c025_3_05 0 bpf_c025_3 0) vcvs gain=8.314696123025e-01
SMIXQ_c025_3_05 (mix_q_src_c025_3_05 mix_q_c025_3 win_3_05 0) relay vt1=-1m vt2=1m ropen=ropen_mix rclosed=rclosed_mix
EMIXI_c025_3_06 (mix_i_src_c025_3_06 0 bpf_c025_3 0) vcvs gain=-8.314696123025e-01
SMIXI_c025_3_06 (mix_i_src_c025_3_06 mix_i_c025_3 win_3_06 0) relay vt1=-1m vt2=1m ropen=ropen_mix rclosed=rclosed_mix
EMIXQ_c025_3_06 (mix_q_src_c025_3_06 0 bpf_c025_3 0) vcvs gain=5.555702330196e-01
SMIXQ_c025_3_06 (mix_q_src_c025_3_06 mix_q_c025_3 win_3_06 0) relay vt1=-1m vt2=1m ropen=ropen_mix rclosed=rclosed_mix
EMIXI_c025_3_07 (mix_i_src_c025_3_07 0 bpf_c025_3 0) vcvs gain=-9.807852804032e-01
SMIXI_c025_3_07 (mix_i_src_c025_3_07 mix_i_c025_3 win_3_07 0) relay vt1=-1m vt2=1m ropen=ropen_mix rclosed=rclosed_mix
EMIXQ_c025_3_07 (mix_q_src_c025_3_07 0 bpf_c025_3 0) vcvs gain=1.950903220161e-01
SMIXQ_c025_3_07 (mix_q_src_c025_3_07 mix_q_c025_3 win_3_07 0) relay vt1=-1m vt2=1m ropen=ropen_mix rclosed=rclosed_mix
EMIXI_c025_3_08 (mix_i_src_c025_3_08 0 bpf_c025_3 0) vcvs gain=-9.807852804032e-01
SMIXI_c025_3_08 (mix_i_src_c025_3_08 mix_i_c025_3 win_3_08 0) relay vt1=-1m vt2=1m ropen=ropen_mix rclosed=rclosed_mix
EMIXQ_c025_3_08 (mix_q_src_c025_3_08 0 bpf_c025_3 0) vcvs gain=-1.950903220161e-01
SMIXQ_c025_3_08 (mix_q_src_c025_3_08 mix_q_c025_3 win_3_08 0) relay vt1=-1m vt2=1m ropen=ropen_mix rclosed=rclosed_mix
EMIXI_c025_3_09 (mix_i_src_c025_3_09 0 bpf_c025_3 0) vcvs gain=-8.314696123025e-01
SMIXI_c025_3_09 (mix_i_src_c025_3_09 mix_i_c025_3 win_3_09 0) relay vt1=-1m vt2=1m ropen=ropen_mix rclosed=rclosed_mix
EMIXQ_c025_3_09 (mix_q_src_c025_3_09 0 bpf_c025_3 0) vcvs gain=-5.555702330196e-01
SMIXQ_c025_3_09 (mix_q_src_c025_3_09 mix_q_c025_3 win_3_09 0) relay vt1=-1m vt2=1m ropen=ropen_mix rclosed=rclosed_mix
EMIXI_c025_3_10 (mix_i_src_c025_3_10 0 bpf_c025_3 0) vcvs gain=-5.555702330196e-01
SMIXI_c025_3_10 (mix_i_src_c025_3_10 mix_i_c025_3 win_3_10 0) relay vt1=-1m vt2=1m ropen=ropen_mix rclosed=rclosed_mix
EMIXQ_c025_3_10 (mix_q_src_c025_3_10 0 bpf_c025_3 0) vcvs gain=-8.314696123025e-01
SMIXQ_c025_3_10 (mix_q_src_c025_3_10 mix_q_c025_3 win_3_10 0) relay vt1=-1m vt2=1m ropen=ropen_mix rclosed=rclosed_mix
EMIXI_c025_3_11 (mix_i_src_c025_3_11 0 bpf_c025_3 0) vcvs gain=-1.950903220161e-01
SMIXI_c025_3_11 (mix_i_src_c025_3_11 mix_i_c025_3 win_3_11 0) relay vt1=-1m vt2=1m ropen=ropen_mix rclosed=rclosed_mix
EMIXQ_c025_3_11 (mix_q_src_c025_3_11 0 bpf_c025_3 0) vcvs gain=-9.807852804032e-01
SMIXQ_c025_3_11 (mix_q_src_c025_3_11 mix_q_c025_3 win_3_11 0) relay vt1=-1m vt2=1m ropen=ropen_mix rclosed=rclosed_mix
EMIXI_c025_3_12 (mix_i_src_c025_3_12 0 bpf_c025_3 0) vcvs gain=1.950903220161e-01
SMIXI_c025_3_12 (mix_i_src_c025_3_12 mix_i_c025_3 win_3_12 0) relay vt1=-1m vt2=1m ropen=ropen_mix rclosed=rclosed_mix
EMIXQ_c025_3_12 (mix_q_src_c025_3_12 0 bpf_c025_3 0) vcvs gain=-9.807852804032e-01
SMIXQ_c025_3_12 (mix_q_src_c025_3_12 mix_q_c025_3 win_3_12 0) relay vt1=-1m vt2=1m ropen=ropen_mix rclosed=rclosed_mix
EMIXI_c025_3_13 (mix_i_src_c025_3_13 0 bpf_c025_3 0) vcvs gain=5.555702330196e-01
SMIXI_c025_3_13 (mix_i_src_c025_3_13 mix_i_c025_3 win_3_13 0) relay vt1=-1m vt2=1m ropen=ropen_mix rclosed=rclosed_mix
EMIXQ_c025_3_13 (mix_q_src_c025_3_13 0 bpf_c025_3 0) vcvs gain=-8.314696123025e-01
SMIXQ_c025_3_13 (mix_q_src_c025_3_13 mix_q_c025_3 win_3_13 0) relay vt1=-1m vt2=1m ropen=ropen_mix rclosed=rclosed_mix
EMIXI_c025_3_14 (mix_i_src_c025_3_14 0 bpf_c025_3 0) vcvs gain=8.314696123025e-01
SMIXI_c025_3_14 (mix_i_src_c025_3_14 mix_i_c025_3 win_3_14 0) relay vt1=-1m vt2=1m ropen=ropen_mix rclosed=rclosed_mix
EMIXQ_c025_3_14 (mix_q_src_c025_3_14 0 bpf_c025_3 0) vcvs gain=-5.555702330196e-01
SMIXQ_c025_3_14 (mix_q_src_c025_3_14 mix_q_c025_3 win_3_14 0) relay vt1=-1m vt2=1m ropen=ropen_mix rclosed=rclosed_mix
EMIXI_c025_3_15 (mix_i_src_c025_3_15 0 bpf_c025_3 0) vcvs gain=9.807852804032e-01
SMIXI_c025_3_15 (mix_i_src_c025_3_15 mix_i_c025_3 win_3_15 0) relay vt1=-1m vt2=1m ropen=ropen_mix rclosed=rclosed_mix
EMIXQ_c025_3_15 (mix_q_src_c025_3_15 0 bpf_c025_3 0) vcvs gain=-1.950903220161e-01
SMIXQ_c025_3_15 (mix_q_src_c025_3_15 mix_q_c025_3 win_3_15 0) relay vt1=-1m vt2=1m ropen=ropen_mix rclosed=rclosed_mix
RMIXI_c025_3 (mix_i_c025_3 0) resistor r=1G
RMIXQ_c025_3 (mix_q_c025_3 0) resistor r=1G
RINTI_c025_3 (mix_i_c025_3 Icar_c025_3) resistor r=1k
CINTI_c025_3 (Icar_c025_3 0) capacitor c=80p
RINTQ_c025_3 (mix_q_c025_3 Qcar_c025_3) resistor r=1k
CINTQ_c025_3 (Qcar_c025_3 0) capacitor c=80p
save bpf_c025_3 Icar_c025_3 Qcar_c025_3

// bl026, carrier_0: 250000000 Hz coherent I/Q phase-window verification-demod path
CBPF_c026_0 (bl026 n_cbpf_c026_0) capacitor c=4.052847345694e-13
LBPF_c026_0 (n_cbpf_c026_0 bpf_c026_0) inductor l=1.000000000000e-06
RBPF_c026_0 (bpf_c026_0 0) resistor r=7.853981633974e+01
EMIXI_c026_0_00 (mix_i_src_c026_0_00 0 bpf_c026_0 0) vcvs gain=9.807852804032e-01
SMIXI_c026_0_00 (mix_i_src_c026_0_00 mix_i_c026_0 win_0_00 0) relay vt1=-1m vt2=1m ropen=ropen_mix rclosed=rclosed_mix
EMIXQ_c026_0_00 (mix_q_src_c026_0_00 0 bpf_c026_0 0) vcvs gain=1.950903220161e-01
SMIXQ_c026_0_00 (mix_q_src_c026_0_00 mix_q_c026_0 win_0_00 0) relay vt1=-1m vt2=1m ropen=ropen_mix rclosed=rclosed_mix
EMIXI_c026_0_01 (mix_i_src_c026_0_01 0 bpf_c026_0 0) vcvs gain=8.314696123025e-01
SMIXI_c026_0_01 (mix_i_src_c026_0_01 mix_i_c026_0 win_0_01 0) relay vt1=-1m vt2=1m ropen=ropen_mix rclosed=rclosed_mix
EMIXQ_c026_0_01 (mix_q_src_c026_0_01 0 bpf_c026_0 0) vcvs gain=5.555702330196e-01
SMIXQ_c026_0_01 (mix_q_src_c026_0_01 mix_q_c026_0 win_0_01 0) relay vt1=-1m vt2=1m ropen=ropen_mix rclosed=rclosed_mix
EMIXI_c026_0_02 (mix_i_src_c026_0_02 0 bpf_c026_0 0) vcvs gain=5.555702330196e-01
SMIXI_c026_0_02 (mix_i_src_c026_0_02 mix_i_c026_0 win_0_02 0) relay vt1=-1m vt2=1m ropen=ropen_mix rclosed=rclosed_mix
EMIXQ_c026_0_02 (mix_q_src_c026_0_02 0 bpf_c026_0 0) vcvs gain=8.314696123025e-01
SMIXQ_c026_0_02 (mix_q_src_c026_0_02 mix_q_c026_0 win_0_02 0) relay vt1=-1m vt2=1m ropen=ropen_mix rclosed=rclosed_mix
EMIXI_c026_0_03 (mix_i_src_c026_0_03 0 bpf_c026_0 0) vcvs gain=1.950903220161e-01
SMIXI_c026_0_03 (mix_i_src_c026_0_03 mix_i_c026_0 win_0_03 0) relay vt1=-1m vt2=1m ropen=ropen_mix rclosed=rclosed_mix
EMIXQ_c026_0_03 (mix_q_src_c026_0_03 0 bpf_c026_0 0) vcvs gain=9.807852804032e-01
SMIXQ_c026_0_03 (mix_q_src_c026_0_03 mix_q_c026_0 win_0_03 0) relay vt1=-1m vt2=1m ropen=ropen_mix rclosed=rclosed_mix
EMIXI_c026_0_04 (mix_i_src_c026_0_04 0 bpf_c026_0 0) vcvs gain=-1.950903220161e-01
SMIXI_c026_0_04 (mix_i_src_c026_0_04 mix_i_c026_0 win_0_04 0) relay vt1=-1m vt2=1m ropen=ropen_mix rclosed=rclosed_mix
EMIXQ_c026_0_04 (mix_q_src_c026_0_04 0 bpf_c026_0 0) vcvs gain=9.807852804032e-01
SMIXQ_c026_0_04 (mix_q_src_c026_0_04 mix_q_c026_0 win_0_04 0) relay vt1=-1m vt2=1m ropen=ropen_mix rclosed=rclosed_mix
EMIXI_c026_0_05 (mix_i_src_c026_0_05 0 bpf_c026_0 0) vcvs gain=-5.555702330196e-01
SMIXI_c026_0_05 (mix_i_src_c026_0_05 mix_i_c026_0 win_0_05 0) relay vt1=-1m vt2=1m ropen=ropen_mix rclosed=rclosed_mix
EMIXQ_c026_0_05 (mix_q_src_c026_0_05 0 bpf_c026_0 0) vcvs gain=8.314696123025e-01
SMIXQ_c026_0_05 (mix_q_src_c026_0_05 mix_q_c026_0 win_0_05 0) relay vt1=-1m vt2=1m ropen=ropen_mix rclosed=rclosed_mix
EMIXI_c026_0_06 (mix_i_src_c026_0_06 0 bpf_c026_0 0) vcvs gain=-8.314696123025e-01
SMIXI_c026_0_06 (mix_i_src_c026_0_06 mix_i_c026_0 win_0_06 0) relay vt1=-1m vt2=1m ropen=ropen_mix rclosed=rclosed_mix
EMIXQ_c026_0_06 (mix_q_src_c026_0_06 0 bpf_c026_0 0) vcvs gain=5.555702330196e-01
SMIXQ_c026_0_06 (mix_q_src_c026_0_06 mix_q_c026_0 win_0_06 0) relay vt1=-1m vt2=1m ropen=ropen_mix rclosed=rclosed_mix
EMIXI_c026_0_07 (mix_i_src_c026_0_07 0 bpf_c026_0 0) vcvs gain=-9.807852804032e-01
SMIXI_c026_0_07 (mix_i_src_c026_0_07 mix_i_c026_0 win_0_07 0) relay vt1=-1m vt2=1m ropen=ropen_mix rclosed=rclosed_mix
EMIXQ_c026_0_07 (mix_q_src_c026_0_07 0 bpf_c026_0 0) vcvs gain=1.950903220161e-01
SMIXQ_c026_0_07 (mix_q_src_c026_0_07 mix_q_c026_0 win_0_07 0) relay vt1=-1m vt2=1m ropen=ropen_mix rclosed=rclosed_mix
EMIXI_c026_0_08 (mix_i_src_c026_0_08 0 bpf_c026_0 0) vcvs gain=-9.807852804032e-01
SMIXI_c026_0_08 (mix_i_src_c026_0_08 mix_i_c026_0 win_0_08 0) relay vt1=-1m vt2=1m ropen=ropen_mix rclosed=rclosed_mix
EMIXQ_c026_0_08 (mix_q_src_c026_0_08 0 bpf_c026_0 0) vcvs gain=-1.950903220161e-01
SMIXQ_c026_0_08 (mix_q_src_c026_0_08 mix_q_c026_0 win_0_08 0) relay vt1=-1m vt2=1m ropen=ropen_mix rclosed=rclosed_mix
EMIXI_c026_0_09 (mix_i_src_c026_0_09 0 bpf_c026_0 0) vcvs gain=-8.314696123025e-01
SMIXI_c026_0_09 (mix_i_src_c026_0_09 mix_i_c026_0 win_0_09 0) relay vt1=-1m vt2=1m ropen=ropen_mix rclosed=rclosed_mix
EMIXQ_c026_0_09 (mix_q_src_c026_0_09 0 bpf_c026_0 0) vcvs gain=-5.555702330196e-01
SMIXQ_c026_0_09 (mix_q_src_c026_0_09 mix_q_c026_0 win_0_09 0) relay vt1=-1m vt2=1m ropen=ropen_mix rclosed=rclosed_mix
EMIXI_c026_0_10 (mix_i_src_c026_0_10 0 bpf_c026_0 0) vcvs gain=-5.555702330196e-01
SMIXI_c026_0_10 (mix_i_src_c026_0_10 mix_i_c026_0 win_0_10 0) relay vt1=-1m vt2=1m ropen=ropen_mix rclosed=rclosed_mix
EMIXQ_c026_0_10 (mix_q_src_c026_0_10 0 bpf_c026_0 0) vcvs gain=-8.314696123025e-01
SMIXQ_c026_0_10 (mix_q_src_c026_0_10 mix_q_c026_0 win_0_10 0) relay vt1=-1m vt2=1m ropen=ropen_mix rclosed=rclosed_mix
EMIXI_c026_0_11 (mix_i_src_c026_0_11 0 bpf_c026_0 0) vcvs gain=-1.950903220161e-01
SMIXI_c026_0_11 (mix_i_src_c026_0_11 mix_i_c026_0 win_0_11 0) relay vt1=-1m vt2=1m ropen=ropen_mix rclosed=rclosed_mix
EMIXQ_c026_0_11 (mix_q_src_c026_0_11 0 bpf_c026_0 0) vcvs gain=-9.807852804032e-01
SMIXQ_c026_0_11 (mix_q_src_c026_0_11 mix_q_c026_0 win_0_11 0) relay vt1=-1m vt2=1m ropen=ropen_mix rclosed=rclosed_mix
EMIXI_c026_0_12 (mix_i_src_c026_0_12 0 bpf_c026_0 0) vcvs gain=1.950903220161e-01
SMIXI_c026_0_12 (mix_i_src_c026_0_12 mix_i_c026_0 win_0_12 0) relay vt1=-1m vt2=1m ropen=ropen_mix rclosed=rclosed_mix
EMIXQ_c026_0_12 (mix_q_src_c026_0_12 0 bpf_c026_0 0) vcvs gain=-9.807852804032e-01
SMIXQ_c026_0_12 (mix_q_src_c026_0_12 mix_q_c026_0 win_0_12 0) relay vt1=-1m vt2=1m ropen=ropen_mix rclosed=rclosed_mix
EMIXI_c026_0_13 (mix_i_src_c026_0_13 0 bpf_c026_0 0) vcvs gain=5.555702330196e-01
SMIXI_c026_0_13 (mix_i_src_c026_0_13 mix_i_c026_0 win_0_13 0) relay vt1=-1m vt2=1m ropen=ropen_mix rclosed=rclosed_mix
EMIXQ_c026_0_13 (mix_q_src_c026_0_13 0 bpf_c026_0 0) vcvs gain=-8.314696123025e-01
SMIXQ_c026_0_13 (mix_q_src_c026_0_13 mix_q_c026_0 win_0_13 0) relay vt1=-1m vt2=1m ropen=ropen_mix rclosed=rclosed_mix
EMIXI_c026_0_14 (mix_i_src_c026_0_14 0 bpf_c026_0 0) vcvs gain=8.314696123025e-01
SMIXI_c026_0_14 (mix_i_src_c026_0_14 mix_i_c026_0 win_0_14 0) relay vt1=-1m vt2=1m ropen=ropen_mix rclosed=rclosed_mix
EMIXQ_c026_0_14 (mix_q_src_c026_0_14 0 bpf_c026_0 0) vcvs gain=-5.555702330196e-01
SMIXQ_c026_0_14 (mix_q_src_c026_0_14 mix_q_c026_0 win_0_14 0) relay vt1=-1m vt2=1m ropen=ropen_mix rclosed=rclosed_mix
EMIXI_c026_0_15 (mix_i_src_c026_0_15 0 bpf_c026_0 0) vcvs gain=9.807852804032e-01
SMIXI_c026_0_15 (mix_i_src_c026_0_15 mix_i_c026_0 win_0_15 0) relay vt1=-1m vt2=1m ropen=ropen_mix rclosed=rclosed_mix
EMIXQ_c026_0_15 (mix_q_src_c026_0_15 0 bpf_c026_0 0) vcvs gain=-1.950903220161e-01
SMIXQ_c026_0_15 (mix_q_src_c026_0_15 mix_q_c026_0 win_0_15 0) relay vt1=-1m vt2=1m ropen=ropen_mix rclosed=rclosed_mix
RMIXI_c026_0 (mix_i_c026_0 0) resistor r=1G
RMIXQ_c026_0 (mix_q_c026_0 0) resistor r=1G
RINTI_c026_0 (mix_i_c026_0 Icar_c026_0) resistor r=1k
CINTI_c026_0 (Icar_c026_0 0) capacitor c=80p
RINTQ_c026_0 (mix_q_c026_0 Qcar_c026_0) resistor r=1k
CINTQ_c026_0 (Qcar_c026_0 0) capacitor c=80p
save bpf_c026_0 Icar_c026_0 Qcar_c026_0

// bl026, carrier_1: 500000000 Hz coherent I/Q phase-window verification-demod path
CBPF_c026_1 (bl026 n_cbpf_c026_1) capacitor c=1.013211836423e-13
LBPF_c026_1 (n_cbpf_c026_1 bpf_c026_1) inductor l=1.000000000000e-06
RBPF_c026_1 (bpf_c026_1 0) resistor r=1.570796326795e+02
EMIXI_c026_1_00 (mix_i_src_c026_1_00 0 bpf_c026_1 0) vcvs gain=9.807852804032e-01
SMIXI_c026_1_00 (mix_i_src_c026_1_00 mix_i_c026_1 win_1_00 0) relay vt1=-1m vt2=1m ropen=ropen_mix rclosed=rclosed_mix
EMIXQ_c026_1_00 (mix_q_src_c026_1_00 0 bpf_c026_1 0) vcvs gain=1.950903220161e-01
SMIXQ_c026_1_00 (mix_q_src_c026_1_00 mix_q_c026_1 win_1_00 0) relay vt1=-1m vt2=1m ropen=ropen_mix rclosed=rclosed_mix
EMIXI_c026_1_01 (mix_i_src_c026_1_01 0 bpf_c026_1 0) vcvs gain=8.314696123025e-01
SMIXI_c026_1_01 (mix_i_src_c026_1_01 mix_i_c026_1 win_1_01 0) relay vt1=-1m vt2=1m ropen=ropen_mix rclosed=rclosed_mix
EMIXQ_c026_1_01 (mix_q_src_c026_1_01 0 bpf_c026_1 0) vcvs gain=5.555702330196e-01
SMIXQ_c026_1_01 (mix_q_src_c026_1_01 mix_q_c026_1 win_1_01 0) relay vt1=-1m vt2=1m ropen=ropen_mix rclosed=rclosed_mix
EMIXI_c026_1_02 (mix_i_src_c026_1_02 0 bpf_c026_1 0) vcvs gain=5.555702330196e-01
SMIXI_c026_1_02 (mix_i_src_c026_1_02 mix_i_c026_1 win_1_02 0) relay vt1=-1m vt2=1m ropen=ropen_mix rclosed=rclosed_mix
EMIXQ_c026_1_02 (mix_q_src_c026_1_02 0 bpf_c026_1 0) vcvs gain=8.314696123025e-01
SMIXQ_c026_1_02 (mix_q_src_c026_1_02 mix_q_c026_1 win_1_02 0) relay vt1=-1m vt2=1m ropen=ropen_mix rclosed=rclosed_mix
EMIXI_c026_1_03 (mix_i_src_c026_1_03 0 bpf_c026_1 0) vcvs gain=1.950903220161e-01
SMIXI_c026_1_03 (mix_i_src_c026_1_03 mix_i_c026_1 win_1_03 0) relay vt1=-1m vt2=1m ropen=ropen_mix rclosed=rclosed_mix
EMIXQ_c026_1_03 (mix_q_src_c026_1_03 0 bpf_c026_1 0) vcvs gain=9.807852804032e-01
SMIXQ_c026_1_03 (mix_q_src_c026_1_03 mix_q_c026_1 win_1_03 0) relay vt1=-1m vt2=1m ropen=ropen_mix rclosed=rclosed_mix
EMIXI_c026_1_04 (mix_i_src_c026_1_04 0 bpf_c026_1 0) vcvs gain=-1.950903220161e-01
SMIXI_c026_1_04 (mix_i_src_c026_1_04 mix_i_c026_1 win_1_04 0) relay vt1=-1m vt2=1m ropen=ropen_mix rclosed=rclosed_mix
EMIXQ_c026_1_04 (mix_q_src_c026_1_04 0 bpf_c026_1 0) vcvs gain=9.807852804032e-01
SMIXQ_c026_1_04 (mix_q_src_c026_1_04 mix_q_c026_1 win_1_04 0) relay vt1=-1m vt2=1m ropen=ropen_mix rclosed=rclosed_mix
EMIXI_c026_1_05 (mix_i_src_c026_1_05 0 bpf_c026_1 0) vcvs gain=-5.555702330196e-01
SMIXI_c026_1_05 (mix_i_src_c026_1_05 mix_i_c026_1 win_1_05 0) relay vt1=-1m vt2=1m ropen=ropen_mix rclosed=rclosed_mix
EMIXQ_c026_1_05 (mix_q_src_c026_1_05 0 bpf_c026_1 0) vcvs gain=8.314696123025e-01
SMIXQ_c026_1_05 (mix_q_src_c026_1_05 mix_q_c026_1 win_1_05 0) relay vt1=-1m vt2=1m ropen=ropen_mix rclosed=rclosed_mix
EMIXI_c026_1_06 (mix_i_src_c026_1_06 0 bpf_c026_1 0) vcvs gain=-8.314696123025e-01
SMIXI_c026_1_06 (mix_i_src_c026_1_06 mix_i_c026_1 win_1_06 0) relay vt1=-1m vt2=1m ropen=ropen_mix rclosed=rclosed_mix
EMIXQ_c026_1_06 (mix_q_src_c026_1_06 0 bpf_c026_1 0) vcvs gain=5.555702330196e-01
SMIXQ_c026_1_06 (mix_q_src_c026_1_06 mix_q_c026_1 win_1_06 0) relay vt1=-1m vt2=1m ropen=ropen_mix rclosed=rclosed_mix
EMIXI_c026_1_07 (mix_i_src_c026_1_07 0 bpf_c026_1 0) vcvs gain=-9.807852804032e-01
SMIXI_c026_1_07 (mix_i_src_c026_1_07 mix_i_c026_1 win_1_07 0) relay vt1=-1m vt2=1m ropen=ropen_mix rclosed=rclosed_mix
EMIXQ_c026_1_07 (mix_q_src_c026_1_07 0 bpf_c026_1 0) vcvs gain=1.950903220161e-01
SMIXQ_c026_1_07 (mix_q_src_c026_1_07 mix_q_c026_1 win_1_07 0) relay vt1=-1m vt2=1m ropen=ropen_mix rclosed=rclosed_mix
EMIXI_c026_1_08 (mix_i_src_c026_1_08 0 bpf_c026_1 0) vcvs gain=-9.807852804032e-01
SMIXI_c026_1_08 (mix_i_src_c026_1_08 mix_i_c026_1 win_1_08 0) relay vt1=-1m vt2=1m ropen=ropen_mix rclosed=rclosed_mix
EMIXQ_c026_1_08 (mix_q_src_c026_1_08 0 bpf_c026_1 0) vcvs gain=-1.950903220161e-01
SMIXQ_c026_1_08 (mix_q_src_c026_1_08 mix_q_c026_1 win_1_08 0) relay vt1=-1m vt2=1m ropen=ropen_mix rclosed=rclosed_mix
EMIXI_c026_1_09 (mix_i_src_c026_1_09 0 bpf_c026_1 0) vcvs gain=-8.314696123025e-01
SMIXI_c026_1_09 (mix_i_src_c026_1_09 mix_i_c026_1 win_1_09 0) relay vt1=-1m vt2=1m ropen=ropen_mix rclosed=rclosed_mix
EMIXQ_c026_1_09 (mix_q_src_c026_1_09 0 bpf_c026_1 0) vcvs gain=-5.555702330196e-01
SMIXQ_c026_1_09 (mix_q_src_c026_1_09 mix_q_c026_1 win_1_09 0) relay vt1=-1m vt2=1m ropen=ropen_mix rclosed=rclosed_mix
EMIXI_c026_1_10 (mix_i_src_c026_1_10 0 bpf_c026_1 0) vcvs gain=-5.555702330196e-01
SMIXI_c026_1_10 (mix_i_src_c026_1_10 mix_i_c026_1 win_1_10 0) relay vt1=-1m vt2=1m ropen=ropen_mix rclosed=rclosed_mix
EMIXQ_c026_1_10 (mix_q_src_c026_1_10 0 bpf_c026_1 0) vcvs gain=-8.314696123025e-01
SMIXQ_c026_1_10 (mix_q_src_c026_1_10 mix_q_c026_1 win_1_10 0) relay vt1=-1m vt2=1m ropen=ropen_mix rclosed=rclosed_mix
EMIXI_c026_1_11 (mix_i_src_c026_1_11 0 bpf_c026_1 0) vcvs gain=-1.950903220161e-01
SMIXI_c026_1_11 (mix_i_src_c026_1_11 mix_i_c026_1 win_1_11 0) relay vt1=-1m vt2=1m ropen=ropen_mix rclosed=rclosed_mix
EMIXQ_c026_1_11 (mix_q_src_c026_1_11 0 bpf_c026_1 0) vcvs gain=-9.807852804032e-01
SMIXQ_c026_1_11 (mix_q_src_c026_1_11 mix_q_c026_1 win_1_11 0) relay vt1=-1m vt2=1m ropen=ropen_mix rclosed=rclosed_mix
EMIXI_c026_1_12 (mix_i_src_c026_1_12 0 bpf_c026_1 0) vcvs gain=1.950903220161e-01
SMIXI_c026_1_12 (mix_i_src_c026_1_12 mix_i_c026_1 win_1_12 0) relay vt1=-1m vt2=1m ropen=ropen_mix rclosed=rclosed_mix
EMIXQ_c026_1_12 (mix_q_src_c026_1_12 0 bpf_c026_1 0) vcvs gain=-9.807852804032e-01
SMIXQ_c026_1_12 (mix_q_src_c026_1_12 mix_q_c026_1 win_1_12 0) relay vt1=-1m vt2=1m ropen=ropen_mix rclosed=rclosed_mix
EMIXI_c026_1_13 (mix_i_src_c026_1_13 0 bpf_c026_1 0) vcvs gain=5.555702330196e-01
SMIXI_c026_1_13 (mix_i_src_c026_1_13 mix_i_c026_1 win_1_13 0) relay vt1=-1m vt2=1m ropen=ropen_mix rclosed=rclosed_mix
EMIXQ_c026_1_13 (mix_q_src_c026_1_13 0 bpf_c026_1 0) vcvs gain=-8.314696123025e-01
SMIXQ_c026_1_13 (mix_q_src_c026_1_13 mix_q_c026_1 win_1_13 0) relay vt1=-1m vt2=1m ropen=ropen_mix rclosed=rclosed_mix
EMIXI_c026_1_14 (mix_i_src_c026_1_14 0 bpf_c026_1 0) vcvs gain=8.314696123025e-01
SMIXI_c026_1_14 (mix_i_src_c026_1_14 mix_i_c026_1 win_1_14 0) relay vt1=-1m vt2=1m ropen=ropen_mix rclosed=rclosed_mix
EMIXQ_c026_1_14 (mix_q_src_c026_1_14 0 bpf_c026_1 0) vcvs gain=-5.555702330196e-01
SMIXQ_c026_1_14 (mix_q_src_c026_1_14 mix_q_c026_1 win_1_14 0) relay vt1=-1m vt2=1m ropen=ropen_mix rclosed=rclosed_mix
EMIXI_c026_1_15 (mix_i_src_c026_1_15 0 bpf_c026_1 0) vcvs gain=9.807852804032e-01
SMIXI_c026_1_15 (mix_i_src_c026_1_15 mix_i_c026_1 win_1_15 0) relay vt1=-1m vt2=1m ropen=ropen_mix rclosed=rclosed_mix
EMIXQ_c026_1_15 (mix_q_src_c026_1_15 0 bpf_c026_1 0) vcvs gain=-1.950903220161e-01
SMIXQ_c026_1_15 (mix_q_src_c026_1_15 mix_q_c026_1 win_1_15 0) relay vt1=-1m vt2=1m ropen=ropen_mix rclosed=rclosed_mix
RMIXI_c026_1 (mix_i_c026_1 0) resistor r=1G
RMIXQ_c026_1 (mix_q_c026_1 0) resistor r=1G
RINTI_c026_1 (mix_i_c026_1 Icar_c026_1) resistor r=1k
CINTI_c026_1 (Icar_c026_1 0) capacitor c=80p
RINTQ_c026_1 (mix_q_c026_1 Qcar_c026_1) resistor r=1k
CINTQ_c026_1 (Qcar_c026_1 0) capacitor c=80p
save bpf_c026_1 Icar_c026_1 Qcar_c026_1

// bl026, carrier_2: 750000000 Hz coherent I/Q phase-window verification-demod path
CBPF_c026_2 (bl026 n_cbpf_c026_2) capacitor c=4.503163717437e-14
LBPF_c026_2 (n_cbpf_c026_2 bpf_c026_2) inductor l=1.000000000000e-06
RBPF_c026_2 (bpf_c026_2 0) resistor r=2.356194490192e+02
EMIXI_c026_2_00 (mix_i_src_c026_2_00 0 bpf_c026_2 0) vcvs gain=9.807852804032e-01
SMIXI_c026_2_00 (mix_i_src_c026_2_00 mix_i_c026_2 win_2_00 0) relay vt1=-1m vt2=1m ropen=ropen_mix rclosed=rclosed_mix
EMIXQ_c026_2_00 (mix_q_src_c026_2_00 0 bpf_c026_2 0) vcvs gain=1.950903220161e-01
SMIXQ_c026_2_00 (mix_q_src_c026_2_00 mix_q_c026_2 win_2_00 0) relay vt1=-1m vt2=1m ropen=ropen_mix rclosed=rclosed_mix
EMIXI_c026_2_01 (mix_i_src_c026_2_01 0 bpf_c026_2 0) vcvs gain=8.314696123025e-01
SMIXI_c026_2_01 (mix_i_src_c026_2_01 mix_i_c026_2 win_2_01 0) relay vt1=-1m vt2=1m ropen=ropen_mix rclosed=rclosed_mix
EMIXQ_c026_2_01 (mix_q_src_c026_2_01 0 bpf_c026_2 0) vcvs gain=5.555702330196e-01
SMIXQ_c026_2_01 (mix_q_src_c026_2_01 mix_q_c026_2 win_2_01 0) relay vt1=-1m vt2=1m ropen=ropen_mix rclosed=rclosed_mix
EMIXI_c026_2_02 (mix_i_src_c026_2_02 0 bpf_c026_2 0) vcvs gain=5.555702330196e-01
SMIXI_c026_2_02 (mix_i_src_c026_2_02 mix_i_c026_2 win_2_02 0) relay vt1=-1m vt2=1m ropen=ropen_mix rclosed=rclosed_mix
EMIXQ_c026_2_02 (mix_q_src_c026_2_02 0 bpf_c026_2 0) vcvs gain=8.314696123025e-01
SMIXQ_c026_2_02 (mix_q_src_c026_2_02 mix_q_c026_2 win_2_02 0) relay vt1=-1m vt2=1m ropen=ropen_mix rclosed=rclosed_mix
EMIXI_c026_2_03 (mix_i_src_c026_2_03 0 bpf_c026_2 0) vcvs gain=1.950903220161e-01
SMIXI_c026_2_03 (mix_i_src_c026_2_03 mix_i_c026_2 win_2_03 0) relay vt1=-1m vt2=1m ropen=ropen_mix rclosed=rclosed_mix
EMIXQ_c026_2_03 (mix_q_src_c026_2_03 0 bpf_c026_2 0) vcvs gain=9.807852804032e-01
SMIXQ_c026_2_03 (mix_q_src_c026_2_03 mix_q_c026_2 win_2_03 0) relay vt1=-1m vt2=1m ropen=ropen_mix rclosed=rclosed_mix
EMIXI_c026_2_04 (mix_i_src_c026_2_04 0 bpf_c026_2 0) vcvs gain=-1.950903220161e-01
SMIXI_c026_2_04 (mix_i_src_c026_2_04 mix_i_c026_2 win_2_04 0) relay vt1=-1m vt2=1m ropen=ropen_mix rclosed=rclosed_mix
EMIXQ_c026_2_04 (mix_q_src_c026_2_04 0 bpf_c026_2 0) vcvs gain=9.807852804032e-01
SMIXQ_c026_2_04 (mix_q_src_c026_2_04 mix_q_c026_2 win_2_04 0) relay vt1=-1m vt2=1m ropen=ropen_mix rclosed=rclosed_mix
EMIXI_c026_2_05 (mix_i_src_c026_2_05 0 bpf_c026_2 0) vcvs gain=-5.555702330196e-01
SMIXI_c026_2_05 (mix_i_src_c026_2_05 mix_i_c026_2 win_2_05 0) relay vt1=-1m vt2=1m ropen=ropen_mix rclosed=rclosed_mix
EMIXQ_c026_2_05 (mix_q_src_c026_2_05 0 bpf_c026_2 0) vcvs gain=8.314696123025e-01
SMIXQ_c026_2_05 (mix_q_src_c026_2_05 mix_q_c026_2 win_2_05 0) relay vt1=-1m vt2=1m ropen=ropen_mix rclosed=rclosed_mix
EMIXI_c026_2_06 (mix_i_src_c026_2_06 0 bpf_c026_2 0) vcvs gain=-8.314696123025e-01
SMIXI_c026_2_06 (mix_i_src_c026_2_06 mix_i_c026_2 win_2_06 0) relay vt1=-1m vt2=1m ropen=ropen_mix rclosed=rclosed_mix
EMIXQ_c026_2_06 (mix_q_src_c026_2_06 0 bpf_c026_2 0) vcvs gain=5.555702330196e-01
SMIXQ_c026_2_06 (mix_q_src_c026_2_06 mix_q_c026_2 win_2_06 0) relay vt1=-1m vt2=1m ropen=ropen_mix rclosed=rclosed_mix
EMIXI_c026_2_07 (mix_i_src_c026_2_07 0 bpf_c026_2 0) vcvs gain=-9.807852804032e-01
SMIXI_c026_2_07 (mix_i_src_c026_2_07 mix_i_c026_2 win_2_07 0) relay vt1=-1m vt2=1m ropen=ropen_mix rclosed=rclosed_mix
EMIXQ_c026_2_07 (mix_q_src_c026_2_07 0 bpf_c026_2 0) vcvs gain=1.950903220161e-01
SMIXQ_c026_2_07 (mix_q_src_c026_2_07 mix_q_c026_2 win_2_07 0) relay vt1=-1m vt2=1m ropen=ropen_mix rclosed=rclosed_mix
EMIXI_c026_2_08 (mix_i_src_c026_2_08 0 bpf_c026_2 0) vcvs gain=-9.807852804032e-01
SMIXI_c026_2_08 (mix_i_src_c026_2_08 mix_i_c026_2 win_2_08 0) relay vt1=-1m vt2=1m ropen=ropen_mix rclosed=rclosed_mix
EMIXQ_c026_2_08 (mix_q_src_c026_2_08 0 bpf_c026_2 0) vcvs gain=-1.950903220161e-01
SMIXQ_c026_2_08 (mix_q_src_c026_2_08 mix_q_c026_2 win_2_08 0) relay vt1=-1m vt2=1m ropen=ropen_mix rclosed=rclosed_mix
EMIXI_c026_2_09 (mix_i_src_c026_2_09 0 bpf_c026_2 0) vcvs gain=-8.314696123025e-01
SMIXI_c026_2_09 (mix_i_src_c026_2_09 mix_i_c026_2 win_2_09 0) relay vt1=-1m vt2=1m ropen=ropen_mix rclosed=rclosed_mix
EMIXQ_c026_2_09 (mix_q_src_c026_2_09 0 bpf_c026_2 0) vcvs gain=-5.555702330196e-01
SMIXQ_c026_2_09 (mix_q_src_c026_2_09 mix_q_c026_2 win_2_09 0) relay vt1=-1m vt2=1m ropen=ropen_mix rclosed=rclosed_mix
EMIXI_c026_2_10 (mix_i_src_c026_2_10 0 bpf_c026_2 0) vcvs gain=-5.555702330196e-01
SMIXI_c026_2_10 (mix_i_src_c026_2_10 mix_i_c026_2 win_2_10 0) relay vt1=-1m vt2=1m ropen=ropen_mix rclosed=rclosed_mix
EMIXQ_c026_2_10 (mix_q_src_c026_2_10 0 bpf_c026_2 0) vcvs gain=-8.314696123025e-01
SMIXQ_c026_2_10 (mix_q_src_c026_2_10 mix_q_c026_2 win_2_10 0) relay vt1=-1m vt2=1m ropen=ropen_mix rclosed=rclosed_mix
EMIXI_c026_2_11 (mix_i_src_c026_2_11 0 bpf_c026_2 0) vcvs gain=-1.950903220161e-01
SMIXI_c026_2_11 (mix_i_src_c026_2_11 mix_i_c026_2 win_2_11 0) relay vt1=-1m vt2=1m ropen=ropen_mix rclosed=rclosed_mix
EMIXQ_c026_2_11 (mix_q_src_c026_2_11 0 bpf_c026_2 0) vcvs gain=-9.807852804032e-01
SMIXQ_c026_2_11 (mix_q_src_c026_2_11 mix_q_c026_2 win_2_11 0) relay vt1=-1m vt2=1m ropen=ropen_mix rclosed=rclosed_mix
EMIXI_c026_2_12 (mix_i_src_c026_2_12 0 bpf_c026_2 0) vcvs gain=1.950903220161e-01
SMIXI_c026_2_12 (mix_i_src_c026_2_12 mix_i_c026_2 win_2_12 0) relay vt1=-1m vt2=1m ropen=ropen_mix rclosed=rclosed_mix
EMIXQ_c026_2_12 (mix_q_src_c026_2_12 0 bpf_c026_2 0) vcvs gain=-9.807852804032e-01
SMIXQ_c026_2_12 (mix_q_src_c026_2_12 mix_q_c026_2 win_2_12 0) relay vt1=-1m vt2=1m ropen=ropen_mix rclosed=rclosed_mix
EMIXI_c026_2_13 (mix_i_src_c026_2_13 0 bpf_c026_2 0) vcvs gain=5.555702330196e-01
SMIXI_c026_2_13 (mix_i_src_c026_2_13 mix_i_c026_2 win_2_13 0) relay vt1=-1m vt2=1m ropen=ropen_mix rclosed=rclosed_mix
EMIXQ_c026_2_13 (mix_q_src_c026_2_13 0 bpf_c026_2 0) vcvs gain=-8.314696123025e-01
SMIXQ_c026_2_13 (mix_q_src_c026_2_13 mix_q_c026_2 win_2_13 0) relay vt1=-1m vt2=1m ropen=ropen_mix rclosed=rclosed_mix
EMIXI_c026_2_14 (mix_i_src_c026_2_14 0 bpf_c026_2 0) vcvs gain=8.314696123025e-01
SMIXI_c026_2_14 (mix_i_src_c026_2_14 mix_i_c026_2 win_2_14 0) relay vt1=-1m vt2=1m ropen=ropen_mix rclosed=rclosed_mix
EMIXQ_c026_2_14 (mix_q_src_c026_2_14 0 bpf_c026_2 0) vcvs gain=-5.555702330196e-01
SMIXQ_c026_2_14 (mix_q_src_c026_2_14 mix_q_c026_2 win_2_14 0) relay vt1=-1m vt2=1m ropen=ropen_mix rclosed=rclosed_mix
EMIXI_c026_2_15 (mix_i_src_c026_2_15 0 bpf_c026_2 0) vcvs gain=9.807852804032e-01
SMIXI_c026_2_15 (mix_i_src_c026_2_15 mix_i_c026_2 win_2_15 0) relay vt1=-1m vt2=1m ropen=ropen_mix rclosed=rclosed_mix
EMIXQ_c026_2_15 (mix_q_src_c026_2_15 0 bpf_c026_2 0) vcvs gain=-1.950903220161e-01
SMIXQ_c026_2_15 (mix_q_src_c026_2_15 mix_q_c026_2 win_2_15 0) relay vt1=-1m vt2=1m ropen=ropen_mix rclosed=rclosed_mix
RMIXI_c026_2 (mix_i_c026_2 0) resistor r=1G
RMIXQ_c026_2 (mix_q_c026_2 0) resistor r=1G
RINTI_c026_2 (mix_i_c026_2 Icar_c026_2) resistor r=1k
CINTI_c026_2 (Icar_c026_2 0) capacitor c=80p
RINTQ_c026_2 (mix_q_c026_2 Qcar_c026_2) resistor r=1k
CINTQ_c026_2 (Qcar_c026_2 0) capacitor c=80p
save bpf_c026_2 Icar_c026_2 Qcar_c026_2

// bl026, carrier_3: 1000000000 Hz coherent I/Q phase-window verification-demod path
CBPF_c026_3 (bl026 n_cbpf_c026_3) capacitor c=2.533029591058e-14
LBPF_c026_3 (n_cbpf_c026_3 bpf_c026_3) inductor l=1.000000000000e-06
RBPF_c026_3 (bpf_c026_3 0) resistor r=3.141592653590e+02
EMIXI_c026_3_00 (mix_i_src_c026_3_00 0 bpf_c026_3 0) vcvs gain=9.807852804032e-01
SMIXI_c026_3_00 (mix_i_src_c026_3_00 mix_i_c026_3 win_3_00 0) relay vt1=-1m vt2=1m ropen=ropen_mix rclosed=rclosed_mix
EMIXQ_c026_3_00 (mix_q_src_c026_3_00 0 bpf_c026_3 0) vcvs gain=1.950903220161e-01
SMIXQ_c026_3_00 (mix_q_src_c026_3_00 mix_q_c026_3 win_3_00 0) relay vt1=-1m vt2=1m ropen=ropen_mix rclosed=rclosed_mix
EMIXI_c026_3_01 (mix_i_src_c026_3_01 0 bpf_c026_3 0) vcvs gain=8.314696123025e-01
SMIXI_c026_3_01 (mix_i_src_c026_3_01 mix_i_c026_3 win_3_01 0) relay vt1=-1m vt2=1m ropen=ropen_mix rclosed=rclosed_mix
EMIXQ_c026_3_01 (mix_q_src_c026_3_01 0 bpf_c026_3 0) vcvs gain=5.555702330196e-01
SMIXQ_c026_3_01 (mix_q_src_c026_3_01 mix_q_c026_3 win_3_01 0) relay vt1=-1m vt2=1m ropen=ropen_mix rclosed=rclosed_mix
EMIXI_c026_3_02 (mix_i_src_c026_3_02 0 bpf_c026_3 0) vcvs gain=5.555702330196e-01
SMIXI_c026_3_02 (mix_i_src_c026_3_02 mix_i_c026_3 win_3_02 0) relay vt1=-1m vt2=1m ropen=ropen_mix rclosed=rclosed_mix
EMIXQ_c026_3_02 (mix_q_src_c026_3_02 0 bpf_c026_3 0) vcvs gain=8.314696123025e-01
SMIXQ_c026_3_02 (mix_q_src_c026_3_02 mix_q_c026_3 win_3_02 0) relay vt1=-1m vt2=1m ropen=ropen_mix rclosed=rclosed_mix
EMIXI_c026_3_03 (mix_i_src_c026_3_03 0 bpf_c026_3 0) vcvs gain=1.950903220161e-01
SMIXI_c026_3_03 (mix_i_src_c026_3_03 mix_i_c026_3 win_3_03 0) relay vt1=-1m vt2=1m ropen=ropen_mix rclosed=rclosed_mix
EMIXQ_c026_3_03 (mix_q_src_c026_3_03 0 bpf_c026_3 0) vcvs gain=9.807852804032e-01
SMIXQ_c026_3_03 (mix_q_src_c026_3_03 mix_q_c026_3 win_3_03 0) relay vt1=-1m vt2=1m ropen=ropen_mix rclosed=rclosed_mix
EMIXI_c026_3_04 (mix_i_src_c026_3_04 0 bpf_c026_3 0) vcvs gain=-1.950903220161e-01
SMIXI_c026_3_04 (mix_i_src_c026_3_04 mix_i_c026_3 win_3_04 0) relay vt1=-1m vt2=1m ropen=ropen_mix rclosed=rclosed_mix
EMIXQ_c026_3_04 (mix_q_src_c026_3_04 0 bpf_c026_3 0) vcvs gain=9.807852804032e-01
SMIXQ_c026_3_04 (mix_q_src_c026_3_04 mix_q_c026_3 win_3_04 0) relay vt1=-1m vt2=1m ropen=ropen_mix rclosed=rclosed_mix
EMIXI_c026_3_05 (mix_i_src_c026_3_05 0 bpf_c026_3 0) vcvs gain=-5.555702330196e-01
SMIXI_c026_3_05 (mix_i_src_c026_3_05 mix_i_c026_3 win_3_05 0) relay vt1=-1m vt2=1m ropen=ropen_mix rclosed=rclosed_mix
EMIXQ_c026_3_05 (mix_q_src_c026_3_05 0 bpf_c026_3 0) vcvs gain=8.314696123025e-01
SMIXQ_c026_3_05 (mix_q_src_c026_3_05 mix_q_c026_3 win_3_05 0) relay vt1=-1m vt2=1m ropen=ropen_mix rclosed=rclosed_mix
EMIXI_c026_3_06 (mix_i_src_c026_3_06 0 bpf_c026_3 0) vcvs gain=-8.314696123025e-01
SMIXI_c026_3_06 (mix_i_src_c026_3_06 mix_i_c026_3 win_3_06 0) relay vt1=-1m vt2=1m ropen=ropen_mix rclosed=rclosed_mix
EMIXQ_c026_3_06 (mix_q_src_c026_3_06 0 bpf_c026_3 0) vcvs gain=5.555702330196e-01
SMIXQ_c026_3_06 (mix_q_src_c026_3_06 mix_q_c026_3 win_3_06 0) relay vt1=-1m vt2=1m ropen=ropen_mix rclosed=rclosed_mix
EMIXI_c026_3_07 (mix_i_src_c026_3_07 0 bpf_c026_3 0) vcvs gain=-9.807852804032e-01
SMIXI_c026_3_07 (mix_i_src_c026_3_07 mix_i_c026_3 win_3_07 0) relay vt1=-1m vt2=1m ropen=ropen_mix rclosed=rclosed_mix
EMIXQ_c026_3_07 (mix_q_src_c026_3_07 0 bpf_c026_3 0) vcvs gain=1.950903220161e-01
SMIXQ_c026_3_07 (mix_q_src_c026_3_07 mix_q_c026_3 win_3_07 0) relay vt1=-1m vt2=1m ropen=ropen_mix rclosed=rclosed_mix
EMIXI_c026_3_08 (mix_i_src_c026_3_08 0 bpf_c026_3 0) vcvs gain=-9.807852804032e-01
SMIXI_c026_3_08 (mix_i_src_c026_3_08 mix_i_c026_3 win_3_08 0) relay vt1=-1m vt2=1m ropen=ropen_mix rclosed=rclosed_mix
EMIXQ_c026_3_08 (mix_q_src_c026_3_08 0 bpf_c026_3 0) vcvs gain=-1.950903220161e-01
SMIXQ_c026_3_08 (mix_q_src_c026_3_08 mix_q_c026_3 win_3_08 0) relay vt1=-1m vt2=1m ropen=ropen_mix rclosed=rclosed_mix
EMIXI_c026_3_09 (mix_i_src_c026_3_09 0 bpf_c026_3 0) vcvs gain=-8.314696123025e-01
SMIXI_c026_3_09 (mix_i_src_c026_3_09 mix_i_c026_3 win_3_09 0) relay vt1=-1m vt2=1m ropen=ropen_mix rclosed=rclosed_mix
EMIXQ_c026_3_09 (mix_q_src_c026_3_09 0 bpf_c026_3 0) vcvs gain=-5.555702330196e-01
SMIXQ_c026_3_09 (mix_q_src_c026_3_09 mix_q_c026_3 win_3_09 0) relay vt1=-1m vt2=1m ropen=ropen_mix rclosed=rclosed_mix
EMIXI_c026_3_10 (mix_i_src_c026_3_10 0 bpf_c026_3 0) vcvs gain=-5.555702330196e-01
SMIXI_c026_3_10 (mix_i_src_c026_3_10 mix_i_c026_3 win_3_10 0) relay vt1=-1m vt2=1m ropen=ropen_mix rclosed=rclosed_mix
EMIXQ_c026_3_10 (mix_q_src_c026_3_10 0 bpf_c026_3 0) vcvs gain=-8.314696123025e-01
SMIXQ_c026_3_10 (mix_q_src_c026_3_10 mix_q_c026_3 win_3_10 0) relay vt1=-1m vt2=1m ropen=ropen_mix rclosed=rclosed_mix
EMIXI_c026_3_11 (mix_i_src_c026_3_11 0 bpf_c026_3 0) vcvs gain=-1.950903220161e-01
SMIXI_c026_3_11 (mix_i_src_c026_3_11 mix_i_c026_3 win_3_11 0) relay vt1=-1m vt2=1m ropen=ropen_mix rclosed=rclosed_mix
EMIXQ_c026_3_11 (mix_q_src_c026_3_11 0 bpf_c026_3 0) vcvs gain=-9.807852804032e-01
SMIXQ_c026_3_11 (mix_q_src_c026_3_11 mix_q_c026_3 win_3_11 0) relay vt1=-1m vt2=1m ropen=ropen_mix rclosed=rclosed_mix
EMIXI_c026_3_12 (mix_i_src_c026_3_12 0 bpf_c026_3 0) vcvs gain=1.950903220161e-01
SMIXI_c026_3_12 (mix_i_src_c026_3_12 mix_i_c026_3 win_3_12 0) relay vt1=-1m vt2=1m ropen=ropen_mix rclosed=rclosed_mix
EMIXQ_c026_3_12 (mix_q_src_c026_3_12 0 bpf_c026_3 0) vcvs gain=-9.807852804032e-01
SMIXQ_c026_3_12 (mix_q_src_c026_3_12 mix_q_c026_3 win_3_12 0) relay vt1=-1m vt2=1m ropen=ropen_mix rclosed=rclosed_mix
EMIXI_c026_3_13 (mix_i_src_c026_3_13 0 bpf_c026_3 0) vcvs gain=5.555702330196e-01
SMIXI_c026_3_13 (mix_i_src_c026_3_13 mix_i_c026_3 win_3_13 0) relay vt1=-1m vt2=1m ropen=ropen_mix rclosed=rclosed_mix
EMIXQ_c026_3_13 (mix_q_src_c026_3_13 0 bpf_c026_3 0) vcvs gain=-8.314696123025e-01
SMIXQ_c026_3_13 (mix_q_src_c026_3_13 mix_q_c026_3 win_3_13 0) relay vt1=-1m vt2=1m ropen=ropen_mix rclosed=rclosed_mix
EMIXI_c026_3_14 (mix_i_src_c026_3_14 0 bpf_c026_3 0) vcvs gain=8.314696123025e-01
SMIXI_c026_3_14 (mix_i_src_c026_3_14 mix_i_c026_3 win_3_14 0) relay vt1=-1m vt2=1m ropen=ropen_mix rclosed=rclosed_mix
EMIXQ_c026_3_14 (mix_q_src_c026_3_14 0 bpf_c026_3 0) vcvs gain=-5.555702330196e-01
SMIXQ_c026_3_14 (mix_q_src_c026_3_14 mix_q_c026_3 win_3_14 0) relay vt1=-1m vt2=1m ropen=ropen_mix rclosed=rclosed_mix
EMIXI_c026_3_15 (mix_i_src_c026_3_15 0 bpf_c026_3 0) vcvs gain=9.807852804032e-01
SMIXI_c026_3_15 (mix_i_src_c026_3_15 mix_i_c026_3 win_3_15 0) relay vt1=-1m vt2=1m ropen=ropen_mix rclosed=rclosed_mix
EMIXQ_c026_3_15 (mix_q_src_c026_3_15 0 bpf_c026_3 0) vcvs gain=-1.950903220161e-01
SMIXQ_c026_3_15 (mix_q_src_c026_3_15 mix_q_c026_3 win_3_15 0) relay vt1=-1m vt2=1m ropen=ropen_mix rclosed=rclosed_mix
RMIXI_c026_3 (mix_i_c026_3 0) resistor r=1G
RMIXQ_c026_3 (mix_q_c026_3 0) resistor r=1G
RINTI_c026_3 (mix_i_c026_3 Icar_c026_3) resistor r=1k
CINTI_c026_3 (Icar_c026_3 0) capacitor c=80p
RINTQ_c026_3 (mix_q_c026_3 Qcar_c026_3) resistor r=1k
CINTQ_c026_3 (Qcar_c026_3 0) capacitor c=80p
save bpf_c026_3 Icar_c026_3 Qcar_c026_3

// bl027, carrier_0: 250000000 Hz coherent I/Q phase-window verification-demod path
CBPF_c027_0 (bl027 n_cbpf_c027_0) capacitor c=4.052847345694e-13
LBPF_c027_0 (n_cbpf_c027_0 bpf_c027_0) inductor l=1.000000000000e-06
RBPF_c027_0 (bpf_c027_0 0) resistor r=7.853981633974e+01
EMIXI_c027_0_00 (mix_i_src_c027_0_00 0 bpf_c027_0 0) vcvs gain=9.807852804032e-01
SMIXI_c027_0_00 (mix_i_src_c027_0_00 mix_i_c027_0 win_0_00 0) relay vt1=-1m vt2=1m ropen=ropen_mix rclosed=rclosed_mix
EMIXQ_c027_0_00 (mix_q_src_c027_0_00 0 bpf_c027_0 0) vcvs gain=1.950903220161e-01
SMIXQ_c027_0_00 (mix_q_src_c027_0_00 mix_q_c027_0 win_0_00 0) relay vt1=-1m vt2=1m ropen=ropen_mix rclosed=rclosed_mix
EMIXI_c027_0_01 (mix_i_src_c027_0_01 0 bpf_c027_0 0) vcvs gain=8.314696123025e-01
SMIXI_c027_0_01 (mix_i_src_c027_0_01 mix_i_c027_0 win_0_01 0) relay vt1=-1m vt2=1m ropen=ropen_mix rclosed=rclosed_mix
EMIXQ_c027_0_01 (mix_q_src_c027_0_01 0 bpf_c027_0 0) vcvs gain=5.555702330196e-01
SMIXQ_c027_0_01 (mix_q_src_c027_0_01 mix_q_c027_0 win_0_01 0) relay vt1=-1m vt2=1m ropen=ropen_mix rclosed=rclosed_mix
EMIXI_c027_0_02 (mix_i_src_c027_0_02 0 bpf_c027_0 0) vcvs gain=5.555702330196e-01
SMIXI_c027_0_02 (mix_i_src_c027_0_02 mix_i_c027_0 win_0_02 0) relay vt1=-1m vt2=1m ropen=ropen_mix rclosed=rclosed_mix
EMIXQ_c027_0_02 (mix_q_src_c027_0_02 0 bpf_c027_0 0) vcvs gain=8.314696123025e-01
SMIXQ_c027_0_02 (mix_q_src_c027_0_02 mix_q_c027_0 win_0_02 0) relay vt1=-1m vt2=1m ropen=ropen_mix rclosed=rclosed_mix
EMIXI_c027_0_03 (mix_i_src_c027_0_03 0 bpf_c027_0 0) vcvs gain=1.950903220161e-01
SMIXI_c027_0_03 (mix_i_src_c027_0_03 mix_i_c027_0 win_0_03 0) relay vt1=-1m vt2=1m ropen=ropen_mix rclosed=rclosed_mix
EMIXQ_c027_0_03 (mix_q_src_c027_0_03 0 bpf_c027_0 0) vcvs gain=9.807852804032e-01
SMIXQ_c027_0_03 (mix_q_src_c027_0_03 mix_q_c027_0 win_0_03 0) relay vt1=-1m vt2=1m ropen=ropen_mix rclosed=rclosed_mix
EMIXI_c027_0_04 (mix_i_src_c027_0_04 0 bpf_c027_0 0) vcvs gain=-1.950903220161e-01
SMIXI_c027_0_04 (mix_i_src_c027_0_04 mix_i_c027_0 win_0_04 0) relay vt1=-1m vt2=1m ropen=ropen_mix rclosed=rclosed_mix
EMIXQ_c027_0_04 (mix_q_src_c027_0_04 0 bpf_c027_0 0) vcvs gain=9.807852804032e-01
SMIXQ_c027_0_04 (mix_q_src_c027_0_04 mix_q_c027_0 win_0_04 0) relay vt1=-1m vt2=1m ropen=ropen_mix rclosed=rclosed_mix
EMIXI_c027_0_05 (mix_i_src_c027_0_05 0 bpf_c027_0 0) vcvs gain=-5.555702330196e-01
SMIXI_c027_0_05 (mix_i_src_c027_0_05 mix_i_c027_0 win_0_05 0) relay vt1=-1m vt2=1m ropen=ropen_mix rclosed=rclosed_mix
EMIXQ_c027_0_05 (mix_q_src_c027_0_05 0 bpf_c027_0 0) vcvs gain=8.314696123025e-01
SMIXQ_c027_0_05 (mix_q_src_c027_0_05 mix_q_c027_0 win_0_05 0) relay vt1=-1m vt2=1m ropen=ropen_mix rclosed=rclosed_mix
EMIXI_c027_0_06 (mix_i_src_c027_0_06 0 bpf_c027_0 0) vcvs gain=-8.314696123025e-01
SMIXI_c027_0_06 (mix_i_src_c027_0_06 mix_i_c027_0 win_0_06 0) relay vt1=-1m vt2=1m ropen=ropen_mix rclosed=rclosed_mix
EMIXQ_c027_0_06 (mix_q_src_c027_0_06 0 bpf_c027_0 0) vcvs gain=5.555702330196e-01
SMIXQ_c027_0_06 (mix_q_src_c027_0_06 mix_q_c027_0 win_0_06 0) relay vt1=-1m vt2=1m ropen=ropen_mix rclosed=rclosed_mix
EMIXI_c027_0_07 (mix_i_src_c027_0_07 0 bpf_c027_0 0) vcvs gain=-9.807852804032e-01
SMIXI_c027_0_07 (mix_i_src_c027_0_07 mix_i_c027_0 win_0_07 0) relay vt1=-1m vt2=1m ropen=ropen_mix rclosed=rclosed_mix
EMIXQ_c027_0_07 (mix_q_src_c027_0_07 0 bpf_c027_0 0) vcvs gain=1.950903220161e-01
SMIXQ_c027_0_07 (mix_q_src_c027_0_07 mix_q_c027_0 win_0_07 0) relay vt1=-1m vt2=1m ropen=ropen_mix rclosed=rclosed_mix
EMIXI_c027_0_08 (mix_i_src_c027_0_08 0 bpf_c027_0 0) vcvs gain=-9.807852804032e-01
SMIXI_c027_0_08 (mix_i_src_c027_0_08 mix_i_c027_0 win_0_08 0) relay vt1=-1m vt2=1m ropen=ropen_mix rclosed=rclosed_mix
EMIXQ_c027_0_08 (mix_q_src_c027_0_08 0 bpf_c027_0 0) vcvs gain=-1.950903220161e-01
SMIXQ_c027_0_08 (mix_q_src_c027_0_08 mix_q_c027_0 win_0_08 0) relay vt1=-1m vt2=1m ropen=ropen_mix rclosed=rclosed_mix
EMIXI_c027_0_09 (mix_i_src_c027_0_09 0 bpf_c027_0 0) vcvs gain=-8.314696123025e-01
SMIXI_c027_0_09 (mix_i_src_c027_0_09 mix_i_c027_0 win_0_09 0) relay vt1=-1m vt2=1m ropen=ropen_mix rclosed=rclosed_mix
EMIXQ_c027_0_09 (mix_q_src_c027_0_09 0 bpf_c027_0 0) vcvs gain=-5.555702330196e-01
SMIXQ_c027_0_09 (mix_q_src_c027_0_09 mix_q_c027_0 win_0_09 0) relay vt1=-1m vt2=1m ropen=ropen_mix rclosed=rclosed_mix
EMIXI_c027_0_10 (mix_i_src_c027_0_10 0 bpf_c027_0 0) vcvs gain=-5.555702330196e-01
SMIXI_c027_0_10 (mix_i_src_c027_0_10 mix_i_c027_0 win_0_10 0) relay vt1=-1m vt2=1m ropen=ropen_mix rclosed=rclosed_mix
EMIXQ_c027_0_10 (mix_q_src_c027_0_10 0 bpf_c027_0 0) vcvs gain=-8.314696123025e-01
SMIXQ_c027_0_10 (mix_q_src_c027_0_10 mix_q_c027_0 win_0_10 0) relay vt1=-1m vt2=1m ropen=ropen_mix rclosed=rclosed_mix
EMIXI_c027_0_11 (mix_i_src_c027_0_11 0 bpf_c027_0 0) vcvs gain=-1.950903220161e-01
SMIXI_c027_0_11 (mix_i_src_c027_0_11 mix_i_c027_0 win_0_11 0) relay vt1=-1m vt2=1m ropen=ropen_mix rclosed=rclosed_mix
EMIXQ_c027_0_11 (mix_q_src_c027_0_11 0 bpf_c027_0 0) vcvs gain=-9.807852804032e-01
SMIXQ_c027_0_11 (mix_q_src_c027_0_11 mix_q_c027_0 win_0_11 0) relay vt1=-1m vt2=1m ropen=ropen_mix rclosed=rclosed_mix
EMIXI_c027_0_12 (mix_i_src_c027_0_12 0 bpf_c027_0 0) vcvs gain=1.950903220161e-01
SMIXI_c027_0_12 (mix_i_src_c027_0_12 mix_i_c027_0 win_0_12 0) relay vt1=-1m vt2=1m ropen=ropen_mix rclosed=rclosed_mix
EMIXQ_c027_0_12 (mix_q_src_c027_0_12 0 bpf_c027_0 0) vcvs gain=-9.807852804032e-01
SMIXQ_c027_0_12 (mix_q_src_c027_0_12 mix_q_c027_0 win_0_12 0) relay vt1=-1m vt2=1m ropen=ropen_mix rclosed=rclosed_mix
EMIXI_c027_0_13 (mix_i_src_c027_0_13 0 bpf_c027_0 0) vcvs gain=5.555702330196e-01
SMIXI_c027_0_13 (mix_i_src_c027_0_13 mix_i_c027_0 win_0_13 0) relay vt1=-1m vt2=1m ropen=ropen_mix rclosed=rclosed_mix
EMIXQ_c027_0_13 (mix_q_src_c027_0_13 0 bpf_c027_0 0) vcvs gain=-8.314696123025e-01
SMIXQ_c027_0_13 (mix_q_src_c027_0_13 mix_q_c027_0 win_0_13 0) relay vt1=-1m vt2=1m ropen=ropen_mix rclosed=rclosed_mix
EMIXI_c027_0_14 (mix_i_src_c027_0_14 0 bpf_c027_0 0) vcvs gain=8.314696123025e-01
SMIXI_c027_0_14 (mix_i_src_c027_0_14 mix_i_c027_0 win_0_14 0) relay vt1=-1m vt2=1m ropen=ropen_mix rclosed=rclosed_mix
EMIXQ_c027_0_14 (mix_q_src_c027_0_14 0 bpf_c027_0 0) vcvs gain=-5.555702330196e-01
SMIXQ_c027_0_14 (mix_q_src_c027_0_14 mix_q_c027_0 win_0_14 0) relay vt1=-1m vt2=1m ropen=ropen_mix rclosed=rclosed_mix
EMIXI_c027_0_15 (mix_i_src_c027_0_15 0 bpf_c027_0 0) vcvs gain=9.807852804032e-01
SMIXI_c027_0_15 (mix_i_src_c027_0_15 mix_i_c027_0 win_0_15 0) relay vt1=-1m vt2=1m ropen=ropen_mix rclosed=rclosed_mix
EMIXQ_c027_0_15 (mix_q_src_c027_0_15 0 bpf_c027_0 0) vcvs gain=-1.950903220161e-01
SMIXQ_c027_0_15 (mix_q_src_c027_0_15 mix_q_c027_0 win_0_15 0) relay vt1=-1m vt2=1m ropen=ropen_mix rclosed=rclosed_mix
RMIXI_c027_0 (mix_i_c027_0 0) resistor r=1G
RMIXQ_c027_0 (mix_q_c027_0 0) resistor r=1G
RINTI_c027_0 (mix_i_c027_0 Icar_c027_0) resistor r=1k
CINTI_c027_0 (Icar_c027_0 0) capacitor c=80p
RINTQ_c027_0 (mix_q_c027_0 Qcar_c027_0) resistor r=1k
CINTQ_c027_0 (Qcar_c027_0 0) capacitor c=80p
save bpf_c027_0 Icar_c027_0 Qcar_c027_0

// bl027, carrier_1: 500000000 Hz coherent I/Q phase-window verification-demod path
CBPF_c027_1 (bl027 n_cbpf_c027_1) capacitor c=1.013211836423e-13
LBPF_c027_1 (n_cbpf_c027_1 bpf_c027_1) inductor l=1.000000000000e-06
RBPF_c027_1 (bpf_c027_1 0) resistor r=1.570796326795e+02
EMIXI_c027_1_00 (mix_i_src_c027_1_00 0 bpf_c027_1 0) vcvs gain=9.807852804032e-01
SMIXI_c027_1_00 (mix_i_src_c027_1_00 mix_i_c027_1 win_1_00 0) relay vt1=-1m vt2=1m ropen=ropen_mix rclosed=rclosed_mix
EMIXQ_c027_1_00 (mix_q_src_c027_1_00 0 bpf_c027_1 0) vcvs gain=1.950903220161e-01
SMIXQ_c027_1_00 (mix_q_src_c027_1_00 mix_q_c027_1 win_1_00 0) relay vt1=-1m vt2=1m ropen=ropen_mix rclosed=rclosed_mix
EMIXI_c027_1_01 (mix_i_src_c027_1_01 0 bpf_c027_1 0) vcvs gain=8.314696123025e-01
SMIXI_c027_1_01 (mix_i_src_c027_1_01 mix_i_c027_1 win_1_01 0) relay vt1=-1m vt2=1m ropen=ropen_mix rclosed=rclosed_mix
EMIXQ_c027_1_01 (mix_q_src_c027_1_01 0 bpf_c027_1 0) vcvs gain=5.555702330196e-01
SMIXQ_c027_1_01 (mix_q_src_c027_1_01 mix_q_c027_1 win_1_01 0) relay vt1=-1m vt2=1m ropen=ropen_mix rclosed=rclosed_mix
EMIXI_c027_1_02 (mix_i_src_c027_1_02 0 bpf_c027_1 0) vcvs gain=5.555702330196e-01
SMIXI_c027_1_02 (mix_i_src_c027_1_02 mix_i_c027_1 win_1_02 0) relay vt1=-1m vt2=1m ropen=ropen_mix rclosed=rclosed_mix
EMIXQ_c027_1_02 (mix_q_src_c027_1_02 0 bpf_c027_1 0) vcvs gain=8.314696123025e-01
SMIXQ_c027_1_02 (mix_q_src_c027_1_02 mix_q_c027_1 win_1_02 0) relay vt1=-1m vt2=1m ropen=ropen_mix rclosed=rclosed_mix
EMIXI_c027_1_03 (mix_i_src_c027_1_03 0 bpf_c027_1 0) vcvs gain=1.950903220161e-01
SMIXI_c027_1_03 (mix_i_src_c027_1_03 mix_i_c027_1 win_1_03 0) relay vt1=-1m vt2=1m ropen=ropen_mix rclosed=rclosed_mix
EMIXQ_c027_1_03 (mix_q_src_c027_1_03 0 bpf_c027_1 0) vcvs gain=9.807852804032e-01
SMIXQ_c027_1_03 (mix_q_src_c027_1_03 mix_q_c027_1 win_1_03 0) relay vt1=-1m vt2=1m ropen=ropen_mix rclosed=rclosed_mix
EMIXI_c027_1_04 (mix_i_src_c027_1_04 0 bpf_c027_1 0) vcvs gain=-1.950903220161e-01
SMIXI_c027_1_04 (mix_i_src_c027_1_04 mix_i_c027_1 win_1_04 0) relay vt1=-1m vt2=1m ropen=ropen_mix rclosed=rclosed_mix
EMIXQ_c027_1_04 (mix_q_src_c027_1_04 0 bpf_c027_1 0) vcvs gain=9.807852804032e-01
SMIXQ_c027_1_04 (mix_q_src_c027_1_04 mix_q_c027_1 win_1_04 0) relay vt1=-1m vt2=1m ropen=ropen_mix rclosed=rclosed_mix
EMIXI_c027_1_05 (mix_i_src_c027_1_05 0 bpf_c027_1 0) vcvs gain=-5.555702330196e-01
SMIXI_c027_1_05 (mix_i_src_c027_1_05 mix_i_c027_1 win_1_05 0) relay vt1=-1m vt2=1m ropen=ropen_mix rclosed=rclosed_mix
EMIXQ_c027_1_05 (mix_q_src_c027_1_05 0 bpf_c027_1 0) vcvs gain=8.314696123025e-01
SMIXQ_c027_1_05 (mix_q_src_c027_1_05 mix_q_c027_1 win_1_05 0) relay vt1=-1m vt2=1m ropen=ropen_mix rclosed=rclosed_mix
EMIXI_c027_1_06 (mix_i_src_c027_1_06 0 bpf_c027_1 0) vcvs gain=-8.314696123025e-01
SMIXI_c027_1_06 (mix_i_src_c027_1_06 mix_i_c027_1 win_1_06 0) relay vt1=-1m vt2=1m ropen=ropen_mix rclosed=rclosed_mix
EMIXQ_c027_1_06 (mix_q_src_c027_1_06 0 bpf_c027_1 0) vcvs gain=5.555702330196e-01
SMIXQ_c027_1_06 (mix_q_src_c027_1_06 mix_q_c027_1 win_1_06 0) relay vt1=-1m vt2=1m ropen=ropen_mix rclosed=rclosed_mix
EMIXI_c027_1_07 (mix_i_src_c027_1_07 0 bpf_c027_1 0) vcvs gain=-9.807852804032e-01
SMIXI_c027_1_07 (mix_i_src_c027_1_07 mix_i_c027_1 win_1_07 0) relay vt1=-1m vt2=1m ropen=ropen_mix rclosed=rclosed_mix
EMIXQ_c027_1_07 (mix_q_src_c027_1_07 0 bpf_c027_1 0) vcvs gain=1.950903220161e-01
SMIXQ_c027_1_07 (mix_q_src_c027_1_07 mix_q_c027_1 win_1_07 0) relay vt1=-1m vt2=1m ropen=ropen_mix rclosed=rclosed_mix
EMIXI_c027_1_08 (mix_i_src_c027_1_08 0 bpf_c027_1 0) vcvs gain=-9.807852804032e-01
SMIXI_c027_1_08 (mix_i_src_c027_1_08 mix_i_c027_1 win_1_08 0) relay vt1=-1m vt2=1m ropen=ropen_mix rclosed=rclosed_mix
EMIXQ_c027_1_08 (mix_q_src_c027_1_08 0 bpf_c027_1 0) vcvs gain=-1.950903220161e-01
SMIXQ_c027_1_08 (mix_q_src_c027_1_08 mix_q_c027_1 win_1_08 0) relay vt1=-1m vt2=1m ropen=ropen_mix rclosed=rclosed_mix
EMIXI_c027_1_09 (mix_i_src_c027_1_09 0 bpf_c027_1 0) vcvs gain=-8.314696123025e-01
SMIXI_c027_1_09 (mix_i_src_c027_1_09 mix_i_c027_1 win_1_09 0) relay vt1=-1m vt2=1m ropen=ropen_mix rclosed=rclosed_mix
EMIXQ_c027_1_09 (mix_q_src_c027_1_09 0 bpf_c027_1 0) vcvs gain=-5.555702330196e-01
SMIXQ_c027_1_09 (mix_q_src_c027_1_09 mix_q_c027_1 win_1_09 0) relay vt1=-1m vt2=1m ropen=ropen_mix rclosed=rclosed_mix
EMIXI_c027_1_10 (mix_i_src_c027_1_10 0 bpf_c027_1 0) vcvs gain=-5.555702330196e-01
SMIXI_c027_1_10 (mix_i_src_c027_1_10 mix_i_c027_1 win_1_10 0) relay vt1=-1m vt2=1m ropen=ropen_mix rclosed=rclosed_mix
EMIXQ_c027_1_10 (mix_q_src_c027_1_10 0 bpf_c027_1 0) vcvs gain=-8.314696123025e-01
SMIXQ_c027_1_10 (mix_q_src_c027_1_10 mix_q_c027_1 win_1_10 0) relay vt1=-1m vt2=1m ropen=ropen_mix rclosed=rclosed_mix
EMIXI_c027_1_11 (mix_i_src_c027_1_11 0 bpf_c027_1 0) vcvs gain=-1.950903220161e-01
SMIXI_c027_1_11 (mix_i_src_c027_1_11 mix_i_c027_1 win_1_11 0) relay vt1=-1m vt2=1m ropen=ropen_mix rclosed=rclosed_mix
EMIXQ_c027_1_11 (mix_q_src_c027_1_11 0 bpf_c027_1 0) vcvs gain=-9.807852804032e-01
SMIXQ_c027_1_11 (mix_q_src_c027_1_11 mix_q_c027_1 win_1_11 0) relay vt1=-1m vt2=1m ropen=ropen_mix rclosed=rclosed_mix
EMIXI_c027_1_12 (mix_i_src_c027_1_12 0 bpf_c027_1 0) vcvs gain=1.950903220161e-01
SMIXI_c027_1_12 (mix_i_src_c027_1_12 mix_i_c027_1 win_1_12 0) relay vt1=-1m vt2=1m ropen=ropen_mix rclosed=rclosed_mix
EMIXQ_c027_1_12 (mix_q_src_c027_1_12 0 bpf_c027_1 0) vcvs gain=-9.807852804032e-01
SMIXQ_c027_1_12 (mix_q_src_c027_1_12 mix_q_c027_1 win_1_12 0) relay vt1=-1m vt2=1m ropen=ropen_mix rclosed=rclosed_mix
EMIXI_c027_1_13 (mix_i_src_c027_1_13 0 bpf_c027_1 0) vcvs gain=5.555702330196e-01
SMIXI_c027_1_13 (mix_i_src_c027_1_13 mix_i_c027_1 win_1_13 0) relay vt1=-1m vt2=1m ropen=ropen_mix rclosed=rclosed_mix
EMIXQ_c027_1_13 (mix_q_src_c027_1_13 0 bpf_c027_1 0) vcvs gain=-8.314696123025e-01
SMIXQ_c027_1_13 (mix_q_src_c027_1_13 mix_q_c027_1 win_1_13 0) relay vt1=-1m vt2=1m ropen=ropen_mix rclosed=rclosed_mix
EMIXI_c027_1_14 (mix_i_src_c027_1_14 0 bpf_c027_1 0) vcvs gain=8.314696123025e-01
SMIXI_c027_1_14 (mix_i_src_c027_1_14 mix_i_c027_1 win_1_14 0) relay vt1=-1m vt2=1m ropen=ropen_mix rclosed=rclosed_mix
EMIXQ_c027_1_14 (mix_q_src_c027_1_14 0 bpf_c027_1 0) vcvs gain=-5.555702330196e-01
SMIXQ_c027_1_14 (mix_q_src_c027_1_14 mix_q_c027_1 win_1_14 0) relay vt1=-1m vt2=1m ropen=ropen_mix rclosed=rclosed_mix
EMIXI_c027_1_15 (mix_i_src_c027_1_15 0 bpf_c027_1 0) vcvs gain=9.807852804032e-01
SMIXI_c027_1_15 (mix_i_src_c027_1_15 mix_i_c027_1 win_1_15 0) relay vt1=-1m vt2=1m ropen=ropen_mix rclosed=rclosed_mix
EMIXQ_c027_1_15 (mix_q_src_c027_1_15 0 bpf_c027_1 0) vcvs gain=-1.950903220161e-01
SMIXQ_c027_1_15 (mix_q_src_c027_1_15 mix_q_c027_1 win_1_15 0) relay vt1=-1m vt2=1m ropen=ropen_mix rclosed=rclosed_mix
RMIXI_c027_1 (mix_i_c027_1 0) resistor r=1G
RMIXQ_c027_1 (mix_q_c027_1 0) resistor r=1G
RINTI_c027_1 (mix_i_c027_1 Icar_c027_1) resistor r=1k
CINTI_c027_1 (Icar_c027_1 0) capacitor c=80p
RINTQ_c027_1 (mix_q_c027_1 Qcar_c027_1) resistor r=1k
CINTQ_c027_1 (Qcar_c027_1 0) capacitor c=80p
save bpf_c027_1 Icar_c027_1 Qcar_c027_1

// bl027, carrier_2: 750000000 Hz coherent I/Q phase-window verification-demod path
CBPF_c027_2 (bl027 n_cbpf_c027_2) capacitor c=4.503163717437e-14
LBPF_c027_2 (n_cbpf_c027_2 bpf_c027_2) inductor l=1.000000000000e-06
RBPF_c027_2 (bpf_c027_2 0) resistor r=2.356194490192e+02
EMIXI_c027_2_00 (mix_i_src_c027_2_00 0 bpf_c027_2 0) vcvs gain=9.807852804032e-01
SMIXI_c027_2_00 (mix_i_src_c027_2_00 mix_i_c027_2 win_2_00 0) relay vt1=-1m vt2=1m ropen=ropen_mix rclosed=rclosed_mix
EMIXQ_c027_2_00 (mix_q_src_c027_2_00 0 bpf_c027_2 0) vcvs gain=1.950903220161e-01
SMIXQ_c027_2_00 (mix_q_src_c027_2_00 mix_q_c027_2 win_2_00 0) relay vt1=-1m vt2=1m ropen=ropen_mix rclosed=rclosed_mix
EMIXI_c027_2_01 (mix_i_src_c027_2_01 0 bpf_c027_2 0) vcvs gain=8.314696123025e-01
SMIXI_c027_2_01 (mix_i_src_c027_2_01 mix_i_c027_2 win_2_01 0) relay vt1=-1m vt2=1m ropen=ropen_mix rclosed=rclosed_mix
EMIXQ_c027_2_01 (mix_q_src_c027_2_01 0 bpf_c027_2 0) vcvs gain=5.555702330196e-01
SMIXQ_c027_2_01 (mix_q_src_c027_2_01 mix_q_c027_2 win_2_01 0) relay vt1=-1m vt2=1m ropen=ropen_mix rclosed=rclosed_mix
EMIXI_c027_2_02 (mix_i_src_c027_2_02 0 bpf_c027_2 0) vcvs gain=5.555702330196e-01
SMIXI_c027_2_02 (mix_i_src_c027_2_02 mix_i_c027_2 win_2_02 0) relay vt1=-1m vt2=1m ropen=ropen_mix rclosed=rclosed_mix
EMIXQ_c027_2_02 (mix_q_src_c027_2_02 0 bpf_c027_2 0) vcvs gain=8.314696123025e-01
SMIXQ_c027_2_02 (mix_q_src_c027_2_02 mix_q_c027_2 win_2_02 0) relay vt1=-1m vt2=1m ropen=ropen_mix rclosed=rclosed_mix
EMIXI_c027_2_03 (mix_i_src_c027_2_03 0 bpf_c027_2 0) vcvs gain=1.950903220161e-01
SMIXI_c027_2_03 (mix_i_src_c027_2_03 mix_i_c027_2 win_2_03 0) relay vt1=-1m vt2=1m ropen=ropen_mix rclosed=rclosed_mix
EMIXQ_c027_2_03 (mix_q_src_c027_2_03 0 bpf_c027_2 0) vcvs gain=9.807852804032e-01
SMIXQ_c027_2_03 (mix_q_src_c027_2_03 mix_q_c027_2 win_2_03 0) relay vt1=-1m vt2=1m ropen=ropen_mix rclosed=rclosed_mix
EMIXI_c027_2_04 (mix_i_src_c027_2_04 0 bpf_c027_2 0) vcvs gain=-1.950903220161e-01
SMIXI_c027_2_04 (mix_i_src_c027_2_04 mix_i_c027_2 win_2_04 0) relay vt1=-1m vt2=1m ropen=ropen_mix rclosed=rclosed_mix
EMIXQ_c027_2_04 (mix_q_src_c027_2_04 0 bpf_c027_2 0) vcvs gain=9.807852804032e-01
SMIXQ_c027_2_04 (mix_q_src_c027_2_04 mix_q_c027_2 win_2_04 0) relay vt1=-1m vt2=1m ropen=ropen_mix rclosed=rclosed_mix
EMIXI_c027_2_05 (mix_i_src_c027_2_05 0 bpf_c027_2 0) vcvs gain=-5.555702330196e-01
SMIXI_c027_2_05 (mix_i_src_c027_2_05 mix_i_c027_2 win_2_05 0) relay vt1=-1m vt2=1m ropen=ropen_mix rclosed=rclosed_mix
EMIXQ_c027_2_05 (mix_q_src_c027_2_05 0 bpf_c027_2 0) vcvs gain=8.314696123025e-01
SMIXQ_c027_2_05 (mix_q_src_c027_2_05 mix_q_c027_2 win_2_05 0) relay vt1=-1m vt2=1m ropen=ropen_mix rclosed=rclosed_mix
EMIXI_c027_2_06 (mix_i_src_c027_2_06 0 bpf_c027_2 0) vcvs gain=-8.314696123025e-01
SMIXI_c027_2_06 (mix_i_src_c027_2_06 mix_i_c027_2 win_2_06 0) relay vt1=-1m vt2=1m ropen=ropen_mix rclosed=rclosed_mix
EMIXQ_c027_2_06 (mix_q_src_c027_2_06 0 bpf_c027_2 0) vcvs gain=5.555702330196e-01
SMIXQ_c027_2_06 (mix_q_src_c027_2_06 mix_q_c027_2 win_2_06 0) relay vt1=-1m vt2=1m ropen=ropen_mix rclosed=rclosed_mix
EMIXI_c027_2_07 (mix_i_src_c027_2_07 0 bpf_c027_2 0) vcvs gain=-9.807852804032e-01
SMIXI_c027_2_07 (mix_i_src_c027_2_07 mix_i_c027_2 win_2_07 0) relay vt1=-1m vt2=1m ropen=ropen_mix rclosed=rclosed_mix
EMIXQ_c027_2_07 (mix_q_src_c027_2_07 0 bpf_c027_2 0) vcvs gain=1.950903220161e-01
SMIXQ_c027_2_07 (mix_q_src_c027_2_07 mix_q_c027_2 win_2_07 0) relay vt1=-1m vt2=1m ropen=ropen_mix rclosed=rclosed_mix
EMIXI_c027_2_08 (mix_i_src_c027_2_08 0 bpf_c027_2 0) vcvs gain=-9.807852804032e-01
SMIXI_c027_2_08 (mix_i_src_c027_2_08 mix_i_c027_2 win_2_08 0) relay vt1=-1m vt2=1m ropen=ropen_mix rclosed=rclosed_mix
EMIXQ_c027_2_08 (mix_q_src_c027_2_08 0 bpf_c027_2 0) vcvs gain=-1.950903220161e-01
SMIXQ_c027_2_08 (mix_q_src_c027_2_08 mix_q_c027_2 win_2_08 0) relay vt1=-1m vt2=1m ropen=ropen_mix rclosed=rclosed_mix
EMIXI_c027_2_09 (mix_i_src_c027_2_09 0 bpf_c027_2 0) vcvs gain=-8.314696123025e-01
SMIXI_c027_2_09 (mix_i_src_c027_2_09 mix_i_c027_2 win_2_09 0) relay vt1=-1m vt2=1m ropen=ropen_mix rclosed=rclosed_mix
EMIXQ_c027_2_09 (mix_q_src_c027_2_09 0 bpf_c027_2 0) vcvs gain=-5.555702330196e-01
SMIXQ_c027_2_09 (mix_q_src_c027_2_09 mix_q_c027_2 win_2_09 0) relay vt1=-1m vt2=1m ropen=ropen_mix rclosed=rclosed_mix
EMIXI_c027_2_10 (mix_i_src_c027_2_10 0 bpf_c027_2 0) vcvs gain=-5.555702330196e-01
SMIXI_c027_2_10 (mix_i_src_c027_2_10 mix_i_c027_2 win_2_10 0) relay vt1=-1m vt2=1m ropen=ropen_mix rclosed=rclosed_mix
EMIXQ_c027_2_10 (mix_q_src_c027_2_10 0 bpf_c027_2 0) vcvs gain=-8.314696123025e-01
SMIXQ_c027_2_10 (mix_q_src_c027_2_10 mix_q_c027_2 win_2_10 0) relay vt1=-1m vt2=1m ropen=ropen_mix rclosed=rclosed_mix
EMIXI_c027_2_11 (mix_i_src_c027_2_11 0 bpf_c027_2 0) vcvs gain=-1.950903220161e-01
SMIXI_c027_2_11 (mix_i_src_c027_2_11 mix_i_c027_2 win_2_11 0) relay vt1=-1m vt2=1m ropen=ropen_mix rclosed=rclosed_mix
EMIXQ_c027_2_11 (mix_q_src_c027_2_11 0 bpf_c027_2 0) vcvs gain=-9.807852804032e-01
SMIXQ_c027_2_11 (mix_q_src_c027_2_11 mix_q_c027_2 win_2_11 0) relay vt1=-1m vt2=1m ropen=ropen_mix rclosed=rclosed_mix
EMIXI_c027_2_12 (mix_i_src_c027_2_12 0 bpf_c027_2 0) vcvs gain=1.950903220161e-01
SMIXI_c027_2_12 (mix_i_src_c027_2_12 mix_i_c027_2 win_2_12 0) relay vt1=-1m vt2=1m ropen=ropen_mix rclosed=rclosed_mix
EMIXQ_c027_2_12 (mix_q_src_c027_2_12 0 bpf_c027_2 0) vcvs gain=-9.807852804032e-01
SMIXQ_c027_2_12 (mix_q_src_c027_2_12 mix_q_c027_2 win_2_12 0) relay vt1=-1m vt2=1m ropen=ropen_mix rclosed=rclosed_mix
EMIXI_c027_2_13 (mix_i_src_c027_2_13 0 bpf_c027_2 0) vcvs gain=5.555702330196e-01
SMIXI_c027_2_13 (mix_i_src_c027_2_13 mix_i_c027_2 win_2_13 0) relay vt1=-1m vt2=1m ropen=ropen_mix rclosed=rclosed_mix
EMIXQ_c027_2_13 (mix_q_src_c027_2_13 0 bpf_c027_2 0) vcvs gain=-8.314696123025e-01
SMIXQ_c027_2_13 (mix_q_src_c027_2_13 mix_q_c027_2 win_2_13 0) relay vt1=-1m vt2=1m ropen=ropen_mix rclosed=rclosed_mix
EMIXI_c027_2_14 (mix_i_src_c027_2_14 0 bpf_c027_2 0) vcvs gain=8.314696123025e-01
SMIXI_c027_2_14 (mix_i_src_c027_2_14 mix_i_c027_2 win_2_14 0) relay vt1=-1m vt2=1m ropen=ropen_mix rclosed=rclosed_mix
EMIXQ_c027_2_14 (mix_q_src_c027_2_14 0 bpf_c027_2 0) vcvs gain=-5.555702330196e-01
SMIXQ_c027_2_14 (mix_q_src_c027_2_14 mix_q_c027_2 win_2_14 0) relay vt1=-1m vt2=1m ropen=ropen_mix rclosed=rclosed_mix
EMIXI_c027_2_15 (mix_i_src_c027_2_15 0 bpf_c027_2 0) vcvs gain=9.807852804032e-01
SMIXI_c027_2_15 (mix_i_src_c027_2_15 mix_i_c027_2 win_2_15 0) relay vt1=-1m vt2=1m ropen=ropen_mix rclosed=rclosed_mix
EMIXQ_c027_2_15 (mix_q_src_c027_2_15 0 bpf_c027_2 0) vcvs gain=-1.950903220161e-01
SMIXQ_c027_2_15 (mix_q_src_c027_2_15 mix_q_c027_2 win_2_15 0) relay vt1=-1m vt2=1m ropen=ropen_mix rclosed=rclosed_mix
RMIXI_c027_2 (mix_i_c027_2 0) resistor r=1G
RMIXQ_c027_2 (mix_q_c027_2 0) resistor r=1G
RINTI_c027_2 (mix_i_c027_2 Icar_c027_2) resistor r=1k
CINTI_c027_2 (Icar_c027_2 0) capacitor c=80p
RINTQ_c027_2 (mix_q_c027_2 Qcar_c027_2) resistor r=1k
CINTQ_c027_2 (Qcar_c027_2 0) capacitor c=80p
save bpf_c027_2 Icar_c027_2 Qcar_c027_2

// bl027, carrier_3: 1000000000 Hz coherent I/Q phase-window verification-demod path
CBPF_c027_3 (bl027 n_cbpf_c027_3) capacitor c=2.533029591058e-14
LBPF_c027_3 (n_cbpf_c027_3 bpf_c027_3) inductor l=1.000000000000e-06
RBPF_c027_3 (bpf_c027_3 0) resistor r=3.141592653590e+02
EMIXI_c027_3_00 (mix_i_src_c027_3_00 0 bpf_c027_3 0) vcvs gain=9.807852804032e-01
SMIXI_c027_3_00 (mix_i_src_c027_3_00 mix_i_c027_3 win_3_00 0) relay vt1=-1m vt2=1m ropen=ropen_mix rclosed=rclosed_mix
EMIXQ_c027_3_00 (mix_q_src_c027_3_00 0 bpf_c027_3 0) vcvs gain=1.950903220161e-01
SMIXQ_c027_3_00 (mix_q_src_c027_3_00 mix_q_c027_3 win_3_00 0) relay vt1=-1m vt2=1m ropen=ropen_mix rclosed=rclosed_mix
EMIXI_c027_3_01 (mix_i_src_c027_3_01 0 bpf_c027_3 0) vcvs gain=8.314696123025e-01
SMIXI_c027_3_01 (mix_i_src_c027_3_01 mix_i_c027_3 win_3_01 0) relay vt1=-1m vt2=1m ropen=ropen_mix rclosed=rclosed_mix
EMIXQ_c027_3_01 (mix_q_src_c027_3_01 0 bpf_c027_3 0) vcvs gain=5.555702330196e-01
SMIXQ_c027_3_01 (mix_q_src_c027_3_01 mix_q_c027_3 win_3_01 0) relay vt1=-1m vt2=1m ropen=ropen_mix rclosed=rclosed_mix
EMIXI_c027_3_02 (mix_i_src_c027_3_02 0 bpf_c027_3 0) vcvs gain=5.555702330196e-01
SMIXI_c027_3_02 (mix_i_src_c027_3_02 mix_i_c027_3 win_3_02 0) relay vt1=-1m vt2=1m ropen=ropen_mix rclosed=rclosed_mix
EMIXQ_c027_3_02 (mix_q_src_c027_3_02 0 bpf_c027_3 0) vcvs gain=8.314696123025e-01
SMIXQ_c027_3_02 (mix_q_src_c027_3_02 mix_q_c027_3 win_3_02 0) relay vt1=-1m vt2=1m ropen=ropen_mix rclosed=rclosed_mix
EMIXI_c027_3_03 (mix_i_src_c027_3_03 0 bpf_c027_3 0) vcvs gain=1.950903220161e-01
SMIXI_c027_3_03 (mix_i_src_c027_3_03 mix_i_c027_3 win_3_03 0) relay vt1=-1m vt2=1m ropen=ropen_mix rclosed=rclosed_mix
EMIXQ_c027_3_03 (mix_q_src_c027_3_03 0 bpf_c027_3 0) vcvs gain=9.807852804032e-01
SMIXQ_c027_3_03 (mix_q_src_c027_3_03 mix_q_c027_3 win_3_03 0) relay vt1=-1m vt2=1m ropen=ropen_mix rclosed=rclosed_mix
EMIXI_c027_3_04 (mix_i_src_c027_3_04 0 bpf_c027_3 0) vcvs gain=-1.950903220161e-01
SMIXI_c027_3_04 (mix_i_src_c027_3_04 mix_i_c027_3 win_3_04 0) relay vt1=-1m vt2=1m ropen=ropen_mix rclosed=rclosed_mix
EMIXQ_c027_3_04 (mix_q_src_c027_3_04 0 bpf_c027_3 0) vcvs gain=9.807852804032e-01
SMIXQ_c027_3_04 (mix_q_src_c027_3_04 mix_q_c027_3 win_3_04 0) relay vt1=-1m vt2=1m ropen=ropen_mix rclosed=rclosed_mix
EMIXI_c027_3_05 (mix_i_src_c027_3_05 0 bpf_c027_3 0) vcvs gain=-5.555702330196e-01
SMIXI_c027_3_05 (mix_i_src_c027_3_05 mix_i_c027_3 win_3_05 0) relay vt1=-1m vt2=1m ropen=ropen_mix rclosed=rclosed_mix
EMIXQ_c027_3_05 (mix_q_src_c027_3_05 0 bpf_c027_3 0) vcvs gain=8.314696123025e-01
SMIXQ_c027_3_05 (mix_q_src_c027_3_05 mix_q_c027_3 win_3_05 0) relay vt1=-1m vt2=1m ropen=ropen_mix rclosed=rclosed_mix
EMIXI_c027_3_06 (mix_i_src_c027_3_06 0 bpf_c027_3 0) vcvs gain=-8.314696123025e-01
SMIXI_c027_3_06 (mix_i_src_c027_3_06 mix_i_c027_3 win_3_06 0) relay vt1=-1m vt2=1m ropen=ropen_mix rclosed=rclosed_mix
EMIXQ_c027_3_06 (mix_q_src_c027_3_06 0 bpf_c027_3 0) vcvs gain=5.555702330196e-01
SMIXQ_c027_3_06 (mix_q_src_c027_3_06 mix_q_c027_3 win_3_06 0) relay vt1=-1m vt2=1m ropen=ropen_mix rclosed=rclosed_mix
EMIXI_c027_3_07 (mix_i_src_c027_3_07 0 bpf_c027_3 0) vcvs gain=-9.807852804032e-01
SMIXI_c027_3_07 (mix_i_src_c027_3_07 mix_i_c027_3 win_3_07 0) relay vt1=-1m vt2=1m ropen=ropen_mix rclosed=rclosed_mix
EMIXQ_c027_3_07 (mix_q_src_c027_3_07 0 bpf_c027_3 0) vcvs gain=1.950903220161e-01
SMIXQ_c027_3_07 (mix_q_src_c027_3_07 mix_q_c027_3 win_3_07 0) relay vt1=-1m vt2=1m ropen=ropen_mix rclosed=rclosed_mix
EMIXI_c027_3_08 (mix_i_src_c027_3_08 0 bpf_c027_3 0) vcvs gain=-9.807852804032e-01
SMIXI_c027_3_08 (mix_i_src_c027_3_08 mix_i_c027_3 win_3_08 0) relay vt1=-1m vt2=1m ropen=ropen_mix rclosed=rclosed_mix
EMIXQ_c027_3_08 (mix_q_src_c027_3_08 0 bpf_c027_3 0) vcvs gain=-1.950903220161e-01
SMIXQ_c027_3_08 (mix_q_src_c027_3_08 mix_q_c027_3 win_3_08 0) relay vt1=-1m vt2=1m ropen=ropen_mix rclosed=rclosed_mix
EMIXI_c027_3_09 (mix_i_src_c027_3_09 0 bpf_c027_3 0) vcvs gain=-8.314696123025e-01
SMIXI_c027_3_09 (mix_i_src_c027_3_09 mix_i_c027_3 win_3_09 0) relay vt1=-1m vt2=1m ropen=ropen_mix rclosed=rclosed_mix
EMIXQ_c027_3_09 (mix_q_src_c027_3_09 0 bpf_c027_3 0) vcvs gain=-5.555702330196e-01
SMIXQ_c027_3_09 (mix_q_src_c027_3_09 mix_q_c027_3 win_3_09 0) relay vt1=-1m vt2=1m ropen=ropen_mix rclosed=rclosed_mix
EMIXI_c027_3_10 (mix_i_src_c027_3_10 0 bpf_c027_3 0) vcvs gain=-5.555702330196e-01
SMIXI_c027_3_10 (mix_i_src_c027_3_10 mix_i_c027_3 win_3_10 0) relay vt1=-1m vt2=1m ropen=ropen_mix rclosed=rclosed_mix
EMIXQ_c027_3_10 (mix_q_src_c027_3_10 0 bpf_c027_3 0) vcvs gain=-8.314696123025e-01
SMIXQ_c027_3_10 (mix_q_src_c027_3_10 mix_q_c027_3 win_3_10 0) relay vt1=-1m vt2=1m ropen=ropen_mix rclosed=rclosed_mix
EMIXI_c027_3_11 (mix_i_src_c027_3_11 0 bpf_c027_3 0) vcvs gain=-1.950903220161e-01
SMIXI_c027_3_11 (mix_i_src_c027_3_11 mix_i_c027_3 win_3_11 0) relay vt1=-1m vt2=1m ropen=ropen_mix rclosed=rclosed_mix
EMIXQ_c027_3_11 (mix_q_src_c027_3_11 0 bpf_c027_3 0) vcvs gain=-9.807852804032e-01
SMIXQ_c027_3_11 (mix_q_src_c027_3_11 mix_q_c027_3 win_3_11 0) relay vt1=-1m vt2=1m ropen=ropen_mix rclosed=rclosed_mix
EMIXI_c027_3_12 (mix_i_src_c027_3_12 0 bpf_c027_3 0) vcvs gain=1.950903220161e-01
SMIXI_c027_3_12 (mix_i_src_c027_3_12 mix_i_c027_3 win_3_12 0) relay vt1=-1m vt2=1m ropen=ropen_mix rclosed=rclosed_mix
EMIXQ_c027_3_12 (mix_q_src_c027_3_12 0 bpf_c027_3 0) vcvs gain=-9.807852804032e-01
SMIXQ_c027_3_12 (mix_q_src_c027_3_12 mix_q_c027_3 win_3_12 0) relay vt1=-1m vt2=1m ropen=ropen_mix rclosed=rclosed_mix
EMIXI_c027_3_13 (mix_i_src_c027_3_13 0 bpf_c027_3 0) vcvs gain=5.555702330196e-01
SMIXI_c027_3_13 (mix_i_src_c027_3_13 mix_i_c027_3 win_3_13 0) relay vt1=-1m vt2=1m ropen=ropen_mix rclosed=rclosed_mix
EMIXQ_c027_3_13 (mix_q_src_c027_3_13 0 bpf_c027_3 0) vcvs gain=-8.314696123025e-01
SMIXQ_c027_3_13 (mix_q_src_c027_3_13 mix_q_c027_3 win_3_13 0) relay vt1=-1m vt2=1m ropen=ropen_mix rclosed=rclosed_mix
EMIXI_c027_3_14 (mix_i_src_c027_3_14 0 bpf_c027_3 0) vcvs gain=8.314696123025e-01
SMIXI_c027_3_14 (mix_i_src_c027_3_14 mix_i_c027_3 win_3_14 0) relay vt1=-1m vt2=1m ropen=ropen_mix rclosed=rclosed_mix
EMIXQ_c027_3_14 (mix_q_src_c027_3_14 0 bpf_c027_3 0) vcvs gain=-5.555702330196e-01
SMIXQ_c027_3_14 (mix_q_src_c027_3_14 mix_q_c027_3 win_3_14 0) relay vt1=-1m vt2=1m ropen=ropen_mix rclosed=rclosed_mix
EMIXI_c027_3_15 (mix_i_src_c027_3_15 0 bpf_c027_3 0) vcvs gain=9.807852804032e-01
SMIXI_c027_3_15 (mix_i_src_c027_3_15 mix_i_c027_3 win_3_15 0) relay vt1=-1m vt2=1m ropen=ropen_mix rclosed=rclosed_mix
EMIXQ_c027_3_15 (mix_q_src_c027_3_15 0 bpf_c027_3 0) vcvs gain=-1.950903220161e-01
SMIXQ_c027_3_15 (mix_q_src_c027_3_15 mix_q_c027_3 win_3_15 0) relay vt1=-1m vt2=1m ropen=ropen_mix rclosed=rclosed_mix
RMIXI_c027_3 (mix_i_c027_3 0) resistor r=1G
RMIXQ_c027_3 (mix_q_c027_3 0) resistor r=1G
RINTI_c027_3 (mix_i_c027_3 Icar_c027_3) resistor r=1k
CINTI_c027_3 (Icar_c027_3 0) capacitor c=80p
RINTQ_c027_3 (mix_q_c027_3 Qcar_c027_3) resistor r=1k
CINTQ_c027_3 (Qcar_c027_3 0) capacitor c=80p
save bpf_c027_3 Icar_c027_3 Qcar_c027_3

// bl028, carrier_0: 250000000 Hz coherent I/Q phase-window verification-demod path
CBPF_c028_0 (bl028 n_cbpf_c028_0) capacitor c=4.052847345694e-13
LBPF_c028_0 (n_cbpf_c028_0 bpf_c028_0) inductor l=1.000000000000e-06
RBPF_c028_0 (bpf_c028_0 0) resistor r=7.853981633974e+01
EMIXI_c028_0_00 (mix_i_src_c028_0_00 0 bpf_c028_0 0) vcvs gain=9.807852804032e-01
SMIXI_c028_0_00 (mix_i_src_c028_0_00 mix_i_c028_0 win_0_00 0) relay vt1=-1m vt2=1m ropen=ropen_mix rclosed=rclosed_mix
EMIXQ_c028_0_00 (mix_q_src_c028_0_00 0 bpf_c028_0 0) vcvs gain=1.950903220161e-01
SMIXQ_c028_0_00 (mix_q_src_c028_0_00 mix_q_c028_0 win_0_00 0) relay vt1=-1m vt2=1m ropen=ropen_mix rclosed=rclosed_mix
EMIXI_c028_0_01 (mix_i_src_c028_0_01 0 bpf_c028_0 0) vcvs gain=8.314696123025e-01
SMIXI_c028_0_01 (mix_i_src_c028_0_01 mix_i_c028_0 win_0_01 0) relay vt1=-1m vt2=1m ropen=ropen_mix rclosed=rclosed_mix
EMIXQ_c028_0_01 (mix_q_src_c028_0_01 0 bpf_c028_0 0) vcvs gain=5.555702330196e-01
SMIXQ_c028_0_01 (mix_q_src_c028_0_01 mix_q_c028_0 win_0_01 0) relay vt1=-1m vt2=1m ropen=ropen_mix rclosed=rclosed_mix
EMIXI_c028_0_02 (mix_i_src_c028_0_02 0 bpf_c028_0 0) vcvs gain=5.555702330196e-01
SMIXI_c028_0_02 (mix_i_src_c028_0_02 mix_i_c028_0 win_0_02 0) relay vt1=-1m vt2=1m ropen=ropen_mix rclosed=rclosed_mix
EMIXQ_c028_0_02 (mix_q_src_c028_0_02 0 bpf_c028_0 0) vcvs gain=8.314696123025e-01
SMIXQ_c028_0_02 (mix_q_src_c028_0_02 mix_q_c028_0 win_0_02 0) relay vt1=-1m vt2=1m ropen=ropen_mix rclosed=rclosed_mix
EMIXI_c028_0_03 (mix_i_src_c028_0_03 0 bpf_c028_0 0) vcvs gain=1.950903220161e-01
SMIXI_c028_0_03 (mix_i_src_c028_0_03 mix_i_c028_0 win_0_03 0) relay vt1=-1m vt2=1m ropen=ropen_mix rclosed=rclosed_mix
EMIXQ_c028_0_03 (mix_q_src_c028_0_03 0 bpf_c028_0 0) vcvs gain=9.807852804032e-01
SMIXQ_c028_0_03 (mix_q_src_c028_0_03 mix_q_c028_0 win_0_03 0) relay vt1=-1m vt2=1m ropen=ropen_mix rclosed=rclosed_mix
EMIXI_c028_0_04 (mix_i_src_c028_0_04 0 bpf_c028_0 0) vcvs gain=-1.950903220161e-01
SMIXI_c028_0_04 (mix_i_src_c028_0_04 mix_i_c028_0 win_0_04 0) relay vt1=-1m vt2=1m ropen=ropen_mix rclosed=rclosed_mix
EMIXQ_c028_0_04 (mix_q_src_c028_0_04 0 bpf_c028_0 0) vcvs gain=9.807852804032e-01
SMIXQ_c028_0_04 (mix_q_src_c028_0_04 mix_q_c028_0 win_0_04 0) relay vt1=-1m vt2=1m ropen=ropen_mix rclosed=rclosed_mix
EMIXI_c028_0_05 (mix_i_src_c028_0_05 0 bpf_c028_0 0) vcvs gain=-5.555702330196e-01
SMIXI_c028_0_05 (mix_i_src_c028_0_05 mix_i_c028_0 win_0_05 0) relay vt1=-1m vt2=1m ropen=ropen_mix rclosed=rclosed_mix
EMIXQ_c028_0_05 (mix_q_src_c028_0_05 0 bpf_c028_0 0) vcvs gain=8.314696123025e-01
SMIXQ_c028_0_05 (mix_q_src_c028_0_05 mix_q_c028_0 win_0_05 0) relay vt1=-1m vt2=1m ropen=ropen_mix rclosed=rclosed_mix
EMIXI_c028_0_06 (mix_i_src_c028_0_06 0 bpf_c028_0 0) vcvs gain=-8.314696123025e-01
SMIXI_c028_0_06 (mix_i_src_c028_0_06 mix_i_c028_0 win_0_06 0) relay vt1=-1m vt2=1m ropen=ropen_mix rclosed=rclosed_mix
EMIXQ_c028_0_06 (mix_q_src_c028_0_06 0 bpf_c028_0 0) vcvs gain=5.555702330196e-01
SMIXQ_c028_0_06 (mix_q_src_c028_0_06 mix_q_c028_0 win_0_06 0) relay vt1=-1m vt2=1m ropen=ropen_mix rclosed=rclosed_mix
EMIXI_c028_0_07 (mix_i_src_c028_0_07 0 bpf_c028_0 0) vcvs gain=-9.807852804032e-01
SMIXI_c028_0_07 (mix_i_src_c028_0_07 mix_i_c028_0 win_0_07 0) relay vt1=-1m vt2=1m ropen=ropen_mix rclosed=rclosed_mix
EMIXQ_c028_0_07 (mix_q_src_c028_0_07 0 bpf_c028_0 0) vcvs gain=1.950903220161e-01
SMIXQ_c028_0_07 (mix_q_src_c028_0_07 mix_q_c028_0 win_0_07 0) relay vt1=-1m vt2=1m ropen=ropen_mix rclosed=rclosed_mix
EMIXI_c028_0_08 (mix_i_src_c028_0_08 0 bpf_c028_0 0) vcvs gain=-9.807852804032e-01
SMIXI_c028_0_08 (mix_i_src_c028_0_08 mix_i_c028_0 win_0_08 0) relay vt1=-1m vt2=1m ropen=ropen_mix rclosed=rclosed_mix
EMIXQ_c028_0_08 (mix_q_src_c028_0_08 0 bpf_c028_0 0) vcvs gain=-1.950903220161e-01
SMIXQ_c028_0_08 (mix_q_src_c028_0_08 mix_q_c028_0 win_0_08 0) relay vt1=-1m vt2=1m ropen=ropen_mix rclosed=rclosed_mix
EMIXI_c028_0_09 (mix_i_src_c028_0_09 0 bpf_c028_0 0) vcvs gain=-8.314696123025e-01
SMIXI_c028_0_09 (mix_i_src_c028_0_09 mix_i_c028_0 win_0_09 0) relay vt1=-1m vt2=1m ropen=ropen_mix rclosed=rclosed_mix
EMIXQ_c028_0_09 (mix_q_src_c028_0_09 0 bpf_c028_0 0) vcvs gain=-5.555702330196e-01
SMIXQ_c028_0_09 (mix_q_src_c028_0_09 mix_q_c028_0 win_0_09 0) relay vt1=-1m vt2=1m ropen=ropen_mix rclosed=rclosed_mix
EMIXI_c028_0_10 (mix_i_src_c028_0_10 0 bpf_c028_0 0) vcvs gain=-5.555702330196e-01
SMIXI_c028_0_10 (mix_i_src_c028_0_10 mix_i_c028_0 win_0_10 0) relay vt1=-1m vt2=1m ropen=ropen_mix rclosed=rclosed_mix
EMIXQ_c028_0_10 (mix_q_src_c028_0_10 0 bpf_c028_0 0) vcvs gain=-8.314696123025e-01
SMIXQ_c028_0_10 (mix_q_src_c028_0_10 mix_q_c028_0 win_0_10 0) relay vt1=-1m vt2=1m ropen=ropen_mix rclosed=rclosed_mix
EMIXI_c028_0_11 (mix_i_src_c028_0_11 0 bpf_c028_0 0) vcvs gain=-1.950903220161e-01
SMIXI_c028_0_11 (mix_i_src_c028_0_11 mix_i_c028_0 win_0_11 0) relay vt1=-1m vt2=1m ropen=ropen_mix rclosed=rclosed_mix
EMIXQ_c028_0_11 (mix_q_src_c028_0_11 0 bpf_c028_0 0) vcvs gain=-9.807852804032e-01
SMIXQ_c028_0_11 (mix_q_src_c028_0_11 mix_q_c028_0 win_0_11 0) relay vt1=-1m vt2=1m ropen=ropen_mix rclosed=rclosed_mix
EMIXI_c028_0_12 (mix_i_src_c028_0_12 0 bpf_c028_0 0) vcvs gain=1.950903220161e-01
SMIXI_c028_0_12 (mix_i_src_c028_0_12 mix_i_c028_0 win_0_12 0) relay vt1=-1m vt2=1m ropen=ropen_mix rclosed=rclosed_mix
EMIXQ_c028_0_12 (mix_q_src_c028_0_12 0 bpf_c028_0 0) vcvs gain=-9.807852804032e-01
SMIXQ_c028_0_12 (mix_q_src_c028_0_12 mix_q_c028_0 win_0_12 0) relay vt1=-1m vt2=1m ropen=ropen_mix rclosed=rclosed_mix
EMIXI_c028_0_13 (mix_i_src_c028_0_13 0 bpf_c028_0 0) vcvs gain=5.555702330196e-01
SMIXI_c028_0_13 (mix_i_src_c028_0_13 mix_i_c028_0 win_0_13 0) relay vt1=-1m vt2=1m ropen=ropen_mix rclosed=rclosed_mix
EMIXQ_c028_0_13 (mix_q_src_c028_0_13 0 bpf_c028_0 0) vcvs gain=-8.314696123025e-01
SMIXQ_c028_0_13 (mix_q_src_c028_0_13 mix_q_c028_0 win_0_13 0) relay vt1=-1m vt2=1m ropen=ropen_mix rclosed=rclosed_mix
EMIXI_c028_0_14 (mix_i_src_c028_0_14 0 bpf_c028_0 0) vcvs gain=8.314696123025e-01
SMIXI_c028_0_14 (mix_i_src_c028_0_14 mix_i_c028_0 win_0_14 0) relay vt1=-1m vt2=1m ropen=ropen_mix rclosed=rclosed_mix
EMIXQ_c028_0_14 (mix_q_src_c028_0_14 0 bpf_c028_0 0) vcvs gain=-5.555702330196e-01
SMIXQ_c028_0_14 (mix_q_src_c028_0_14 mix_q_c028_0 win_0_14 0) relay vt1=-1m vt2=1m ropen=ropen_mix rclosed=rclosed_mix
EMIXI_c028_0_15 (mix_i_src_c028_0_15 0 bpf_c028_0 0) vcvs gain=9.807852804032e-01
SMIXI_c028_0_15 (mix_i_src_c028_0_15 mix_i_c028_0 win_0_15 0) relay vt1=-1m vt2=1m ropen=ropen_mix rclosed=rclosed_mix
EMIXQ_c028_0_15 (mix_q_src_c028_0_15 0 bpf_c028_0 0) vcvs gain=-1.950903220161e-01
SMIXQ_c028_0_15 (mix_q_src_c028_0_15 mix_q_c028_0 win_0_15 0) relay vt1=-1m vt2=1m ropen=ropen_mix rclosed=rclosed_mix
RMIXI_c028_0 (mix_i_c028_0 0) resistor r=1G
RMIXQ_c028_0 (mix_q_c028_0 0) resistor r=1G
RINTI_c028_0 (mix_i_c028_0 Icar_c028_0) resistor r=1k
CINTI_c028_0 (Icar_c028_0 0) capacitor c=80p
RINTQ_c028_0 (mix_q_c028_0 Qcar_c028_0) resistor r=1k
CINTQ_c028_0 (Qcar_c028_0 0) capacitor c=80p
save bpf_c028_0 Icar_c028_0 Qcar_c028_0

// bl028, carrier_1: 500000000 Hz coherent I/Q phase-window verification-demod path
CBPF_c028_1 (bl028 n_cbpf_c028_1) capacitor c=1.013211836423e-13
LBPF_c028_1 (n_cbpf_c028_1 bpf_c028_1) inductor l=1.000000000000e-06
RBPF_c028_1 (bpf_c028_1 0) resistor r=1.570796326795e+02
EMIXI_c028_1_00 (mix_i_src_c028_1_00 0 bpf_c028_1 0) vcvs gain=9.807852804032e-01
SMIXI_c028_1_00 (mix_i_src_c028_1_00 mix_i_c028_1 win_1_00 0) relay vt1=-1m vt2=1m ropen=ropen_mix rclosed=rclosed_mix
EMIXQ_c028_1_00 (mix_q_src_c028_1_00 0 bpf_c028_1 0) vcvs gain=1.950903220161e-01
SMIXQ_c028_1_00 (mix_q_src_c028_1_00 mix_q_c028_1 win_1_00 0) relay vt1=-1m vt2=1m ropen=ropen_mix rclosed=rclosed_mix
EMIXI_c028_1_01 (mix_i_src_c028_1_01 0 bpf_c028_1 0) vcvs gain=8.314696123025e-01
SMIXI_c028_1_01 (mix_i_src_c028_1_01 mix_i_c028_1 win_1_01 0) relay vt1=-1m vt2=1m ropen=ropen_mix rclosed=rclosed_mix
EMIXQ_c028_1_01 (mix_q_src_c028_1_01 0 bpf_c028_1 0) vcvs gain=5.555702330196e-01
SMIXQ_c028_1_01 (mix_q_src_c028_1_01 mix_q_c028_1 win_1_01 0) relay vt1=-1m vt2=1m ropen=ropen_mix rclosed=rclosed_mix
EMIXI_c028_1_02 (mix_i_src_c028_1_02 0 bpf_c028_1 0) vcvs gain=5.555702330196e-01
SMIXI_c028_1_02 (mix_i_src_c028_1_02 mix_i_c028_1 win_1_02 0) relay vt1=-1m vt2=1m ropen=ropen_mix rclosed=rclosed_mix
EMIXQ_c028_1_02 (mix_q_src_c028_1_02 0 bpf_c028_1 0) vcvs gain=8.314696123025e-01
SMIXQ_c028_1_02 (mix_q_src_c028_1_02 mix_q_c028_1 win_1_02 0) relay vt1=-1m vt2=1m ropen=ropen_mix rclosed=rclosed_mix
EMIXI_c028_1_03 (mix_i_src_c028_1_03 0 bpf_c028_1 0) vcvs gain=1.950903220161e-01
SMIXI_c028_1_03 (mix_i_src_c028_1_03 mix_i_c028_1 win_1_03 0) relay vt1=-1m vt2=1m ropen=ropen_mix rclosed=rclosed_mix
EMIXQ_c028_1_03 (mix_q_src_c028_1_03 0 bpf_c028_1 0) vcvs gain=9.807852804032e-01
SMIXQ_c028_1_03 (mix_q_src_c028_1_03 mix_q_c028_1 win_1_03 0) relay vt1=-1m vt2=1m ropen=ropen_mix rclosed=rclosed_mix
EMIXI_c028_1_04 (mix_i_src_c028_1_04 0 bpf_c028_1 0) vcvs gain=-1.950903220161e-01
SMIXI_c028_1_04 (mix_i_src_c028_1_04 mix_i_c028_1 win_1_04 0) relay vt1=-1m vt2=1m ropen=ropen_mix rclosed=rclosed_mix
EMIXQ_c028_1_04 (mix_q_src_c028_1_04 0 bpf_c028_1 0) vcvs gain=9.807852804032e-01
SMIXQ_c028_1_04 (mix_q_src_c028_1_04 mix_q_c028_1 win_1_04 0) relay vt1=-1m vt2=1m ropen=ropen_mix rclosed=rclosed_mix
EMIXI_c028_1_05 (mix_i_src_c028_1_05 0 bpf_c028_1 0) vcvs gain=-5.555702330196e-01
SMIXI_c028_1_05 (mix_i_src_c028_1_05 mix_i_c028_1 win_1_05 0) relay vt1=-1m vt2=1m ropen=ropen_mix rclosed=rclosed_mix
EMIXQ_c028_1_05 (mix_q_src_c028_1_05 0 bpf_c028_1 0) vcvs gain=8.314696123025e-01
SMIXQ_c028_1_05 (mix_q_src_c028_1_05 mix_q_c028_1 win_1_05 0) relay vt1=-1m vt2=1m ropen=ropen_mix rclosed=rclosed_mix
EMIXI_c028_1_06 (mix_i_src_c028_1_06 0 bpf_c028_1 0) vcvs gain=-8.314696123025e-01
SMIXI_c028_1_06 (mix_i_src_c028_1_06 mix_i_c028_1 win_1_06 0) relay vt1=-1m vt2=1m ropen=ropen_mix rclosed=rclosed_mix
EMIXQ_c028_1_06 (mix_q_src_c028_1_06 0 bpf_c028_1 0) vcvs gain=5.555702330196e-01
SMIXQ_c028_1_06 (mix_q_src_c028_1_06 mix_q_c028_1 win_1_06 0) relay vt1=-1m vt2=1m ropen=ropen_mix rclosed=rclosed_mix
EMIXI_c028_1_07 (mix_i_src_c028_1_07 0 bpf_c028_1 0) vcvs gain=-9.807852804032e-01
SMIXI_c028_1_07 (mix_i_src_c028_1_07 mix_i_c028_1 win_1_07 0) relay vt1=-1m vt2=1m ropen=ropen_mix rclosed=rclosed_mix
EMIXQ_c028_1_07 (mix_q_src_c028_1_07 0 bpf_c028_1 0) vcvs gain=1.950903220161e-01
SMIXQ_c028_1_07 (mix_q_src_c028_1_07 mix_q_c028_1 win_1_07 0) relay vt1=-1m vt2=1m ropen=ropen_mix rclosed=rclosed_mix
EMIXI_c028_1_08 (mix_i_src_c028_1_08 0 bpf_c028_1 0) vcvs gain=-9.807852804032e-01
SMIXI_c028_1_08 (mix_i_src_c028_1_08 mix_i_c028_1 win_1_08 0) relay vt1=-1m vt2=1m ropen=ropen_mix rclosed=rclosed_mix
EMIXQ_c028_1_08 (mix_q_src_c028_1_08 0 bpf_c028_1 0) vcvs gain=-1.950903220161e-01
SMIXQ_c028_1_08 (mix_q_src_c028_1_08 mix_q_c028_1 win_1_08 0) relay vt1=-1m vt2=1m ropen=ropen_mix rclosed=rclosed_mix
EMIXI_c028_1_09 (mix_i_src_c028_1_09 0 bpf_c028_1 0) vcvs gain=-8.314696123025e-01
SMIXI_c028_1_09 (mix_i_src_c028_1_09 mix_i_c028_1 win_1_09 0) relay vt1=-1m vt2=1m ropen=ropen_mix rclosed=rclosed_mix
EMIXQ_c028_1_09 (mix_q_src_c028_1_09 0 bpf_c028_1 0) vcvs gain=-5.555702330196e-01
SMIXQ_c028_1_09 (mix_q_src_c028_1_09 mix_q_c028_1 win_1_09 0) relay vt1=-1m vt2=1m ropen=ropen_mix rclosed=rclosed_mix
EMIXI_c028_1_10 (mix_i_src_c028_1_10 0 bpf_c028_1 0) vcvs gain=-5.555702330196e-01
SMIXI_c028_1_10 (mix_i_src_c028_1_10 mix_i_c028_1 win_1_10 0) relay vt1=-1m vt2=1m ropen=ropen_mix rclosed=rclosed_mix
EMIXQ_c028_1_10 (mix_q_src_c028_1_10 0 bpf_c028_1 0) vcvs gain=-8.314696123025e-01
SMIXQ_c028_1_10 (mix_q_src_c028_1_10 mix_q_c028_1 win_1_10 0) relay vt1=-1m vt2=1m ropen=ropen_mix rclosed=rclosed_mix
EMIXI_c028_1_11 (mix_i_src_c028_1_11 0 bpf_c028_1 0) vcvs gain=-1.950903220161e-01
SMIXI_c028_1_11 (mix_i_src_c028_1_11 mix_i_c028_1 win_1_11 0) relay vt1=-1m vt2=1m ropen=ropen_mix rclosed=rclosed_mix
EMIXQ_c028_1_11 (mix_q_src_c028_1_11 0 bpf_c028_1 0) vcvs gain=-9.807852804032e-01
SMIXQ_c028_1_11 (mix_q_src_c028_1_11 mix_q_c028_1 win_1_11 0) relay vt1=-1m vt2=1m ropen=ropen_mix rclosed=rclosed_mix
EMIXI_c028_1_12 (mix_i_src_c028_1_12 0 bpf_c028_1 0) vcvs gain=1.950903220161e-01
SMIXI_c028_1_12 (mix_i_src_c028_1_12 mix_i_c028_1 win_1_12 0) relay vt1=-1m vt2=1m ropen=ropen_mix rclosed=rclosed_mix
EMIXQ_c028_1_12 (mix_q_src_c028_1_12 0 bpf_c028_1 0) vcvs gain=-9.807852804032e-01
SMIXQ_c028_1_12 (mix_q_src_c028_1_12 mix_q_c028_1 win_1_12 0) relay vt1=-1m vt2=1m ropen=ropen_mix rclosed=rclosed_mix
EMIXI_c028_1_13 (mix_i_src_c028_1_13 0 bpf_c028_1 0) vcvs gain=5.555702330196e-01
SMIXI_c028_1_13 (mix_i_src_c028_1_13 mix_i_c028_1 win_1_13 0) relay vt1=-1m vt2=1m ropen=ropen_mix rclosed=rclosed_mix
EMIXQ_c028_1_13 (mix_q_src_c028_1_13 0 bpf_c028_1 0) vcvs gain=-8.314696123025e-01
SMIXQ_c028_1_13 (mix_q_src_c028_1_13 mix_q_c028_1 win_1_13 0) relay vt1=-1m vt2=1m ropen=ropen_mix rclosed=rclosed_mix
EMIXI_c028_1_14 (mix_i_src_c028_1_14 0 bpf_c028_1 0) vcvs gain=8.314696123025e-01
SMIXI_c028_1_14 (mix_i_src_c028_1_14 mix_i_c028_1 win_1_14 0) relay vt1=-1m vt2=1m ropen=ropen_mix rclosed=rclosed_mix
EMIXQ_c028_1_14 (mix_q_src_c028_1_14 0 bpf_c028_1 0) vcvs gain=-5.555702330196e-01
SMIXQ_c028_1_14 (mix_q_src_c028_1_14 mix_q_c028_1 win_1_14 0) relay vt1=-1m vt2=1m ropen=ropen_mix rclosed=rclosed_mix
EMIXI_c028_1_15 (mix_i_src_c028_1_15 0 bpf_c028_1 0) vcvs gain=9.807852804032e-01
SMIXI_c028_1_15 (mix_i_src_c028_1_15 mix_i_c028_1 win_1_15 0) relay vt1=-1m vt2=1m ropen=ropen_mix rclosed=rclosed_mix
EMIXQ_c028_1_15 (mix_q_src_c028_1_15 0 bpf_c028_1 0) vcvs gain=-1.950903220161e-01
SMIXQ_c028_1_15 (mix_q_src_c028_1_15 mix_q_c028_1 win_1_15 0) relay vt1=-1m vt2=1m ropen=ropen_mix rclosed=rclosed_mix
RMIXI_c028_1 (mix_i_c028_1 0) resistor r=1G
RMIXQ_c028_1 (mix_q_c028_1 0) resistor r=1G
RINTI_c028_1 (mix_i_c028_1 Icar_c028_1) resistor r=1k
CINTI_c028_1 (Icar_c028_1 0) capacitor c=80p
RINTQ_c028_1 (mix_q_c028_1 Qcar_c028_1) resistor r=1k
CINTQ_c028_1 (Qcar_c028_1 0) capacitor c=80p
save bpf_c028_1 Icar_c028_1 Qcar_c028_1

// bl028, carrier_2: 750000000 Hz coherent I/Q phase-window verification-demod path
CBPF_c028_2 (bl028 n_cbpf_c028_2) capacitor c=4.503163717437e-14
LBPF_c028_2 (n_cbpf_c028_2 bpf_c028_2) inductor l=1.000000000000e-06
RBPF_c028_2 (bpf_c028_2 0) resistor r=2.356194490192e+02
EMIXI_c028_2_00 (mix_i_src_c028_2_00 0 bpf_c028_2 0) vcvs gain=9.807852804032e-01
SMIXI_c028_2_00 (mix_i_src_c028_2_00 mix_i_c028_2 win_2_00 0) relay vt1=-1m vt2=1m ropen=ropen_mix rclosed=rclosed_mix
EMIXQ_c028_2_00 (mix_q_src_c028_2_00 0 bpf_c028_2 0) vcvs gain=1.950903220161e-01
SMIXQ_c028_2_00 (mix_q_src_c028_2_00 mix_q_c028_2 win_2_00 0) relay vt1=-1m vt2=1m ropen=ropen_mix rclosed=rclosed_mix
EMIXI_c028_2_01 (mix_i_src_c028_2_01 0 bpf_c028_2 0) vcvs gain=8.314696123025e-01
SMIXI_c028_2_01 (mix_i_src_c028_2_01 mix_i_c028_2 win_2_01 0) relay vt1=-1m vt2=1m ropen=ropen_mix rclosed=rclosed_mix
EMIXQ_c028_2_01 (mix_q_src_c028_2_01 0 bpf_c028_2 0) vcvs gain=5.555702330196e-01
SMIXQ_c028_2_01 (mix_q_src_c028_2_01 mix_q_c028_2 win_2_01 0) relay vt1=-1m vt2=1m ropen=ropen_mix rclosed=rclosed_mix
EMIXI_c028_2_02 (mix_i_src_c028_2_02 0 bpf_c028_2 0) vcvs gain=5.555702330196e-01
SMIXI_c028_2_02 (mix_i_src_c028_2_02 mix_i_c028_2 win_2_02 0) relay vt1=-1m vt2=1m ropen=ropen_mix rclosed=rclosed_mix
EMIXQ_c028_2_02 (mix_q_src_c028_2_02 0 bpf_c028_2 0) vcvs gain=8.314696123025e-01
SMIXQ_c028_2_02 (mix_q_src_c028_2_02 mix_q_c028_2 win_2_02 0) relay vt1=-1m vt2=1m ropen=ropen_mix rclosed=rclosed_mix
EMIXI_c028_2_03 (mix_i_src_c028_2_03 0 bpf_c028_2 0) vcvs gain=1.950903220161e-01
SMIXI_c028_2_03 (mix_i_src_c028_2_03 mix_i_c028_2 win_2_03 0) relay vt1=-1m vt2=1m ropen=ropen_mix rclosed=rclosed_mix
EMIXQ_c028_2_03 (mix_q_src_c028_2_03 0 bpf_c028_2 0) vcvs gain=9.807852804032e-01
SMIXQ_c028_2_03 (mix_q_src_c028_2_03 mix_q_c028_2 win_2_03 0) relay vt1=-1m vt2=1m ropen=ropen_mix rclosed=rclosed_mix
EMIXI_c028_2_04 (mix_i_src_c028_2_04 0 bpf_c028_2 0) vcvs gain=-1.950903220161e-01
SMIXI_c028_2_04 (mix_i_src_c028_2_04 mix_i_c028_2 win_2_04 0) relay vt1=-1m vt2=1m ropen=ropen_mix rclosed=rclosed_mix
EMIXQ_c028_2_04 (mix_q_src_c028_2_04 0 bpf_c028_2 0) vcvs gain=9.807852804032e-01
SMIXQ_c028_2_04 (mix_q_src_c028_2_04 mix_q_c028_2 win_2_04 0) relay vt1=-1m vt2=1m ropen=ropen_mix rclosed=rclosed_mix
EMIXI_c028_2_05 (mix_i_src_c028_2_05 0 bpf_c028_2 0) vcvs gain=-5.555702330196e-01
SMIXI_c028_2_05 (mix_i_src_c028_2_05 mix_i_c028_2 win_2_05 0) relay vt1=-1m vt2=1m ropen=ropen_mix rclosed=rclosed_mix
EMIXQ_c028_2_05 (mix_q_src_c028_2_05 0 bpf_c028_2 0) vcvs gain=8.314696123025e-01
SMIXQ_c028_2_05 (mix_q_src_c028_2_05 mix_q_c028_2 win_2_05 0) relay vt1=-1m vt2=1m ropen=ropen_mix rclosed=rclosed_mix
EMIXI_c028_2_06 (mix_i_src_c028_2_06 0 bpf_c028_2 0) vcvs gain=-8.314696123025e-01
SMIXI_c028_2_06 (mix_i_src_c028_2_06 mix_i_c028_2 win_2_06 0) relay vt1=-1m vt2=1m ropen=ropen_mix rclosed=rclosed_mix
EMIXQ_c028_2_06 (mix_q_src_c028_2_06 0 bpf_c028_2 0) vcvs gain=5.555702330196e-01
SMIXQ_c028_2_06 (mix_q_src_c028_2_06 mix_q_c028_2 win_2_06 0) relay vt1=-1m vt2=1m ropen=ropen_mix rclosed=rclosed_mix
EMIXI_c028_2_07 (mix_i_src_c028_2_07 0 bpf_c028_2 0) vcvs gain=-9.807852804032e-01
SMIXI_c028_2_07 (mix_i_src_c028_2_07 mix_i_c028_2 win_2_07 0) relay vt1=-1m vt2=1m ropen=ropen_mix rclosed=rclosed_mix
EMIXQ_c028_2_07 (mix_q_src_c028_2_07 0 bpf_c028_2 0) vcvs gain=1.950903220161e-01
SMIXQ_c028_2_07 (mix_q_src_c028_2_07 mix_q_c028_2 win_2_07 0) relay vt1=-1m vt2=1m ropen=ropen_mix rclosed=rclosed_mix
EMIXI_c028_2_08 (mix_i_src_c028_2_08 0 bpf_c028_2 0) vcvs gain=-9.807852804032e-01
SMIXI_c028_2_08 (mix_i_src_c028_2_08 mix_i_c028_2 win_2_08 0) relay vt1=-1m vt2=1m ropen=ropen_mix rclosed=rclosed_mix
EMIXQ_c028_2_08 (mix_q_src_c028_2_08 0 bpf_c028_2 0) vcvs gain=-1.950903220161e-01
SMIXQ_c028_2_08 (mix_q_src_c028_2_08 mix_q_c028_2 win_2_08 0) relay vt1=-1m vt2=1m ropen=ropen_mix rclosed=rclosed_mix
EMIXI_c028_2_09 (mix_i_src_c028_2_09 0 bpf_c028_2 0) vcvs gain=-8.314696123025e-01
SMIXI_c028_2_09 (mix_i_src_c028_2_09 mix_i_c028_2 win_2_09 0) relay vt1=-1m vt2=1m ropen=ropen_mix rclosed=rclosed_mix
EMIXQ_c028_2_09 (mix_q_src_c028_2_09 0 bpf_c028_2 0) vcvs gain=-5.555702330196e-01
SMIXQ_c028_2_09 (mix_q_src_c028_2_09 mix_q_c028_2 win_2_09 0) relay vt1=-1m vt2=1m ropen=ropen_mix rclosed=rclosed_mix
EMIXI_c028_2_10 (mix_i_src_c028_2_10 0 bpf_c028_2 0) vcvs gain=-5.555702330196e-01
SMIXI_c028_2_10 (mix_i_src_c028_2_10 mix_i_c028_2 win_2_10 0) relay vt1=-1m vt2=1m ropen=ropen_mix rclosed=rclosed_mix
EMIXQ_c028_2_10 (mix_q_src_c028_2_10 0 bpf_c028_2 0) vcvs gain=-8.314696123025e-01
SMIXQ_c028_2_10 (mix_q_src_c028_2_10 mix_q_c028_2 win_2_10 0) relay vt1=-1m vt2=1m ropen=ropen_mix rclosed=rclosed_mix
EMIXI_c028_2_11 (mix_i_src_c028_2_11 0 bpf_c028_2 0) vcvs gain=-1.950903220161e-01
SMIXI_c028_2_11 (mix_i_src_c028_2_11 mix_i_c028_2 win_2_11 0) relay vt1=-1m vt2=1m ropen=ropen_mix rclosed=rclosed_mix
EMIXQ_c028_2_11 (mix_q_src_c028_2_11 0 bpf_c028_2 0) vcvs gain=-9.807852804032e-01
SMIXQ_c028_2_11 (mix_q_src_c028_2_11 mix_q_c028_2 win_2_11 0) relay vt1=-1m vt2=1m ropen=ropen_mix rclosed=rclosed_mix
EMIXI_c028_2_12 (mix_i_src_c028_2_12 0 bpf_c028_2 0) vcvs gain=1.950903220161e-01
SMIXI_c028_2_12 (mix_i_src_c028_2_12 mix_i_c028_2 win_2_12 0) relay vt1=-1m vt2=1m ropen=ropen_mix rclosed=rclosed_mix
EMIXQ_c028_2_12 (mix_q_src_c028_2_12 0 bpf_c028_2 0) vcvs gain=-9.807852804032e-01
SMIXQ_c028_2_12 (mix_q_src_c028_2_12 mix_q_c028_2 win_2_12 0) relay vt1=-1m vt2=1m ropen=ropen_mix rclosed=rclosed_mix
EMIXI_c028_2_13 (mix_i_src_c028_2_13 0 bpf_c028_2 0) vcvs gain=5.555702330196e-01
SMIXI_c028_2_13 (mix_i_src_c028_2_13 mix_i_c028_2 win_2_13 0) relay vt1=-1m vt2=1m ropen=ropen_mix rclosed=rclosed_mix
EMIXQ_c028_2_13 (mix_q_src_c028_2_13 0 bpf_c028_2 0) vcvs gain=-8.314696123025e-01
SMIXQ_c028_2_13 (mix_q_src_c028_2_13 mix_q_c028_2 win_2_13 0) relay vt1=-1m vt2=1m ropen=ropen_mix rclosed=rclosed_mix
EMIXI_c028_2_14 (mix_i_src_c028_2_14 0 bpf_c028_2 0) vcvs gain=8.314696123025e-01
SMIXI_c028_2_14 (mix_i_src_c028_2_14 mix_i_c028_2 win_2_14 0) relay vt1=-1m vt2=1m ropen=ropen_mix rclosed=rclosed_mix
EMIXQ_c028_2_14 (mix_q_src_c028_2_14 0 bpf_c028_2 0) vcvs gain=-5.555702330196e-01
SMIXQ_c028_2_14 (mix_q_src_c028_2_14 mix_q_c028_2 win_2_14 0) relay vt1=-1m vt2=1m ropen=ropen_mix rclosed=rclosed_mix
EMIXI_c028_2_15 (mix_i_src_c028_2_15 0 bpf_c028_2 0) vcvs gain=9.807852804032e-01
SMIXI_c028_2_15 (mix_i_src_c028_2_15 mix_i_c028_2 win_2_15 0) relay vt1=-1m vt2=1m ropen=ropen_mix rclosed=rclosed_mix
EMIXQ_c028_2_15 (mix_q_src_c028_2_15 0 bpf_c028_2 0) vcvs gain=-1.950903220161e-01
SMIXQ_c028_2_15 (mix_q_src_c028_2_15 mix_q_c028_2 win_2_15 0) relay vt1=-1m vt2=1m ropen=ropen_mix rclosed=rclosed_mix
RMIXI_c028_2 (mix_i_c028_2 0) resistor r=1G
RMIXQ_c028_2 (mix_q_c028_2 0) resistor r=1G
RINTI_c028_2 (mix_i_c028_2 Icar_c028_2) resistor r=1k
CINTI_c028_2 (Icar_c028_2 0) capacitor c=80p
RINTQ_c028_2 (mix_q_c028_2 Qcar_c028_2) resistor r=1k
CINTQ_c028_2 (Qcar_c028_2 0) capacitor c=80p
save bpf_c028_2 Icar_c028_2 Qcar_c028_2

// bl028, carrier_3: 1000000000 Hz coherent I/Q phase-window verification-demod path
CBPF_c028_3 (bl028 n_cbpf_c028_3) capacitor c=2.533029591058e-14
LBPF_c028_3 (n_cbpf_c028_3 bpf_c028_3) inductor l=1.000000000000e-06
RBPF_c028_3 (bpf_c028_3 0) resistor r=3.141592653590e+02
EMIXI_c028_3_00 (mix_i_src_c028_3_00 0 bpf_c028_3 0) vcvs gain=9.807852804032e-01
SMIXI_c028_3_00 (mix_i_src_c028_3_00 mix_i_c028_3 win_3_00 0) relay vt1=-1m vt2=1m ropen=ropen_mix rclosed=rclosed_mix
EMIXQ_c028_3_00 (mix_q_src_c028_3_00 0 bpf_c028_3 0) vcvs gain=1.950903220161e-01
SMIXQ_c028_3_00 (mix_q_src_c028_3_00 mix_q_c028_3 win_3_00 0) relay vt1=-1m vt2=1m ropen=ropen_mix rclosed=rclosed_mix
EMIXI_c028_3_01 (mix_i_src_c028_3_01 0 bpf_c028_3 0) vcvs gain=8.314696123025e-01
SMIXI_c028_3_01 (mix_i_src_c028_3_01 mix_i_c028_3 win_3_01 0) relay vt1=-1m vt2=1m ropen=ropen_mix rclosed=rclosed_mix
EMIXQ_c028_3_01 (mix_q_src_c028_3_01 0 bpf_c028_3 0) vcvs gain=5.555702330196e-01
SMIXQ_c028_3_01 (mix_q_src_c028_3_01 mix_q_c028_3 win_3_01 0) relay vt1=-1m vt2=1m ropen=ropen_mix rclosed=rclosed_mix
EMIXI_c028_3_02 (mix_i_src_c028_3_02 0 bpf_c028_3 0) vcvs gain=5.555702330196e-01
SMIXI_c028_3_02 (mix_i_src_c028_3_02 mix_i_c028_3 win_3_02 0) relay vt1=-1m vt2=1m ropen=ropen_mix rclosed=rclosed_mix
EMIXQ_c028_3_02 (mix_q_src_c028_3_02 0 bpf_c028_3 0) vcvs gain=8.314696123025e-01
SMIXQ_c028_3_02 (mix_q_src_c028_3_02 mix_q_c028_3 win_3_02 0) relay vt1=-1m vt2=1m ropen=ropen_mix rclosed=rclosed_mix
EMIXI_c028_3_03 (mix_i_src_c028_3_03 0 bpf_c028_3 0) vcvs gain=1.950903220161e-01
SMIXI_c028_3_03 (mix_i_src_c028_3_03 mix_i_c028_3 win_3_03 0) relay vt1=-1m vt2=1m ropen=ropen_mix rclosed=rclosed_mix
EMIXQ_c028_3_03 (mix_q_src_c028_3_03 0 bpf_c028_3 0) vcvs gain=9.807852804032e-01
SMIXQ_c028_3_03 (mix_q_src_c028_3_03 mix_q_c028_3 win_3_03 0) relay vt1=-1m vt2=1m ropen=ropen_mix rclosed=rclosed_mix
EMIXI_c028_3_04 (mix_i_src_c028_3_04 0 bpf_c028_3 0) vcvs gain=-1.950903220161e-01
SMIXI_c028_3_04 (mix_i_src_c028_3_04 mix_i_c028_3 win_3_04 0) relay vt1=-1m vt2=1m ropen=ropen_mix rclosed=rclosed_mix
EMIXQ_c028_3_04 (mix_q_src_c028_3_04 0 bpf_c028_3 0) vcvs gain=9.807852804032e-01
SMIXQ_c028_3_04 (mix_q_src_c028_3_04 mix_q_c028_3 win_3_04 0) relay vt1=-1m vt2=1m ropen=ropen_mix rclosed=rclosed_mix
EMIXI_c028_3_05 (mix_i_src_c028_3_05 0 bpf_c028_3 0) vcvs gain=-5.555702330196e-01
SMIXI_c028_3_05 (mix_i_src_c028_3_05 mix_i_c028_3 win_3_05 0) relay vt1=-1m vt2=1m ropen=ropen_mix rclosed=rclosed_mix
EMIXQ_c028_3_05 (mix_q_src_c028_3_05 0 bpf_c028_3 0) vcvs gain=8.314696123025e-01
SMIXQ_c028_3_05 (mix_q_src_c028_3_05 mix_q_c028_3 win_3_05 0) relay vt1=-1m vt2=1m ropen=ropen_mix rclosed=rclosed_mix
EMIXI_c028_3_06 (mix_i_src_c028_3_06 0 bpf_c028_3 0) vcvs gain=-8.314696123025e-01
SMIXI_c028_3_06 (mix_i_src_c028_3_06 mix_i_c028_3 win_3_06 0) relay vt1=-1m vt2=1m ropen=ropen_mix rclosed=rclosed_mix
EMIXQ_c028_3_06 (mix_q_src_c028_3_06 0 bpf_c028_3 0) vcvs gain=5.555702330196e-01
SMIXQ_c028_3_06 (mix_q_src_c028_3_06 mix_q_c028_3 win_3_06 0) relay vt1=-1m vt2=1m ropen=ropen_mix rclosed=rclosed_mix
EMIXI_c028_3_07 (mix_i_src_c028_3_07 0 bpf_c028_3 0) vcvs gain=-9.807852804032e-01
SMIXI_c028_3_07 (mix_i_src_c028_3_07 mix_i_c028_3 win_3_07 0) relay vt1=-1m vt2=1m ropen=ropen_mix rclosed=rclosed_mix
EMIXQ_c028_3_07 (mix_q_src_c028_3_07 0 bpf_c028_3 0) vcvs gain=1.950903220161e-01
SMIXQ_c028_3_07 (mix_q_src_c028_3_07 mix_q_c028_3 win_3_07 0) relay vt1=-1m vt2=1m ropen=ropen_mix rclosed=rclosed_mix
EMIXI_c028_3_08 (mix_i_src_c028_3_08 0 bpf_c028_3 0) vcvs gain=-9.807852804032e-01
SMIXI_c028_3_08 (mix_i_src_c028_3_08 mix_i_c028_3 win_3_08 0) relay vt1=-1m vt2=1m ropen=ropen_mix rclosed=rclosed_mix
EMIXQ_c028_3_08 (mix_q_src_c028_3_08 0 bpf_c028_3 0) vcvs gain=-1.950903220161e-01
SMIXQ_c028_3_08 (mix_q_src_c028_3_08 mix_q_c028_3 win_3_08 0) relay vt1=-1m vt2=1m ropen=ropen_mix rclosed=rclosed_mix
EMIXI_c028_3_09 (mix_i_src_c028_3_09 0 bpf_c028_3 0) vcvs gain=-8.314696123025e-01
SMIXI_c028_3_09 (mix_i_src_c028_3_09 mix_i_c028_3 win_3_09 0) relay vt1=-1m vt2=1m ropen=ropen_mix rclosed=rclosed_mix
EMIXQ_c028_3_09 (mix_q_src_c028_3_09 0 bpf_c028_3 0) vcvs gain=-5.555702330196e-01
SMIXQ_c028_3_09 (mix_q_src_c028_3_09 mix_q_c028_3 win_3_09 0) relay vt1=-1m vt2=1m ropen=ropen_mix rclosed=rclosed_mix
EMIXI_c028_3_10 (mix_i_src_c028_3_10 0 bpf_c028_3 0) vcvs gain=-5.555702330196e-01
SMIXI_c028_3_10 (mix_i_src_c028_3_10 mix_i_c028_3 win_3_10 0) relay vt1=-1m vt2=1m ropen=ropen_mix rclosed=rclosed_mix
EMIXQ_c028_3_10 (mix_q_src_c028_3_10 0 bpf_c028_3 0) vcvs gain=-8.314696123025e-01
SMIXQ_c028_3_10 (mix_q_src_c028_3_10 mix_q_c028_3 win_3_10 0) relay vt1=-1m vt2=1m ropen=ropen_mix rclosed=rclosed_mix
EMIXI_c028_3_11 (mix_i_src_c028_3_11 0 bpf_c028_3 0) vcvs gain=-1.950903220161e-01
SMIXI_c028_3_11 (mix_i_src_c028_3_11 mix_i_c028_3 win_3_11 0) relay vt1=-1m vt2=1m ropen=ropen_mix rclosed=rclosed_mix
EMIXQ_c028_3_11 (mix_q_src_c028_3_11 0 bpf_c028_3 0) vcvs gain=-9.807852804032e-01
SMIXQ_c028_3_11 (mix_q_src_c028_3_11 mix_q_c028_3 win_3_11 0) relay vt1=-1m vt2=1m ropen=ropen_mix rclosed=rclosed_mix
EMIXI_c028_3_12 (mix_i_src_c028_3_12 0 bpf_c028_3 0) vcvs gain=1.950903220161e-01
SMIXI_c028_3_12 (mix_i_src_c028_3_12 mix_i_c028_3 win_3_12 0) relay vt1=-1m vt2=1m ropen=ropen_mix rclosed=rclosed_mix
EMIXQ_c028_3_12 (mix_q_src_c028_3_12 0 bpf_c028_3 0) vcvs gain=-9.807852804032e-01
SMIXQ_c028_3_12 (mix_q_src_c028_3_12 mix_q_c028_3 win_3_12 0) relay vt1=-1m vt2=1m ropen=ropen_mix rclosed=rclosed_mix
EMIXI_c028_3_13 (mix_i_src_c028_3_13 0 bpf_c028_3 0) vcvs gain=5.555702330196e-01
SMIXI_c028_3_13 (mix_i_src_c028_3_13 mix_i_c028_3 win_3_13 0) relay vt1=-1m vt2=1m ropen=ropen_mix rclosed=rclosed_mix
EMIXQ_c028_3_13 (mix_q_src_c028_3_13 0 bpf_c028_3 0) vcvs gain=-8.314696123025e-01
SMIXQ_c028_3_13 (mix_q_src_c028_3_13 mix_q_c028_3 win_3_13 0) relay vt1=-1m vt2=1m ropen=ropen_mix rclosed=rclosed_mix
EMIXI_c028_3_14 (mix_i_src_c028_3_14 0 bpf_c028_3 0) vcvs gain=8.314696123025e-01
SMIXI_c028_3_14 (mix_i_src_c028_3_14 mix_i_c028_3 win_3_14 0) relay vt1=-1m vt2=1m ropen=ropen_mix rclosed=rclosed_mix
EMIXQ_c028_3_14 (mix_q_src_c028_3_14 0 bpf_c028_3 0) vcvs gain=-5.555702330196e-01
SMIXQ_c028_3_14 (mix_q_src_c028_3_14 mix_q_c028_3 win_3_14 0) relay vt1=-1m vt2=1m ropen=ropen_mix rclosed=rclosed_mix
EMIXI_c028_3_15 (mix_i_src_c028_3_15 0 bpf_c028_3 0) vcvs gain=9.807852804032e-01
SMIXI_c028_3_15 (mix_i_src_c028_3_15 mix_i_c028_3 win_3_15 0) relay vt1=-1m vt2=1m ropen=ropen_mix rclosed=rclosed_mix
EMIXQ_c028_3_15 (mix_q_src_c028_3_15 0 bpf_c028_3 0) vcvs gain=-1.950903220161e-01
SMIXQ_c028_3_15 (mix_q_src_c028_3_15 mix_q_c028_3 win_3_15 0) relay vt1=-1m vt2=1m ropen=ropen_mix rclosed=rclosed_mix
RMIXI_c028_3 (mix_i_c028_3 0) resistor r=1G
RMIXQ_c028_3 (mix_q_c028_3 0) resistor r=1G
RINTI_c028_3 (mix_i_c028_3 Icar_c028_3) resistor r=1k
CINTI_c028_3 (Icar_c028_3 0) capacitor c=80p
RINTQ_c028_3 (mix_q_c028_3 Qcar_c028_3) resistor r=1k
CINTQ_c028_3 (Qcar_c028_3 0) capacitor c=80p
save bpf_c028_3 Icar_c028_3 Qcar_c028_3

// bl029, carrier_0: 250000000 Hz coherent I/Q phase-window verification-demod path
CBPF_c029_0 (bl029 n_cbpf_c029_0) capacitor c=4.052847345694e-13
LBPF_c029_0 (n_cbpf_c029_0 bpf_c029_0) inductor l=1.000000000000e-06
RBPF_c029_0 (bpf_c029_0 0) resistor r=7.853981633974e+01
EMIXI_c029_0_00 (mix_i_src_c029_0_00 0 bpf_c029_0 0) vcvs gain=9.807852804032e-01
SMIXI_c029_0_00 (mix_i_src_c029_0_00 mix_i_c029_0 win_0_00 0) relay vt1=-1m vt2=1m ropen=ropen_mix rclosed=rclosed_mix
EMIXQ_c029_0_00 (mix_q_src_c029_0_00 0 bpf_c029_0 0) vcvs gain=1.950903220161e-01
SMIXQ_c029_0_00 (mix_q_src_c029_0_00 mix_q_c029_0 win_0_00 0) relay vt1=-1m vt2=1m ropen=ropen_mix rclosed=rclosed_mix
EMIXI_c029_0_01 (mix_i_src_c029_0_01 0 bpf_c029_0 0) vcvs gain=8.314696123025e-01
SMIXI_c029_0_01 (mix_i_src_c029_0_01 mix_i_c029_0 win_0_01 0) relay vt1=-1m vt2=1m ropen=ropen_mix rclosed=rclosed_mix
EMIXQ_c029_0_01 (mix_q_src_c029_0_01 0 bpf_c029_0 0) vcvs gain=5.555702330196e-01
SMIXQ_c029_0_01 (mix_q_src_c029_0_01 mix_q_c029_0 win_0_01 0) relay vt1=-1m vt2=1m ropen=ropen_mix rclosed=rclosed_mix
EMIXI_c029_0_02 (mix_i_src_c029_0_02 0 bpf_c029_0 0) vcvs gain=5.555702330196e-01
SMIXI_c029_0_02 (mix_i_src_c029_0_02 mix_i_c029_0 win_0_02 0) relay vt1=-1m vt2=1m ropen=ropen_mix rclosed=rclosed_mix
EMIXQ_c029_0_02 (mix_q_src_c029_0_02 0 bpf_c029_0 0) vcvs gain=8.314696123025e-01
SMIXQ_c029_0_02 (mix_q_src_c029_0_02 mix_q_c029_0 win_0_02 0) relay vt1=-1m vt2=1m ropen=ropen_mix rclosed=rclosed_mix
EMIXI_c029_0_03 (mix_i_src_c029_0_03 0 bpf_c029_0 0) vcvs gain=1.950903220161e-01
SMIXI_c029_0_03 (mix_i_src_c029_0_03 mix_i_c029_0 win_0_03 0) relay vt1=-1m vt2=1m ropen=ropen_mix rclosed=rclosed_mix
EMIXQ_c029_0_03 (mix_q_src_c029_0_03 0 bpf_c029_0 0) vcvs gain=9.807852804032e-01
SMIXQ_c029_0_03 (mix_q_src_c029_0_03 mix_q_c029_0 win_0_03 0) relay vt1=-1m vt2=1m ropen=ropen_mix rclosed=rclosed_mix
EMIXI_c029_0_04 (mix_i_src_c029_0_04 0 bpf_c029_0 0) vcvs gain=-1.950903220161e-01
SMIXI_c029_0_04 (mix_i_src_c029_0_04 mix_i_c029_0 win_0_04 0) relay vt1=-1m vt2=1m ropen=ropen_mix rclosed=rclosed_mix
EMIXQ_c029_0_04 (mix_q_src_c029_0_04 0 bpf_c029_0 0) vcvs gain=9.807852804032e-01
SMIXQ_c029_0_04 (mix_q_src_c029_0_04 mix_q_c029_0 win_0_04 0) relay vt1=-1m vt2=1m ropen=ropen_mix rclosed=rclosed_mix
EMIXI_c029_0_05 (mix_i_src_c029_0_05 0 bpf_c029_0 0) vcvs gain=-5.555702330196e-01
SMIXI_c029_0_05 (mix_i_src_c029_0_05 mix_i_c029_0 win_0_05 0) relay vt1=-1m vt2=1m ropen=ropen_mix rclosed=rclosed_mix
EMIXQ_c029_0_05 (mix_q_src_c029_0_05 0 bpf_c029_0 0) vcvs gain=8.314696123025e-01
SMIXQ_c029_0_05 (mix_q_src_c029_0_05 mix_q_c029_0 win_0_05 0) relay vt1=-1m vt2=1m ropen=ropen_mix rclosed=rclosed_mix
EMIXI_c029_0_06 (mix_i_src_c029_0_06 0 bpf_c029_0 0) vcvs gain=-8.314696123025e-01
SMIXI_c029_0_06 (mix_i_src_c029_0_06 mix_i_c029_0 win_0_06 0) relay vt1=-1m vt2=1m ropen=ropen_mix rclosed=rclosed_mix
EMIXQ_c029_0_06 (mix_q_src_c029_0_06 0 bpf_c029_0 0) vcvs gain=5.555702330196e-01
SMIXQ_c029_0_06 (mix_q_src_c029_0_06 mix_q_c029_0 win_0_06 0) relay vt1=-1m vt2=1m ropen=ropen_mix rclosed=rclosed_mix
EMIXI_c029_0_07 (mix_i_src_c029_0_07 0 bpf_c029_0 0) vcvs gain=-9.807852804032e-01
SMIXI_c029_0_07 (mix_i_src_c029_0_07 mix_i_c029_0 win_0_07 0) relay vt1=-1m vt2=1m ropen=ropen_mix rclosed=rclosed_mix
EMIXQ_c029_0_07 (mix_q_src_c029_0_07 0 bpf_c029_0 0) vcvs gain=1.950903220161e-01
SMIXQ_c029_0_07 (mix_q_src_c029_0_07 mix_q_c029_0 win_0_07 0) relay vt1=-1m vt2=1m ropen=ropen_mix rclosed=rclosed_mix
EMIXI_c029_0_08 (mix_i_src_c029_0_08 0 bpf_c029_0 0) vcvs gain=-9.807852804032e-01
SMIXI_c029_0_08 (mix_i_src_c029_0_08 mix_i_c029_0 win_0_08 0) relay vt1=-1m vt2=1m ropen=ropen_mix rclosed=rclosed_mix
EMIXQ_c029_0_08 (mix_q_src_c029_0_08 0 bpf_c029_0 0) vcvs gain=-1.950903220161e-01
SMIXQ_c029_0_08 (mix_q_src_c029_0_08 mix_q_c029_0 win_0_08 0) relay vt1=-1m vt2=1m ropen=ropen_mix rclosed=rclosed_mix
EMIXI_c029_0_09 (mix_i_src_c029_0_09 0 bpf_c029_0 0) vcvs gain=-8.314696123025e-01
SMIXI_c029_0_09 (mix_i_src_c029_0_09 mix_i_c029_0 win_0_09 0) relay vt1=-1m vt2=1m ropen=ropen_mix rclosed=rclosed_mix
EMIXQ_c029_0_09 (mix_q_src_c029_0_09 0 bpf_c029_0 0) vcvs gain=-5.555702330196e-01
SMIXQ_c029_0_09 (mix_q_src_c029_0_09 mix_q_c029_0 win_0_09 0) relay vt1=-1m vt2=1m ropen=ropen_mix rclosed=rclosed_mix
EMIXI_c029_0_10 (mix_i_src_c029_0_10 0 bpf_c029_0 0) vcvs gain=-5.555702330196e-01
SMIXI_c029_0_10 (mix_i_src_c029_0_10 mix_i_c029_0 win_0_10 0) relay vt1=-1m vt2=1m ropen=ropen_mix rclosed=rclosed_mix
EMIXQ_c029_0_10 (mix_q_src_c029_0_10 0 bpf_c029_0 0) vcvs gain=-8.314696123025e-01
SMIXQ_c029_0_10 (mix_q_src_c029_0_10 mix_q_c029_0 win_0_10 0) relay vt1=-1m vt2=1m ropen=ropen_mix rclosed=rclosed_mix
EMIXI_c029_0_11 (mix_i_src_c029_0_11 0 bpf_c029_0 0) vcvs gain=-1.950903220161e-01
SMIXI_c029_0_11 (mix_i_src_c029_0_11 mix_i_c029_0 win_0_11 0) relay vt1=-1m vt2=1m ropen=ropen_mix rclosed=rclosed_mix
EMIXQ_c029_0_11 (mix_q_src_c029_0_11 0 bpf_c029_0 0) vcvs gain=-9.807852804032e-01
SMIXQ_c029_0_11 (mix_q_src_c029_0_11 mix_q_c029_0 win_0_11 0) relay vt1=-1m vt2=1m ropen=ropen_mix rclosed=rclosed_mix
EMIXI_c029_0_12 (mix_i_src_c029_0_12 0 bpf_c029_0 0) vcvs gain=1.950903220161e-01
SMIXI_c029_0_12 (mix_i_src_c029_0_12 mix_i_c029_0 win_0_12 0) relay vt1=-1m vt2=1m ropen=ropen_mix rclosed=rclosed_mix
EMIXQ_c029_0_12 (mix_q_src_c029_0_12 0 bpf_c029_0 0) vcvs gain=-9.807852804032e-01
SMIXQ_c029_0_12 (mix_q_src_c029_0_12 mix_q_c029_0 win_0_12 0) relay vt1=-1m vt2=1m ropen=ropen_mix rclosed=rclosed_mix
EMIXI_c029_0_13 (mix_i_src_c029_0_13 0 bpf_c029_0 0) vcvs gain=5.555702330196e-01
SMIXI_c029_0_13 (mix_i_src_c029_0_13 mix_i_c029_0 win_0_13 0) relay vt1=-1m vt2=1m ropen=ropen_mix rclosed=rclosed_mix
EMIXQ_c029_0_13 (mix_q_src_c029_0_13 0 bpf_c029_0 0) vcvs gain=-8.314696123025e-01
SMIXQ_c029_0_13 (mix_q_src_c029_0_13 mix_q_c029_0 win_0_13 0) relay vt1=-1m vt2=1m ropen=ropen_mix rclosed=rclosed_mix
EMIXI_c029_0_14 (mix_i_src_c029_0_14 0 bpf_c029_0 0) vcvs gain=8.314696123025e-01
SMIXI_c029_0_14 (mix_i_src_c029_0_14 mix_i_c029_0 win_0_14 0) relay vt1=-1m vt2=1m ropen=ropen_mix rclosed=rclosed_mix
EMIXQ_c029_0_14 (mix_q_src_c029_0_14 0 bpf_c029_0 0) vcvs gain=-5.555702330196e-01
SMIXQ_c029_0_14 (mix_q_src_c029_0_14 mix_q_c029_0 win_0_14 0) relay vt1=-1m vt2=1m ropen=ropen_mix rclosed=rclosed_mix
EMIXI_c029_0_15 (mix_i_src_c029_0_15 0 bpf_c029_0 0) vcvs gain=9.807852804032e-01
SMIXI_c029_0_15 (mix_i_src_c029_0_15 mix_i_c029_0 win_0_15 0) relay vt1=-1m vt2=1m ropen=ropen_mix rclosed=rclosed_mix
EMIXQ_c029_0_15 (mix_q_src_c029_0_15 0 bpf_c029_0 0) vcvs gain=-1.950903220161e-01
SMIXQ_c029_0_15 (mix_q_src_c029_0_15 mix_q_c029_0 win_0_15 0) relay vt1=-1m vt2=1m ropen=ropen_mix rclosed=rclosed_mix
RMIXI_c029_0 (mix_i_c029_0 0) resistor r=1G
RMIXQ_c029_0 (mix_q_c029_0 0) resistor r=1G
RINTI_c029_0 (mix_i_c029_0 Icar_c029_0) resistor r=1k
CINTI_c029_0 (Icar_c029_0 0) capacitor c=80p
RINTQ_c029_0 (mix_q_c029_0 Qcar_c029_0) resistor r=1k
CINTQ_c029_0 (Qcar_c029_0 0) capacitor c=80p
save bpf_c029_0 Icar_c029_0 Qcar_c029_0

// bl029, carrier_1: 500000000 Hz coherent I/Q phase-window verification-demod path
CBPF_c029_1 (bl029 n_cbpf_c029_1) capacitor c=1.013211836423e-13
LBPF_c029_1 (n_cbpf_c029_1 bpf_c029_1) inductor l=1.000000000000e-06
RBPF_c029_1 (bpf_c029_1 0) resistor r=1.570796326795e+02
EMIXI_c029_1_00 (mix_i_src_c029_1_00 0 bpf_c029_1 0) vcvs gain=9.807852804032e-01
SMIXI_c029_1_00 (mix_i_src_c029_1_00 mix_i_c029_1 win_1_00 0) relay vt1=-1m vt2=1m ropen=ropen_mix rclosed=rclosed_mix
EMIXQ_c029_1_00 (mix_q_src_c029_1_00 0 bpf_c029_1 0) vcvs gain=1.950903220161e-01
SMIXQ_c029_1_00 (mix_q_src_c029_1_00 mix_q_c029_1 win_1_00 0) relay vt1=-1m vt2=1m ropen=ropen_mix rclosed=rclosed_mix
EMIXI_c029_1_01 (mix_i_src_c029_1_01 0 bpf_c029_1 0) vcvs gain=8.314696123025e-01
SMIXI_c029_1_01 (mix_i_src_c029_1_01 mix_i_c029_1 win_1_01 0) relay vt1=-1m vt2=1m ropen=ropen_mix rclosed=rclosed_mix
EMIXQ_c029_1_01 (mix_q_src_c029_1_01 0 bpf_c029_1 0) vcvs gain=5.555702330196e-01
SMIXQ_c029_1_01 (mix_q_src_c029_1_01 mix_q_c029_1 win_1_01 0) relay vt1=-1m vt2=1m ropen=ropen_mix rclosed=rclosed_mix
EMIXI_c029_1_02 (mix_i_src_c029_1_02 0 bpf_c029_1 0) vcvs gain=5.555702330196e-01
SMIXI_c029_1_02 (mix_i_src_c029_1_02 mix_i_c029_1 win_1_02 0) relay vt1=-1m vt2=1m ropen=ropen_mix rclosed=rclosed_mix
EMIXQ_c029_1_02 (mix_q_src_c029_1_02 0 bpf_c029_1 0) vcvs gain=8.314696123025e-01
SMIXQ_c029_1_02 (mix_q_src_c029_1_02 mix_q_c029_1 win_1_02 0) relay vt1=-1m vt2=1m ropen=ropen_mix rclosed=rclosed_mix
EMIXI_c029_1_03 (mix_i_src_c029_1_03 0 bpf_c029_1 0) vcvs gain=1.950903220161e-01
SMIXI_c029_1_03 (mix_i_src_c029_1_03 mix_i_c029_1 win_1_03 0) relay vt1=-1m vt2=1m ropen=ropen_mix rclosed=rclosed_mix
EMIXQ_c029_1_03 (mix_q_src_c029_1_03 0 bpf_c029_1 0) vcvs gain=9.807852804032e-01
SMIXQ_c029_1_03 (mix_q_src_c029_1_03 mix_q_c029_1 win_1_03 0) relay vt1=-1m vt2=1m ropen=ropen_mix rclosed=rclosed_mix
EMIXI_c029_1_04 (mix_i_src_c029_1_04 0 bpf_c029_1 0) vcvs gain=-1.950903220161e-01
SMIXI_c029_1_04 (mix_i_src_c029_1_04 mix_i_c029_1 win_1_04 0) relay vt1=-1m vt2=1m ropen=ropen_mix rclosed=rclosed_mix
EMIXQ_c029_1_04 (mix_q_src_c029_1_04 0 bpf_c029_1 0) vcvs gain=9.807852804032e-01
SMIXQ_c029_1_04 (mix_q_src_c029_1_04 mix_q_c029_1 win_1_04 0) relay vt1=-1m vt2=1m ropen=ropen_mix rclosed=rclosed_mix
EMIXI_c029_1_05 (mix_i_src_c029_1_05 0 bpf_c029_1 0) vcvs gain=-5.555702330196e-01
SMIXI_c029_1_05 (mix_i_src_c029_1_05 mix_i_c029_1 win_1_05 0) relay vt1=-1m vt2=1m ropen=ropen_mix rclosed=rclosed_mix
EMIXQ_c029_1_05 (mix_q_src_c029_1_05 0 bpf_c029_1 0) vcvs gain=8.314696123025e-01
SMIXQ_c029_1_05 (mix_q_src_c029_1_05 mix_q_c029_1 win_1_05 0) relay vt1=-1m vt2=1m ropen=ropen_mix rclosed=rclosed_mix
EMIXI_c029_1_06 (mix_i_src_c029_1_06 0 bpf_c029_1 0) vcvs gain=-8.314696123025e-01
SMIXI_c029_1_06 (mix_i_src_c029_1_06 mix_i_c029_1 win_1_06 0) relay vt1=-1m vt2=1m ropen=ropen_mix rclosed=rclosed_mix
EMIXQ_c029_1_06 (mix_q_src_c029_1_06 0 bpf_c029_1 0) vcvs gain=5.555702330196e-01
SMIXQ_c029_1_06 (mix_q_src_c029_1_06 mix_q_c029_1 win_1_06 0) relay vt1=-1m vt2=1m ropen=ropen_mix rclosed=rclosed_mix
EMIXI_c029_1_07 (mix_i_src_c029_1_07 0 bpf_c029_1 0) vcvs gain=-9.807852804032e-01
SMIXI_c029_1_07 (mix_i_src_c029_1_07 mix_i_c029_1 win_1_07 0) relay vt1=-1m vt2=1m ropen=ropen_mix rclosed=rclosed_mix
EMIXQ_c029_1_07 (mix_q_src_c029_1_07 0 bpf_c029_1 0) vcvs gain=1.950903220161e-01
SMIXQ_c029_1_07 (mix_q_src_c029_1_07 mix_q_c029_1 win_1_07 0) relay vt1=-1m vt2=1m ropen=ropen_mix rclosed=rclosed_mix
EMIXI_c029_1_08 (mix_i_src_c029_1_08 0 bpf_c029_1 0) vcvs gain=-9.807852804032e-01
SMIXI_c029_1_08 (mix_i_src_c029_1_08 mix_i_c029_1 win_1_08 0) relay vt1=-1m vt2=1m ropen=ropen_mix rclosed=rclosed_mix
EMIXQ_c029_1_08 (mix_q_src_c029_1_08 0 bpf_c029_1 0) vcvs gain=-1.950903220161e-01
SMIXQ_c029_1_08 (mix_q_src_c029_1_08 mix_q_c029_1 win_1_08 0) relay vt1=-1m vt2=1m ropen=ropen_mix rclosed=rclosed_mix
EMIXI_c029_1_09 (mix_i_src_c029_1_09 0 bpf_c029_1 0) vcvs gain=-8.314696123025e-01
SMIXI_c029_1_09 (mix_i_src_c029_1_09 mix_i_c029_1 win_1_09 0) relay vt1=-1m vt2=1m ropen=ropen_mix rclosed=rclosed_mix
EMIXQ_c029_1_09 (mix_q_src_c029_1_09 0 bpf_c029_1 0) vcvs gain=-5.555702330196e-01
SMIXQ_c029_1_09 (mix_q_src_c029_1_09 mix_q_c029_1 win_1_09 0) relay vt1=-1m vt2=1m ropen=ropen_mix rclosed=rclosed_mix
EMIXI_c029_1_10 (mix_i_src_c029_1_10 0 bpf_c029_1 0) vcvs gain=-5.555702330196e-01
SMIXI_c029_1_10 (mix_i_src_c029_1_10 mix_i_c029_1 win_1_10 0) relay vt1=-1m vt2=1m ropen=ropen_mix rclosed=rclosed_mix
EMIXQ_c029_1_10 (mix_q_src_c029_1_10 0 bpf_c029_1 0) vcvs gain=-8.314696123025e-01
SMIXQ_c029_1_10 (mix_q_src_c029_1_10 mix_q_c029_1 win_1_10 0) relay vt1=-1m vt2=1m ropen=ropen_mix rclosed=rclosed_mix
EMIXI_c029_1_11 (mix_i_src_c029_1_11 0 bpf_c029_1 0) vcvs gain=-1.950903220161e-01
SMIXI_c029_1_11 (mix_i_src_c029_1_11 mix_i_c029_1 win_1_11 0) relay vt1=-1m vt2=1m ropen=ropen_mix rclosed=rclosed_mix
EMIXQ_c029_1_11 (mix_q_src_c029_1_11 0 bpf_c029_1 0) vcvs gain=-9.807852804032e-01
SMIXQ_c029_1_11 (mix_q_src_c029_1_11 mix_q_c029_1 win_1_11 0) relay vt1=-1m vt2=1m ropen=ropen_mix rclosed=rclosed_mix
EMIXI_c029_1_12 (mix_i_src_c029_1_12 0 bpf_c029_1 0) vcvs gain=1.950903220161e-01
SMIXI_c029_1_12 (mix_i_src_c029_1_12 mix_i_c029_1 win_1_12 0) relay vt1=-1m vt2=1m ropen=ropen_mix rclosed=rclosed_mix
EMIXQ_c029_1_12 (mix_q_src_c029_1_12 0 bpf_c029_1 0) vcvs gain=-9.807852804032e-01
SMIXQ_c029_1_12 (mix_q_src_c029_1_12 mix_q_c029_1 win_1_12 0) relay vt1=-1m vt2=1m ropen=ropen_mix rclosed=rclosed_mix
EMIXI_c029_1_13 (mix_i_src_c029_1_13 0 bpf_c029_1 0) vcvs gain=5.555702330196e-01
SMIXI_c029_1_13 (mix_i_src_c029_1_13 mix_i_c029_1 win_1_13 0) relay vt1=-1m vt2=1m ropen=ropen_mix rclosed=rclosed_mix
EMIXQ_c029_1_13 (mix_q_src_c029_1_13 0 bpf_c029_1 0) vcvs gain=-8.314696123025e-01
SMIXQ_c029_1_13 (mix_q_src_c029_1_13 mix_q_c029_1 win_1_13 0) relay vt1=-1m vt2=1m ropen=ropen_mix rclosed=rclosed_mix
EMIXI_c029_1_14 (mix_i_src_c029_1_14 0 bpf_c029_1 0) vcvs gain=8.314696123025e-01
SMIXI_c029_1_14 (mix_i_src_c029_1_14 mix_i_c029_1 win_1_14 0) relay vt1=-1m vt2=1m ropen=ropen_mix rclosed=rclosed_mix
EMIXQ_c029_1_14 (mix_q_src_c029_1_14 0 bpf_c029_1 0) vcvs gain=-5.555702330196e-01
SMIXQ_c029_1_14 (mix_q_src_c029_1_14 mix_q_c029_1 win_1_14 0) relay vt1=-1m vt2=1m ropen=ropen_mix rclosed=rclosed_mix
EMIXI_c029_1_15 (mix_i_src_c029_1_15 0 bpf_c029_1 0) vcvs gain=9.807852804032e-01
SMIXI_c029_1_15 (mix_i_src_c029_1_15 mix_i_c029_1 win_1_15 0) relay vt1=-1m vt2=1m ropen=ropen_mix rclosed=rclosed_mix
EMIXQ_c029_1_15 (mix_q_src_c029_1_15 0 bpf_c029_1 0) vcvs gain=-1.950903220161e-01
SMIXQ_c029_1_15 (mix_q_src_c029_1_15 mix_q_c029_1 win_1_15 0) relay vt1=-1m vt2=1m ropen=ropen_mix rclosed=rclosed_mix
RMIXI_c029_1 (mix_i_c029_1 0) resistor r=1G
RMIXQ_c029_1 (mix_q_c029_1 0) resistor r=1G
RINTI_c029_1 (mix_i_c029_1 Icar_c029_1) resistor r=1k
CINTI_c029_1 (Icar_c029_1 0) capacitor c=80p
RINTQ_c029_1 (mix_q_c029_1 Qcar_c029_1) resistor r=1k
CINTQ_c029_1 (Qcar_c029_1 0) capacitor c=80p
save bpf_c029_1 Icar_c029_1 Qcar_c029_1

// bl029, carrier_2: 750000000 Hz coherent I/Q phase-window verification-demod path
CBPF_c029_2 (bl029 n_cbpf_c029_2) capacitor c=4.503163717437e-14
LBPF_c029_2 (n_cbpf_c029_2 bpf_c029_2) inductor l=1.000000000000e-06
RBPF_c029_2 (bpf_c029_2 0) resistor r=2.356194490192e+02
EMIXI_c029_2_00 (mix_i_src_c029_2_00 0 bpf_c029_2 0) vcvs gain=9.807852804032e-01
SMIXI_c029_2_00 (mix_i_src_c029_2_00 mix_i_c029_2 win_2_00 0) relay vt1=-1m vt2=1m ropen=ropen_mix rclosed=rclosed_mix
EMIXQ_c029_2_00 (mix_q_src_c029_2_00 0 bpf_c029_2 0) vcvs gain=1.950903220161e-01
SMIXQ_c029_2_00 (mix_q_src_c029_2_00 mix_q_c029_2 win_2_00 0) relay vt1=-1m vt2=1m ropen=ropen_mix rclosed=rclosed_mix
EMIXI_c029_2_01 (mix_i_src_c029_2_01 0 bpf_c029_2 0) vcvs gain=8.314696123025e-01
SMIXI_c029_2_01 (mix_i_src_c029_2_01 mix_i_c029_2 win_2_01 0) relay vt1=-1m vt2=1m ropen=ropen_mix rclosed=rclosed_mix
EMIXQ_c029_2_01 (mix_q_src_c029_2_01 0 bpf_c029_2 0) vcvs gain=5.555702330196e-01
SMIXQ_c029_2_01 (mix_q_src_c029_2_01 mix_q_c029_2 win_2_01 0) relay vt1=-1m vt2=1m ropen=ropen_mix rclosed=rclosed_mix
EMIXI_c029_2_02 (mix_i_src_c029_2_02 0 bpf_c029_2 0) vcvs gain=5.555702330196e-01
SMIXI_c029_2_02 (mix_i_src_c029_2_02 mix_i_c029_2 win_2_02 0) relay vt1=-1m vt2=1m ropen=ropen_mix rclosed=rclosed_mix
EMIXQ_c029_2_02 (mix_q_src_c029_2_02 0 bpf_c029_2 0) vcvs gain=8.314696123025e-01
SMIXQ_c029_2_02 (mix_q_src_c029_2_02 mix_q_c029_2 win_2_02 0) relay vt1=-1m vt2=1m ropen=ropen_mix rclosed=rclosed_mix
EMIXI_c029_2_03 (mix_i_src_c029_2_03 0 bpf_c029_2 0) vcvs gain=1.950903220161e-01
SMIXI_c029_2_03 (mix_i_src_c029_2_03 mix_i_c029_2 win_2_03 0) relay vt1=-1m vt2=1m ropen=ropen_mix rclosed=rclosed_mix
EMIXQ_c029_2_03 (mix_q_src_c029_2_03 0 bpf_c029_2 0) vcvs gain=9.807852804032e-01
SMIXQ_c029_2_03 (mix_q_src_c029_2_03 mix_q_c029_2 win_2_03 0) relay vt1=-1m vt2=1m ropen=ropen_mix rclosed=rclosed_mix
EMIXI_c029_2_04 (mix_i_src_c029_2_04 0 bpf_c029_2 0) vcvs gain=-1.950903220161e-01
SMIXI_c029_2_04 (mix_i_src_c029_2_04 mix_i_c029_2 win_2_04 0) relay vt1=-1m vt2=1m ropen=ropen_mix rclosed=rclosed_mix
EMIXQ_c029_2_04 (mix_q_src_c029_2_04 0 bpf_c029_2 0) vcvs gain=9.807852804032e-01
SMIXQ_c029_2_04 (mix_q_src_c029_2_04 mix_q_c029_2 win_2_04 0) relay vt1=-1m vt2=1m ropen=ropen_mix rclosed=rclosed_mix
EMIXI_c029_2_05 (mix_i_src_c029_2_05 0 bpf_c029_2 0) vcvs gain=-5.555702330196e-01
SMIXI_c029_2_05 (mix_i_src_c029_2_05 mix_i_c029_2 win_2_05 0) relay vt1=-1m vt2=1m ropen=ropen_mix rclosed=rclosed_mix
EMIXQ_c029_2_05 (mix_q_src_c029_2_05 0 bpf_c029_2 0) vcvs gain=8.314696123025e-01
SMIXQ_c029_2_05 (mix_q_src_c029_2_05 mix_q_c029_2 win_2_05 0) relay vt1=-1m vt2=1m ropen=ropen_mix rclosed=rclosed_mix
EMIXI_c029_2_06 (mix_i_src_c029_2_06 0 bpf_c029_2 0) vcvs gain=-8.314696123025e-01
SMIXI_c029_2_06 (mix_i_src_c029_2_06 mix_i_c029_2 win_2_06 0) relay vt1=-1m vt2=1m ropen=ropen_mix rclosed=rclosed_mix
EMIXQ_c029_2_06 (mix_q_src_c029_2_06 0 bpf_c029_2 0) vcvs gain=5.555702330196e-01
SMIXQ_c029_2_06 (mix_q_src_c029_2_06 mix_q_c029_2 win_2_06 0) relay vt1=-1m vt2=1m ropen=ropen_mix rclosed=rclosed_mix
EMIXI_c029_2_07 (mix_i_src_c029_2_07 0 bpf_c029_2 0) vcvs gain=-9.807852804032e-01
SMIXI_c029_2_07 (mix_i_src_c029_2_07 mix_i_c029_2 win_2_07 0) relay vt1=-1m vt2=1m ropen=ropen_mix rclosed=rclosed_mix
EMIXQ_c029_2_07 (mix_q_src_c029_2_07 0 bpf_c029_2 0) vcvs gain=1.950903220161e-01
SMIXQ_c029_2_07 (mix_q_src_c029_2_07 mix_q_c029_2 win_2_07 0) relay vt1=-1m vt2=1m ropen=ropen_mix rclosed=rclosed_mix
EMIXI_c029_2_08 (mix_i_src_c029_2_08 0 bpf_c029_2 0) vcvs gain=-9.807852804032e-01
SMIXI_c029_2_08 (mix_i_src_c029_2_08 mix_i_c029_2 win_2_08 0) relay vt1=-1m vt2=1m ropen=ropen_mix rclosed=rclosed_mix
EMIXQ_c029_2_08 (mix_q_src_c029_2_08 0 bpf_c029_2 0) vcvs gain=-1.950903220161e-01
SMIXQ_c029_2_08 (mix_q_src_c029_2_08 mix_q_c029_2 win_2_08 0) relay vt1=-1m vt2=1m ropen=ropen_mix rclosed=rclosed_mix
EMIXI_c029_2_09 (mix_i_src_c029_2_09 0 bpf_c029_2 0) vcvs gain=-8.314696123025e-01
SMIXI_c029_2_09 (mix_i_src_c029_2_09 mix_i_c029_2 win_2_09 0) relay vt1=-1m vt2=1m ropen=ropen_mix rclosed=rclosed_mix
EMIXQ_c029_2_09 (mix_q_src_c029_2_09 0 bpf_c029_2 0) vcvs gain=-5.555702330196e-01
SMIXQ_c029_2_09 (mix_q_src_c029_2_09 mix_q_c029_2 win_2_09 0) relay vt1=-1m vt2=1m ropen=ropen_mix rclosed=rclosed_mix
EMIXI_c029_2_10 (mix_i_src_c029_2_10 0 bpf_c029_2 0) vcvs gain=-5.555702330196e-01
SMIXI_c029_2_10 (mix_i_src_c029_2_10 mix_i_c029_2 win_2_10 0) relay vt1=-1m vt2=1m ropen=ropen_mix rclosed=rclosed_mix
EMIXQ_c029_2_10 (mix_q_src_c029_2_10 0 bpf_c029_2 0) vcvs gain=-8.314696123025e-01
SMIXQ_c029_2_10 (mix_q_src_c029_2_10 mix_q_c029_2 win_2_10 0) relay vt1=-1m vt2=1m ropen=ropen_mix rclosed=rclosed_mix
EMIXI_c029_2_11 (mix_i_src_c029_2_11 0 bpf_c029_2 0) vcvs gain=-1.950903220161e-01
SMIXI_c029_2_11 (mix_i_src_c029_2_11 mix_i_c029_2 win_2_11 0) relay vt1=-1m vt2=1m ropen=ropen_mix rclosed=rclosed_mix
EMIXQ_c029_2_11 (mix_q_src_c029_2_11 0 bpf_c029_2 0) vcvs gain=-9.807852804032e-01
SMIXQ_c029_2_11 (mix_q_src_c029_2_11 mix_q_c029_2 win_2_11 0) relay vt1=-1m vt2=1m ropen=ropen_mix rclosed=rclosed_mix
EMIXI_c029_2_12 (mix_i_src_c029_2_12 0 bpf_c029_2 0) vcvs gain=1.950903220161e-01
SMIXI_c029_2_12 (mix_i_src_c029_2_12 mix_i_c029_2 win_2_12 0) relay vt1=-1m vt2=1m ropen=ropen_mix rclosed=rclosed_mix
EMIXQ_c029_2_12 (mix_q_src_c029_2_12 0 bpf_c029_2 0) vcvs gain=-9.807852804032e-01
SMIXQ_c029_2_12 (mix_q_src_c029_2_12 mix_q_c029_2 win_2_12 0) relay vt1=-1m vt2=1m ropen=ropen_mix rclosed=rclosed_mix
EMIXI_c029_2_13 (mix_i_src_c029_2_13 0 bpf_c029_2 0) vcvs gain=5.555702330196e-01
SMIXI_c029_2_13 (mix_i_src_c029_2_13 mix_i_c029_2 win_2_13 0) relay vt1=-1m vt2=1m ropen=ropen_mix rclosed=rclosed_mix
EMIXQ_c029_2_13 (mix_q_src_c029_2_13 0 bpf_c029_2 0) vcvs gain=-8.314696123025e-01
SMIXQ_c029_2_13 (mix_q_src_c029_2_13 mix_q_c029_2 win_2_13 0) relay vt1=-1m vt2=1m ropen=ropen_mix rclosed=rclosed_mix
EMIXI_c029_2_14 (mix_i_src_c029_2_14 0 bpf_c029_2 0) vcvs gain=8.314696123025e-01
SMIXI_c029_2_14 (mix_i_src_c029_2_14 mix_i_c029_2 win_2_14 0) relay vt1=-1m vt2=1m ropen=ropen_mix rclosed=rclosed_mix
EMIXQ_c029_2_14 (mix_q_src_c029_2_14 0 bpf_c029_2 0) vcvs gain=-5.555702330196e-01
SMIXQ_c029_2_14 (mix_q_src_c029_2_14 mix_q_c029_2 win_2_14 0) relay vt1=-1m vt2=1m ropen=ropen_mix rclosed=rclosed_mix
EMIXI_c029_2_15 (mix_i_src_c029_2_15 0 bpf_c029_2 0) vcvs gain=9.807852804032e-01
SMIXI_c029_2_15 (mix_i_src_c029_2_15 mix_i_c029_2 win_2_15 0) relay vt1=-1m vt2=1m ropen=ropen_mix rclosed=rclosed_mix
EMIXQ_c029_2_15 (mix_q_src_c029_2_15 0 bpf_c029_2 0) vcvs gain=-1.950903220161e-01
SMIXQ_c029_2_15 (mix_q_src_c029_2_15 mix_q_c029_2 win_2_15 0) relay vt1=-1m vt2=1m ropen=ropen_mix rclosed=rclosed_mix
RMIXI_c029_2 (mix_i_c029_2 0) resistor r=1G
RMIXQ_c029_2 (mix_q_c029_2 0) resistor r=1G
RINTI_c029_2 (mix_i_c029_2 Icar_c029_2) resistor r=1k
CINTI_c029_2 (Icar_c029_2 0) capacitor c=80p
RINTQ_c029_2 (mix_q_c029_2 Qcar_c029_2) resistor r=1k
CINTQ_c029_2 (Qcar_c029_2 0) capacitor c=80p
save bpf_c029_2 Icar_c029_2 Qcar_c029_2

// bl029, carrier_3: 1000000000 Hz coherent I/Q phase-window verification-demod path
CBPF_c029_3 (bl029 n_cbpf_c029_3) capacitor c=2.533029591058e-14
LBPF_c029_3 (n_cbpf_c029_3 bpf_c029_3) inductor l=1.000000000000e-06
RBPF_c029_3 (bpf_c029_3 0) resistor r=3.141592653590e+02
EMIXI_c029_3_00 (mix_i_src_c029_3_00 0 bpf_c029_3 0) vcvs gain=9.807852804032e-01
SMIXI_c029_3_00 (mix_i_src_c029_3_00 mix_i_c029_3 win_3_00 0) relay vt1=-1m vt2=1m ropen=ropen_mix rclosed=rclosed_mix
EMIXQ_c029_3_00 (mix_q_src_c029_3_00 0 bpf_c029_3 0) vcvs gain=1.950903220161e-01
SMIXQ_c029_3_00 (mix_q_src_c029_3_00 mix_q_c029_3 win_3_00 0) relay vt1=-1m vt2=1m ropen=ropen_mix rclosed=rclosed_mix
EMIXI_c029_3_01 (mix_i_src_c029_3_01 0 bpf_c029_3 0) vcvs gain=8.314696123025e-01
SMIXI_c029_3_01 (mix_i_src_c029_3_01 mix_i_c029_3 win_3_01 0) relay vt1=-1m vt2=1m ropen=ropen_mix rclosed=rclosed_mix
EMIXQ_c029_3_01 (mix_q_src_c029_3_01 0 bpf_c029_3 0) vcvs gain=5.555702330196e-01
SMIXQ_c029_3_01 (mix_q_src_c029_3_01 mix_q_c029_3 win_3_01 0) relay vt1=-1m vt2=1m ropen=ropen_mix rclosed=rclosed_mix
EMIXI_c029_3_02 (mix_i_src_c029_3_02 0 bpf_c029_3 0) vcvs gain=5.555702330196e-01
SMIXI_c029_3_02 (mix_i_src_c029_3_02 mix_i_c029_3 win_3_02 0) relay vt1=-1m vt2=1m ropen=ropen_mix rclosed=rclosed_mix
EMIXQ_c029_3_02 (mix_q_src_c029_3_02 0 bpf_c029_3 0) vcvs gain=8.314696123025e-01
SMIXQ_c029_3_02 (mix_q_src_c029_3_02 mix_q_c029_3 win_3_02 0) relay vt1=-1m vt2=1m ropen=ropen_mix rclosed=rclosed_mix
EMIXI_c029_3_03 (mix_i_src_c029_3_03 0 bpf_c029_3 0) vcvs gain=1.950903220161e-01
SMIXI_c029_3_03 (mix_i_src_c029_3_03 mix_i_c029_3 win_3_03 0) relay vt1=-1m vt2=1m ropen=ropen_mix rclosed=rclosed_mix
EMIXQ_c029_3_03 (mix_q_src_c029_3_03 0 bpf_c029_3 0) vcvs gain=9.807852804032e-01
SMIXQ_c029_3_03 (mix_q_src_c029_3_03 mix_q_c029_3 win_3_03 0) relay vt1=-1m vt2=1m ropen=ropen_mix rclosed=rclosed_mix
EMIXI_c029_3_04 (mix_i_src_c029_3_04 0 bpf_c029_3 0) vcvs gain=-1.950903220161e-01
SMIXI_c029_3_04 (mix_i_src_c029_3_04 mix_i_c029_3 win_3_04 0) relay vt1=-1m vt2=1m ropen=ropen_mix rclosed=rclosed_mix
EMIXQ_c029_3_04 (mix_q_src_c029_3_04 0 bpf_c029_3 0) vcvs gain=9.807852804032e-01
SMIXQ_c029_3_04 (mix_q_src_c029_3_04 mix_q_c029_3 win_3_04 0) relay vt1=-1m vt2=1m ropen=ropen_mix rclosed=rclosed_mix
EMIXI_c029_3_05 (mix_i_src_c029_3_05 0 bpf_c029_3 0) vcvs gain=-5.555702330196e-01
SMIXI_c029_3_05 (mix_i_src_c029_3_05 mix_i_c029_3 win_3_05 0) relay vt1=-1m vt2=1m ropen=ropen_mix rclosed=rclosed_mix
EMIXQ_c029_3_05 (mix_q_src_c029_3_05 0 bpf_c029_3 0) vcvs gain=8.314696123025e-01
SMIXQ_c029_3_05 (mix_q_src_c029_3_05 mix_q_c029_3 win_3_05 0) relay vt1=-1m vt2=1m ropen=ropen_mix rclosed=rclosed_mix
EMIXI_c029_3_06 (mix_i_src_c029_3_06 0 bpf_c029_3 0) vcvs gain=-8.314696123025e-01
SMIXI_c029_3_06 (mix_i_src_c029_3_06 mix_i_c029_3 win_3_06 0) relay vt1=-1m vt2=1m ropen=ropen_mix rclosed=rclosed_mix
EMIXQ_c029_3_06 (mix_q_src_c029_3_06 0 bpf_c029_3 0) vcvs gain=5.555702330196e-01
SMIXQ_c029_3_06 (mix_q_src_c029_3_06 mix_q_c029_3 win_3_06 0) relay vt1=-1m vt2=1m ropen=ropen_mix rclosed=rclosed_mix
EMIXI_c029_3_07 (mix_i_src_c029_3_07 0 bpf_c029_3 0) vcvs gain=-9.807852804032e-01
SMIXI_c029_3_07 (mix_i_src_c029_3_07 mix_i_c029_3 win_3_07 0) relay vt1=-1m vt2=1m ropen=ropen_mix rclosed=rclosed_mix
EMIXQ_c029_3_07 (mix_q_src_c029_3_07 0 bpf_c029_3 0) vcvs gain=1.950903220161e-01
SMIXQ_c029_3_07 (mix_q_src_c029_3_07 mix_q_c029_3 win_3_07 0) relay vt1=-1m vt2=1m ropen=ropen_mix rclosed=rclosed_mix
EMIXI_c029_3_08 (mix_i_src_c029_3_08 0 bpf_c029_3 0) vcvs gain=-9.807852804032e-01
SMIXI_c029_3_08 (mix_i_src_c029_3_08 mix_i_c029_3 win_3_08 0) relay vt1=-1m vt2=1m ropen=ropen_mix rclosed=rclosed_mix
EMIXQ_c029_3_08 (mix_q_src_c029_3_08 0 bpf_c029_3 0) vcvs gain=-1.950903220161e-01
SMIXQ_c029_3_08 (mix_q_src_c029_3_08 mix_q_c029_3 win_3_08 0) relay vt1=-1m vt2=1m ropen=ropen_mix rclosed=rclosed_mix
EMIXI_c029_3_09 (mix_i_src_c029_3_09 0 bpf_c029_3 0) vcvs gain=-8.314696123025e-01
SMIXI_c029_3_09 (mix_i_src_c029_3_09 mix_i_c029_3 win_3_09 0) relay vt1=-1m vt2=1m ropen=ropen_mix rclosed=rclosed_mix
EMIXQ_c029_3_09 (mix_q_src_c029_3_09 0 bpf_c029_3 0) vcvs gain=-5.555702330196e-01
SMIXQ_c029_3_09 (mix_q_src_c029_3_09 mix_q_c029_3 win_3_09 0) relay vt1=-1m vt2=1m ropen=ropen_mix rclosed=rclosed_mix
EMIXI_c029_3_10 (mix_i_src_c029_3_10 0 bpf_c029_3 0) vcvs gain=-5.555702330196e-01
SMIXI_c029_3_10 (mix_i_src_c029_3_10 mix_i_c029_3 win_3_10 0) relay vt1=-1m vt2=1m ropen=ropen_mix rclosed=rclosed_mix
EMIXQ_c029_3_10 (mix_q_src_c029_3_10 0 bpf_c029_3 0) vcvs gain=-8.314696123025e-01
SMIXQ_c029_3_10 (mix_q_src_c029_3_10 mix_q_c029_3 win_3_10 0) relay vt1=-1m vt2=1m ropen=ropen_mix rclosed=rclosed_mix
EMIXI_c029_3_11 (mix_i_src_c029_3_11 0 bpf_c029_3 0) vcvs gain=-1.950903220161e-01
SMIXI_c029_3_11 (mix_i_src_c029_3_11 mix_i_c029_3 win_3_11 0) relay vt1=-1m vt2=1m ropen=ropen_mix rclosed=rclosed_mix
EMIXQ_c029_3_11 (mix_q_src_c029_3_11 0 bpf_c029_3 0) vcvs gain=-9.807852804032e-01
SMIXQ_c029_3_11 (mix_q_src_c029_3_11 mix_q_c029_3 win_3_11 0) relay vt1=-1m vt2=1m ropen=ropen_mix rclosed=rclosed_mix
EMIXI_c029_3_12 (mix_i_src_c029_3_12 0 bpf_c029_3 0) vcvs gain=1.950903220161e-01
SMIXI_c029_3_12 (mix_i_src_c029_3_12 mix_i_c029_3 win_3_12 0) relay vt1=-1m vt2=1m ropen=ropen_mix rclosed=rclosed_mix
EMIXQ_c029_3_12 (mix_q_src_c029_3_12 0 bpf_c029_3 0) vcvs gain=-9.807852804032e-01
SMIXQ_c029_3_12 (mix_q_src_c029_3_12 mix_q_c029_3 win_3_12 0) relay vt1=-1m vt2=1m ropen=ropen_mix rclosed=rclosed_mix
EMIXI_c029_3_13 (mix_i_src_c029_3_13 0 bpf_c029_3 0) vcvs gain=5.555702330196e-01
SMIXI_c029_3_13 (mix_i_src_c029_3_13 mix_i_c029_3 win_3_13 0) relay vt1=-1m vt2=1m ropen=ropen_mix rclosed=rclosed_mix
EMIXQ_c029_3_13 (mix_q_src_c029_3_13 0 bpf_c029_3 0) vcvs gain=-8.314696123025e-01
SMIXQ_c029_3_13 (mix_q_src_c029_3_13 mix_q_c029_3 win_3_13 0) relay vt1=-1m vt2=1m ropen=ropen_mix rclosed=rclosed_mix
EMIXI_c029_3_14 (mix_i_src_c029_3_14 0 bpf_c029_3 0) vcvs gain=8.314696123025e-01
SMIXI_c029_3_14 (mix_i_src_c029_3_14 mix_i_c029_3 win_3_14 0) relay vt1=-1m vt2=1m ropen=ropen_mix rclosed=rclosed_mix
EMIXQ_c029_3_14 (mix_q_src_c029_3_14 0 bpf_c029_3 0) vcvs gain=-5.555702330196e-01
SMIXQ_c029_3_14 (mix_q_src_c029_3_14 mix_q_c029_3 win_3_14 0) relay vt1=-1m vt2=1m ropen=ropen_mix rclosed=rclosed_mix
EMIXI_c029_3_15 (mix_i_src_c029_3_15 0 bpf_c029_3 0) vcvs gain=9.807852804032e-01
SMIXI_c029_3_15 (mix_i_src_c029_3_15 mix_i_c029_3 win_3_15 0) relay vt1=-1m vt2=1m ropen=ropen_mix rclosed=rclosed_mix
EMIXQ_c029_3_15 (mix_q_src_c029_3_15 0 bpf_c029_3 0) vcvs gain=-1.950903220161e-01
SMIXQ_c029_3_15 (mix_q_src_c029_3_15 mix_q_c029_3 win_3_15 0) relay vt1=-1m vt2=1m ropen=ropen_mix rclosed=rclosed_mix
RMIXI_c029_3 (mix_i_c029_3 0) resistor r=1G
RMIXQ_c029_3 (mix_q_c029_3 0) resistor r=1G
RINTI_c029_3 (mix_i_c029_3 Icar_c029_3) resistor r=1k
CINTI_c029_3 (Icar_c029_3 0) capacitor c=80p
RINTQ_c029_3 (mix_q_c029_3 Qcar_c029_3) resistor r=1k
CINTQ_c029_3 (Qcar_c029_3 0) capacitor c=80p
save bpf_c029_3 Icar_c029_3 Qcar_c029_3

// bl030, carrier_0: 250000000 Hz coherent I/Q phase-window verification-demod path
CBPF_c030_0 (bl030 n_cbpf_c030_0) capacitor c=4.052847345694e-13
LBPF_c030_0 (n_cbpf_c030_0 bpf_c030_0) inductor l=1.000000000000e-06
RBPF_c030_0 (bpf_c030_0 0) resistor r=7.853981633974e+01
EMIXI_c030_0_00 (mix_i_src_c030_0_00 0 bpf_c030_0 0) vcvs gain=9.807852804032e-01
SMIXI_c030_0_00 (mix_i_src_c030_0_00 mix_i_c030_0 win_0_00 0) relay vt1=-1m vt2=1m ropen=ropen_mix rclosed=rclosed_mix
EMIXQ_c030_0_00 (mix_q_src_c030_0_00 0 bpf_c030_0 0) vcvs gain=1.950903220161e-01
SMIXQ_c030_0_00 (mix_q_src_c030_0_00 mix_q_c030_0 win_0_00 0) relay vt1=-1m vt2=1m ropen=ropen_mix rclosed=rclosed_mix
EMIXI_c030_0_01 (mix_i_src_c030_0_01 0 bpf_c030_0 0) vcvs gain=8.314696123025e-01
SMIXI_c030_0_01 (mix_i_src_c030_0_01 mix_i_c030_0 win_0_01 0) relay vt1=-1m vt2=1m ropen=ropen_mix rclosed=rclosed_mix
EMIXQ_c030_0_01 (mix_q_src_c030_0_01 0 bpf_c030_0 0) vcvs gain=5.555702330196e-01
SMIXQ_c030_0_01 (mix_q_src_c030_0_01 mix_q_c030_0 win_0_01 0) relay vt1=-1m vt2=1m ropen=ropen_mix rclosed=rclosed_mix
EMIXI_c030_0_02 (mix_i_src_c030_0_02 0 bpf_c030_0 0) vcvs gain=5.555702330196e-01
SMIXI_c030_0_02 (mix_i_src_c030_0_02 mix_i_c030_0 win_0_02 0) relay vt1=-1m vt2=1m ropen=ropen_mix rclosed=rclosed_mix
EMIXQ_c030_0_02 (mix_q_src_c030_0_02 0 bpf_c030_0 0) vcvs gain=8.314696123025e-01
SMIXQ_c030_0_02 (mix_q_src_c030_0_02 mix_q_c030_0 win_0_02 0) relay vt1=-1m vt2=1m ropen=ropen_mix rclosed=rclosed_mix
EMIXI_c030_0_03 (mix_i_src_c030_0_03 0 bpf_c030_0 0) vcvs gain=1.950903220161e-01
SMIXI_c030_0_03 (mix_i_src_c030_0_03 mix_i_c030_0 win_0_03 0) relay vt1=-1m vt2=1m ropen=ropen_mix rclosed=rclosed_mix
EMIXQ_c030_0_03 (mix_q_src_c030_0_03 0 bpf_c030_0 0) vcvs gain=9.807852804032e-01
SMIXQ_c030_0_03 (mix_q_src_c030_0_03 mix_q_c030_0 win_0_03 0) relay vt1=-1m vt2=1m ropen=ropen_mix rclosed=rclosed_mix
EMIXI_c030_0_04 (mix_i_src_c030_0_04 0 bpf_c030_0 0) vcvs gain=-1.950903220161e-01
SMIXI_c030_0_04 (mix_i_src_c030_0_04 mix_i_c030_0 win_0_04 0) relay vt1=-1m vt2=1m ropen=ropen_mix rclosed=rclosed_mix
EMIXQ_c030_0_04 (mix_q_src_c030_0_04 0 bpf_c030_0 0) vcvs gain=9.807852804032e-01
SMIXQ_c030_0_04 (mix_q_src_c030_0_04 mix_q_c030_0 win_0_04 0) relay vt1=-1m vt2=1m ropen=ropen_mix rclosed=rclosed_mix
EMIXI_c030_0_05 (mix_i_src_c030_0_05 0 bpf_c030_0 0) vcvs gain=-5.555702330196e-01
SMIXI_c030_0_05 (mix_i_src_c030_0_05 mix_i_c030_0 win_0_05 0) relay vt1=-1m vt2=1m ropen=ropen_mix rclosed=rclosed_mix
EMIXQ_c030_0_05 (mix_q_src_c030_0_05 0 bpf_c030_0 0) vcvs gain=8.314696123025e-01
SMIXQ_c030_0_05 (mix_q_src_c030_0_05 mix_q_c030_0 win_0_05 0) relay vt1=-1m vt2=1m ropen=ropen_mix rclosed=rclosed_mix
EMIXI_c030_0_06 (mix_i_src_c030_0_06 0 bpf_c030_0 0) vcvs gain=-8.314696123025e-01
SMIXI_c030_0_06 (mix_i_src_c030_0_06 mix_i_c030_0 win_0_06 0) relay vt1=-1m vt2=1m ropen=ropen_mix rclosed=rclosed_mix
EMIXQ_c030_0_06 (mix_q_src_c030_0_06 0 bpf_c030_0 0) vcvs gain=5.555702330196e-01
SMIXQ_c030_0_06 (mix_q_src_c030_0_06 mix_q_c030_0 win_0_06 0) relay vt1=-1m vt2=1m ropen=ropen_mix rclosed=rclosed_mix
EMIXI_c030_0_07 (mix_i_src_c030_0_07 0 bpf_c030_0 0) vcvs gain=-9.807852804032e-01
SMIXI_c030_0_07 (mix_i_src_c030_0_07 mix_i_c030_0 win_0_07 0) relay vt1=-1m vt2=1m ropen=ropen_mix rclosed=rclosed_mix
EMIXQ_c030_0_07 (mix_q_src_c030_0_07 0 bpf_c030_0 0) vcvs gain=1.950903220161e-01
SMIXQ_c030_0_07 (mix_q_src_c030_0_07 mix_q_c030_0 win_0_07 0) relay vt1=-1m vt2=1m ropen=ropen_mix rclosed=rclosed_mix
EMIXI_c030_0_08 (mix_i_src_c030_0_08 0 bpf_c030_0 0) vcvs gain=-9.807852804032e-01
SMIXI_c030_0_08 (mix_i_src_c030_0_08 mix_i_c030_0 win_0_08 0) relay vt1=-1m vt2=1m ropen=ropen_mix rclosed=rclosed_mix
EMIXQ_c030_0_08 (mix_q_src_c030_0_08 0 bpf_c030_0 0) vcvs gain=-1.950903220161e-01
SMIXQ_c030_0_08 (mix_q_src_c030_0_08 mix_q_c030_0 win_0_08 0) relay vt1=-1m vt2=1m ropen=ropen_mix rclosed=rclosed_mix
EMIXI_c030_0_09 (mix_i_src_c030_0_09 0 bpf_c030_0 0) vcvs gain=-8.314696123025e-01
SMIXI_c030_0_09 (mix_i_src_c030_0_09 mix_i_c030_0 win_0_09 0) relay vt1=-1m vt2=1m ropen=ropen_mix rclosed=rclosed_mix
EMIXQ_c030_0_09 (mix_q_src_c030_0_09 0 bpf_c030_0 0) vcvs gain=-5.555702330196e-01
SMIXQ_c030_0_09 (mix_q_src_c030_0_09 mix_q_c030_0 win_0_09 0) relay vt1=-1m vt2=1m ropen=ropen_mix rclosed=rclosed_mix
EMIXI_c030_0_10 (mix_i_src_c030_0_10 0 bpf_c030_0 0) vcvs gain=-5.555702330196e-01
SMIXI_c030_0_10 (mix_i_src_c030_0_10 mix_i_c030_0 win_0_10 0) relay vt1=-1m vt2=1m ropen=ropen_mix rclosed=rclosed_mix
EMIXQ_c030_0_10 (mix_q_src_c030_0_10 0 bpf_c030_0 0) vcvs gain=-8.314696123025e-01
SMIXQ_c030_0_10 (mix_q_src_c030_0_10 mix_q_c030_0 win_0_10 0) relay vt1=-1m vt2=1m ropen=ropen_mix rclosed=rclosed_mix
EMIXI_c030_0_11 (mix_i_src_c030_0_11 0 bpf_c030_0 0) vcvs gain=-1.950903220161e-01
SMIXI_c030_0_11 (mix_i_src_c030_0_11 mix_i_c030_0 win_0_11 0) relay vt1=-1m vt2=1m ropen=ropen_mix rclosed=rclosed_mix
EMIXQ_c030_0_11 (mix_q_src_c030_0_11 0 bpf_c030_0 0) vcvs gain=-9.807852804032e-01
SMIXQ_c030_0_11 (mix_q_src_c030_0_11 mix_q_c030_0 win_0_11 0) relay vt1=-1m vt2=1m ropen=ropen_mix rclosed=rclosed_mix
EMIXI_c030_0_12 (mix_i_src_c030_0_12 0 bpf_c030_0 0) vcvs gain=1.950903220161e-01
SMIXI_c030_0_12 (mix_i_src_c030_0_12 mix_i_c030_0 win_0_12 0) relay vt1=-1m vt2=1m ropen=ropen_mix rclosed=rclosed_mix
EMIXQ_c030_0_12 (mix_q_src_c030_0_12 0 bpf_c030_0 0) vcvs gain=-9.807852804032e-01
SMIXQ_c030_0_12 (mix_q_src_c030_0_12 mix_q_c030_0 win_0_12 0) relay vt1=-1m vt2=1m ropen=ropen_mix rclosed=rclosed_mix
EMIXI_c030_0_13 (mix_i_src_c030_0_13 0 bpf_c030_0 0) vcvs gain=5.555702330196e-01
SMIXI_c030_0_13 (mix_i_src_c030_0_13 mix_i_c030_0 win_0_13 0) relay vt1=-1m vt2=1m ropen=ropen_mix rclosed=rclosed_mix
EMIXQ_c030_0_13 (mix_q_src_c030_0_13 0 bpf_c030_0 0) vcvs gain=-8.314696123025e-01
SMIXQ_c030_0_13 (mix_q_src_c030_0_13 mix_q_c030_0 win_0_13 0) relay vt1=-1m vt2=1m ropen=ropen_mix rclosed=rclosed_mix
EMIXI_c030_0_14 (mix_i_src_c030_0_14 0 bpf_c030_0 0) vcvs gain=8.314696123025e-01
SMIXI_c030_0_14 (mix_i_src_c030_0_14 mix_i_c030_0 win_0_14 0) relay vt1=-1m vt2=1m ropen=ropen_mix rclosed=rclosed_mix
EMIXQ_c030_0_14 (mix_q_src_c030_0_14 0 bpf_c030_0 0) vcvs gain=-5.555702330196e-01
SMIXQ_c030_0_14 (mix_q_src_c030_0_14 mix_q_c030_0 win_0_14 0) relay vt1=-1m vt2=1m ropen=ropen_mix rclosed=rclosed_mix
EMIXI_c030_0_15 (mix_i_src_c030_0_15 0 bpf_c030_0 0) vcvs gain=9.807852804032e-01
SMIXI_c030_0_15 (mix_i_src_c030_0_15 mix_i_c030_0 win_0_15 0) relay vt1=-1m vt2=1m ropen=ropen_mix rclosed=rclosed_mix
EMIXQ_c030_0_15 (mix_q_src_c030_0_15 0 bpf_c030_0 0) vcvs gain=-1.950903220161e-01
SMIXQ_c030_0_15 (mix_q_src_c030_0_15 mix_q_c030_0 win_0_15 0) relay vt1=-1m vt2=1m ropen=ropen_mix rclosed=rclosed_mix
RMIXI_c030_0 (mix_i_c030_0 0) resistor r=1G
RMIXQ_c030_0 (mix_q_c030_0 0) resistor r=1G
RINTI_c030_0 (mix_i_c030_0 Icar_c030_0) resistor r=1k
CINTI_c030_0 (Icar_c030_0 0) capacitor c=80p
RINTQ_c030_0 (mix_q_c030_0 Qcar_c030_0) resistor r=1k
CINTQ_c030_0 (Qcar_c030_0 0) capacitor c=80p
save bpf_c030_0 Icar_c030_0 Qcar_c030_0

// bl030, carrier_1: 500000000 Hz coherent I/Q phase-window verification-demod path
CBPF_c030_1 (bl030 n_cbpf_c030_1) capacitor c=1.013211836423e-13
LBPF_c030_1 (n_cbpf_c030_1 bpf_c030_1) inductor l=1.000000000000e-06
RBPF_c030_1 (bpf_c030_1 0) resistor r=1.570796326795e+02
EMIXI_c030_1_00 (mix_i_src_c030_1_00 0 bpf_c030_1 0) vcvs gain=9.807852804032e-01
SMIXI_c030_1_00 (mix_i_src_c030_1_00 mix_i_c030_1 win_1_00 0) relay vt1=-1m vt2=1m ropen=ropen_mix rclosed=rclosed_mix
EMIXQ_c030_1_00 (mix_q_src_c030_1_00 0 bpf_c030_1 0) vcvs gain=1.950903220161e-01
SMIXQ_c030_1_00 (mix_q_src_c030_1_00 mix_q_c030_1 win_1_00 0) relay vt1=-1m vt2=1m ropen=ropen_mix rclosed=rclosed_mix
EMIXI_c030_1_01 (mix_i_src_c030_1_01 0 bpf_c030_1 0) vcvs gain=8.314696123025e-01
SMIXI_c030_1_01 (mix_i_src_c030_1_01 mix_i_c030_1 win_1_01 0) relay vt1=-1m vt2=1m ropen=ropen_mix rclosed=rclosed_mix
EMIXQ_c030_1_01 (mix_q_src_c030_1_01 0 bpf_c030_1 0) vcvs gain=5.555702330196e-01
SMIXQ_c030_1_01 (mix_q_src_c030_1_01 mix_q_c030_1 win_1_01 0) relay vt1=-1m vt2=1m ropen=ropen_mix rclosed=rclosed_mix
EMIXI_c030_1_02 (mix_i_src_c030_1_02 0 bpf_c030_1 0) vcvs gain=5.555702330196e-01
SMIXI_c030_1_02 (mix_i_src_c030_1_02 mix_i_c030_1 win_1_02 0) relay vt1=-1m vt2=1m ropen=ropen_mix rclosed=rclosed_mix
EMIXQ_c030_1_02 (mix_q_src_c030_1_02 0 bpf_c030_1 0) vcvs gain=8.314696123025e-01
SMIXQ_c030_1_02 (mix_q_src_c030_1_02 mix_q_c030_1 win_1_02 0) relay vt1=-1m vt2=1m ropen=ropen_mix rclosed=rclosed_mix
EMIXI_c030_1_03 (mix_i_src_c030_1_03 0 bpf_c030_1 0) vcvs gain=1.950903220161e-01
SMIXI_c030_1_03 (mix_i_src_c030_1_03 mix_i_c030_1 win_1_03 0) relay vt1=-1m vt2=1m ropen=ropen_mix rclosed=rclosed_mix
EMIXQ_c030_1_03 (mix_q_src_c030_1_03 0 bpf_c030_1 0) vcvs gain=9.807852804032e-01
SMIXQ_c030_1_03 (mix_q_src_c030_1_03 mix_q_c030_1 win_1_03 0) relay vt1=-1m vt2=1m ropen=ropen_mix rclosed=rclosed_mix
EMIXI_c030_1_04 (mix_i_src_c030_1_04 0 bpf_c030_1 0) vcvs gain=-1.950903220161e-01
SMIXI_c030_1_04 (mix_i_src_c030_1_04 mix_i_c030_1 win_1_04 0) relay vt1=-1m vt2=1m ropen=ropen_mix rclosed=rclosed_mix
EMIXQ_c030_1_04 (mix_q_src_c030_1_04 0 bpf_c030_1 0) vcvs gain=9.807852804032e-01
SMIXQ_c030_1_04 (mix_q_src_c030_1_04 mix_q_c030_1 win_1_04 0) relay vt1=-1m vt2=1m ropen=ropen_mix rclosed=rclosed_mix
EMIXI_c030_1_05 (mix_i_src_c030_1_05 0 bpf_c030_1 0) vcvs gain=-5.555702330196e-01
SMIXI_c030_1_05 (mix_i_src_c030_1_05 mix_i_c030_1 win_1_05 0) relay vt1=-1m vt2=1m ropen=ropen_mix rclosed=rclosed_mix
EMIXQ_c030_1_05 (mix_q_src_c030_1_05 0 bpf_c030_1 0) vcvs gain=8.314696123025e-01
SMIXQ_c030_1_05 (mix_q_src_c030_1_05 mix_q_c030_1 win_1_05 0) relay vt1=-1m vt2=1m ropen=ropen_mix rclosed=rclosed_mix
EMIXI_c030_1_06 (mix_i_src_c030_1_06 0 bpf_c030_1 0) vcvs gain=-8.314696123025e-01
SMIXI_c030_1_06 (mix_i_src_c030_1_06 mix_i_c030_1 win_1_06 0) relay vt1=-1m vt2=1m ropen=ropen_mix rclosed=rclosed_mix
EMIXQ_c030_1_06 (mix_q_src_c030_1_06 0 bpf_c030_1 0) vcvs gain=5.555702330196e-01
SMIXQ_c030_1_06 (mix_q_src_c030_1_06 mix_q_c030_1 win_1_06 0) relay vt1=-1m vt2=1m ropen=ropen_mix rclosed=rclosed_mix
EMIXI_c030_1_07 (mix_i_src_c030_1_07 0 bpf_c030_1 0) vcvs gain=-9.807852804032e-01
SMIXI_c030_1_07 (mix_i_src_c030_1_07 mix_i_c030_1 win_1_07 0) relay vt1=-1m vt2=1m ropen=ropen_mix rclosed=rclosed_mix
EMIXQ_c030_1_07 (mix_q_src_c030_1_07 0 bpf_c030_1 0) vcvs gain=1.950903220161e-01
SMIXQ_c030_1_07 (mix_q_src_c030_1_07 mix_q_c030_1 win_1_07 0) relay vt1=-1m vt2=1m ropen=ropen_mix rclosed=rclosed_mix
EMIXI_c030_1_08 (mix_i_src_c030_1_08 0 bpf_c030_1 0) vcvs gain=-9.807852804032e-01
SMIXI_c030_1_08 (mix_i_src_c030_1_08 mix_i_c030_1 win_1_08 0) relay vt1=-1m vt2=1m ropen=ropen_mix rclosed=rclosed_mix
EMIXQ_c030_1_08 (mix_q_src_c030_1_08 0 bpf_c030_1 0) vcvs gain=-1.950903220161e-01
SMIXQ_c030_1_08 (mix_q_src_c030_1_08 mix_q_c030_1 win_1_08 0) relay vt1=-1m vt2=1m ropen=ropen_mix rclosed=rclosed_mix
EMIXI_c030_1_09 (mix_i_src_c030_1_09 0 bpf_c030_1 0) vcvs gain=-8.314696123025e-01
SMIXI_c030_1_09 (mix_i_src_c030_1_09 mix_i_c030_1 win_1_09 0) relay vt1=-1m vt2=1m ropen=ropen_mix rclosed=rclosed_mix
EMIXQ_c030_1_09 (mix_q_src_c030_1_09 0 bpf_c030_1 0) vcvs gain=-5.555702330196e-01
SMIXQ_c030_1_09 (mix_q_src_c030_1_09 mix_q_c030_1 win_1_09 0) relay vt1=-1m vt2=1m ropen=ropen_mix rclosed=rclosed_mix
EMIXI_c030_1_10 (mix_i_src_c030_1_10 0 bpf_c030_1 0) vcvs gain=-5.555702330196e-01
SMIXI_c030_1_10 (mix_i_src_c030_1_10 mix_i_c030_1 win_1_10 0) relay vt1=-1m vt2=1m ropen=ropen_mix rclosed=rclosed_mix
EMIXQ_c030_1_10 (mix_q_src_c030_1_10 0 bpf_c030_1 0) vcvs gain=-8.314696123025e-01
SMIXQ_c030_1_10 (mix_q_src_c030_1_10 mix_q_c030_1 win_1_10 0) relay vt1=-1m vt2=1m ropen=ropen_mix rclosed=rclosed_mix
EMIXI_c030_1_11 (mix_i_src_c030_1_11 0 bpf_c030_1 0) vcvs gain=-1.950903220161e-01
SMIXI_c030_1_11 (mix_i_src_c030_1_11 mix_i_c030_1 win_1_11 0) relay vt1=-1m vt2=1m ropen=ropen_mix rclosed=rclosed_mix
EMIXQ_c030_1_11 (mix_q_src_c030_1_11 0 bpf_c030_1 0) vcvs gain=-9.807852804032e-01
SMIXQ_c030_1_11 (mix_q_src_c030_1_11 mix_q_c030_1 win_1_11 0) relay vt1=-1m vt2=1m ropen=ropen_mix rclosed=rclosed_mix
EMIXI_c030_1_12 (mix_i_src_c030_1_12 0 bpf_c030_1 0) vcvs gain=1.950903220161e-01
SMIXI_c030_1_12 (mix_i_src_c030_1_12 mix_i_c030_1 win_1_12 0) relay vt1=-1m vt2=1m ropen=ropen_mix rclosed=rclosed_mix
EMIXQ_c030_1_12 (mix_q_src_c030_1_12 0 bpf_c030_1 0) vcvs gain=-9.807852804032e-01
SMIXQ_c030_1_12 (mix_q_src_c030_1_12 mix_q_c030_1 win_1_12 0) relay vt1=-1m vt2=1m ropen=ropen_mix rclosed=rclosed_mix
EMIXI_c030_1_13 (mix_i_src_c030_1_13 0 bpf_c030_1 0) vcvs gain=5.555702330196e-01
SMIXI_c030_1_13 (mix_i_src_c030_1_13 mix_i_c030_1 win_1_13 0) relay vt1=-1m vt2=1m ropen=ropen_mix rclosed=rclosed_mix
EMIXQ_c030_1_13 (mix_q_src_c030_1_13 0 bpf_c030_1 0) vcvs gain=-8.314696123025e-01
SMIXQ_c030_1_13 (mix_q_src_c030_1_13 mix_q_c030_1 win_1_13 0) relay vt1=-1m vt2=1m ropen=ropen_mix rclosed=rclosed_mix
EMIXI_c030_1_14 (mix_i_src_c030_1_14 0 bpf_c030_1 0) vcvs gain=8.314696123025e-01
SMIXI_c030_1_14 (mix_i_src_c030_1_14 mix_i_c030_1 win_1_14 0) relay vt1=-1m vt2=1m ropen=ropen_mix rclosed=rclosed_mix
EMIXQ_c030_1_14 (mix_q_src_c030_1_14 0 bpf_c030_1 0) vcvs gain=-5.555702330196e-01
SMIXQ_c030_1_14 (mix_q_src_c030_1_14 mix_q_c030_1 win_1_14 0) relay vt1=-1m vt2=1m ropen=ropen_mix rclosed=rclosed_mix
EMIXI_c030_1_15 (mix_i_src_c030_1_15 0 bpf_c030_1 0) vcvs gain=9.807852804032e-01
SMIXI_c030_1_15 (mix_i_src_c030_1_15 mix_i_c030_1 win_1_15 0) relay vt1=-1m vt2=1m ropen=ropen_mix rclosed=rclosed_mix
EMIXQ_c030_1_15 (mix_q_src_c030_1_15 0 bpf_c030_1 0) vcvs gain=-1.950903220161e-01
SMIXQ_c030_1_15 (mix_q_src_c030_1_15 mix_q_c030_1 win_1_15 0) relay vt1=-1m vt2=1m ropen=ropen_mix rclosed=rclosed_mix
RMIXI_c030_1 (mix_i_c030_1 0) resistor r=1G
RMIXQ_c030_1 (mix_q_c030_1 0) resistor r=1G
RINTI_c030_1 (mix_i_c030_1 Icar_c030_1) resistor r=1k
CINTI_c030_1 (Icar_c030_1 0) capacitor c=80p
RINTQ_c030_1 (mix_q_c030_1 Qcar_c030_1) resistor r=1k
CINTQ_c030_1 (Qcar_c030_1 0) capacitor c=80p
save bpf_c030_1 Icar_c030_1 Qcar_c030_1

// bl030, carrier_2: 750000000 Hz coherent I/Q phase-window verification-demod path
CBPF_c030_2 (bl030 n_cbpf_c030_2) capacitor c=4.503163717437e-14
LBPF_c030_2 (n_cbpf_c030_2 bpf_c030_2) inductor l=1.000000000000e-06
RBPF_c030_2 (bpf_c030_2 0) resistor r=2.356194490192e+02
EMIXI_c030_2_00 (mix_i_src_c030_2_00 0 bpf_c030_2 0) vcvs gain=9.807852804032e-01
SMIXI_c030_2_00 (mix_i_src_c030_2_00 mix_i_c030_2 win_2_00 0) relay vt1=-1m vt2=1m ropen=ropen_mix rclosed=rclosed_mix
EMIXQ_c030_2_00 (mix_q_src_c030_2_00 0 bpf_c030_2 0) vcvs gain=1.950903220161e-01
SMIXQ_c030_2_00 (mix_q_src_c030_2_00 mix_q_c030_2 win_2_00 0) relay vt1=-1m vt2=1m ropen=ropen_mix rclosed=rclosed_mix
EMIXI_c030_2_01 (mix_i_src_c030_2_01 0 bpf_c030_2 0) vcvs gain=8.314696123025e-01
SMIXI_c030_2_01 (mix_i_src_c030_2_01 mix_i_c030_2 win_2_01 0) relay vt1=-1m vt2=1m ropen=ropen_mix rclosed=rclosed_mix
EMIXQ_c030_2_01 (mix_q_src_c030_2_01 0 bpf_c030_2 0) vcvs gain=5.555702330196e-01
SMIXQ_c030_2_01 (mix_q_src_c030_2_01 mix_q_c030_2 win_2_01 0) relay vt1=-1m vt2=1m ropen=ropen_mix rclosed=rclosed_mix
EMIXI_c030_2_02 (mix_i_src_c030_2_02 0 bpf_c030_2 0) vcvs gain=5.555702330196e-01
SMIXI_c030_2_02 (mix_i_src_c030_2_02 mix_i_c030_2 win_2_02 0) relay vt1=-1m vt2=1m ropen=ropen_mix rclosed=rclosed_mix
EMIXQ_c030_2_02 (mix_q_src_c030_2_02 0 bpf_c030_2 0) vcvs gain=8.314696123025e-01
SMIXQ_c030_2_02 (mix_q_src_c030_2_02 mix_q_c030_2 win_2_02 0) relay vt1=-1m vt2=1m ropen=ropen_mix rclosed=rclosed_mix
EMIXI_c030_2_03 (mix_i_src_c030_2_03 0 bpf_c030_2 0) vcvs gain=1.950903220161e-01
SMIXI_c030_2_03 (mix_i_src_c030_2_03 mix_i_c030_2 win_2_03 0) relay vt1=-1m vt2=1m ropen=ropen_mix rclosed=rclosed_mix
EMIXQ_c030_2_03 (mix_q_src_c030_2_03 0 bpf_c030_2 0) vcvs gain=9.807852804032e-01
SMIXQ_c030_2_03 (mix_q_src_c030_2_03 mix_q_c030_2 win_2_03 0) relay vt1=-1m vt2=1m ropen=ropen_mix rclosed=rclosed_mix
EMIXI_c030_2_04 (mix_i_src_c030_2_04 0 bpf_c030_2 0) vcvs gain=-1.950903220161e-01
SMIXI_c030_2_04 (mix_i_src_c030_2_04 mix_i_c030_2 win_2_04 0) relay vt1=-1m vt2=1m ropen=ropen_mix rclosed=rclosed_mix
EMIXQ_c030_2_04 (mix_q_src_c030_2_04 0 bpf_c030_2 0) vcvs gain=9.807852804032e-01
SMIXQ_c030_2_04 (mix_q_src_c030_2_04 mix_q_c030_2 win_2_04 0) relay vt1=-1m vt2=1m ropen=ropen_mix rclosed=rclosed_mix
EMIXI_c030_2_05 (mix_i_src_c030_2_05 0 bpf_c030_2 0) vcvs gain=-5.555702330196e-01
SMIXI_c030_2_05 (mix_i_src_c030_2_05 mix_i_c030_2 win_2_05 0) relay vt1=-1m vt2=1m ropen=ropen_mix rclosed=rclosed_mix
EMIXQ_c030_2_05 (mix_q_src_c030_2_05 0 bpf_c030_2 0) vcvs gain=8.314696123025e-01
SMIXQ_c030_2_05 (mix_q_src_c030_2_05 mix_q_c030_2 win_2_05 0) relay vt1=-1m vt2=1m ropen=ropen_mix rclosed=rclosed_mix
EMIXI_c030_2_06 (mix_i_src_c030_2_06 0 bpf_c030_2 0) vcvs gain=-8.314696123025e-01
SMIXI_c030_2_06 (mix_i_src_c030_2_06 mix_i_c030_2 win_2_06 0) relay vt1=-1m vt2=1m ropen=ropen_mix rclosed=rclosed_mix
EMIXQ_c030_2_06 (mix_q_src_c030_2_06 0 bpf_c030_2 0) vcvs gain=5.555702330196e-01
SMIXQ_c030_2_06 (mix_q_src_c030_2_06 mix_q_c030_2 win_2_06 0) relay vt1=-1m vt2=1m ropen=ropen_mix rclosed=rclosed_mix
EMIXI_c030_2_07 (mix_i_src_c030_2_07 0 bpf_c030_2 0) vcvs gain=-9.807852804032e-01
SMIXI_c030_2_07 (mix_i_src_c030_2_07 mix_i_c030_2 win_2_07 0) relay vt1=-1m vt2=1m ropen=ropen_mix rclosed=rclosed_mix
EMIXQ_c030_2_07 (mix_q_src_c030_2_07 0 bpf_c030_2 0) vcvs gain=1.950903220161e-01
SMIXQ_c030_2_07 (mix_q_src_c030_2_07 mix_q_c030_2 win_2_07 0) relay vt1=-1m vt2=1m ropen=ropen_mix rclosed=rclosed_mix
EMIXI_c030_2_08 (mix_i_src_c030_2_08 0 bpf_c030_2 0) vcvs gain=-9.807852804032e-01
SMIXI_c030_2_08 (mix_i_src_c030_2_08 mix_i_c030_2 win_2_08 0) relay vt1=-1m vt2=1m ropen=ropen_mix rclosed=rclosed_mix
EMIXQ_c030_2_08 (mix_q_src_c030_2_08 0 bpf_c030_2 0) vcvs gain=-1.950903220161e-01
SMIXQ_c030_2_08 (mix_q_src_c030_2_08 mix_q_c030_2 win_2_08 0) relay vt1=-1m vt2=1m ropen=ropen_mix rclosed=rclosed_mix
EMIXI_c030_2_09 (mix_i_src_c030_2_09 0 bpf_c030_2 0) vcvs gain=-8.314696123025e-01
SMIXI_c030_2_09 (mix_i_src_c030_2_09 mix_i_c030_2 win_2_09 0) relay vt1=-1m vt2=1m ropen=ropen_mix rclosed=rclosed_mix
EMIXQ_c030_2_09 (mix_q_src_c030_2_09 0 bpf_c030_2 0) vcvs gain=-5.555702330196e-01
SMIXQ_c030_2_09 (mix_q_src_c030_2_09 mix_q_c030_2 win_2_09 0) relay vt1=-1m vt2=1m ropen=ropen_mix rclosed=rclosed_mix
EMIXI_c030_2_10 (mix_i_src_c030_2_10 0 bpf_c030_2 0) vcvs gain=-5.555702330196e-01
SMIXI_c030_2_10 (mix_i_src_c030_2_10 mix_i_c030_2 win_2_10 0) relay vt1=-1m vt2=1m ropen=ropen_mix rclosed=rclosed_mix
EMIXQ_c030_2_10 (mix_q_src_c030_2_10 0 bpf_c030_2 0) vcvs gain=-8.314696123025e-01
SMIXQ_c030_2_10 (mix_q_src_c030_2_10 mix_q_c030_2 win_2_10 0) relay vt1=-1m vt2=1m ropen=ropen_mix rclosed=rclosed_mix
EMIXI_c030_2_11 (mix_i_src_c030_2_11 0 bpf_c030_2 0) vcvs gain=-1.950903220161e-01
SMIXI_c030_2_11 (mix_i_src_c030_2_11 mix_i_c030_2 win_2_11 0) relay vt1=-1m vt2=1m ropen=ropen_mix rclosed=rclosed_mix
EMIXQ_c030_2_11 (mix_q_src_c030_2_11 0 bpf_c030_2 0) vcvs gain=-9.807852804032e-01
SMIXQ_c030_2_11 (mix_q_src_c030_2_11 mix_q_c030_2 win_2_11 0) relay vt1=-1m vt2=1m ropen=ropen_mix rclosed=rclosed_mix
EMIXI_c030_2_12 (mix_i_src_c030_2_12 0 bpf_c030_2 0) vcvs gain=1.950903220161e-01
SMIXI_c030_2_12 (mix_i_src_c030_2_12 mix_i_c030_2 win_2_12 0) relay vt1=-1m vt2=1m ropen=ropen_mix rclosed=rclosed_mix
EMIXQ_c030_2_12 (mix_q_src_c030_2_12 0 bpf_c030_2 0) vcvs gain=-9.807852804032e-01
SMIXQ_c030_2_12 (mix_q_src_c030_2_12 mix_q_c030_2 win_2_12 0) relay vt1=-1m vt2=1m ropen=ropen_mix rclosed=rclosed_mix
EMIXI_c030_2_13 (mix_i_src_c030_2_13 0 bpf_c030_2 0) vcvs gain=5.555702330196e-01
SMIXI_c030_2_13 (mix_i_src_c030_2_13 mix_i_c030_2 win_2_13 0) relay vt1=-1m vt2=1m ropen=ropen_mix rclosed=rclosed_mix
EMIXQ_c030_2_13 (mix_q_src_c030_2_13 0 bpf_c030_2 0) vcvs gain=-8.314696123025e-01
SMIXQ_c030_2_13 (mix_q_src_c030_2_13 mix_q_c030_2 win_2_13 0) relay vt1=-1m vt2=1m ropen=ropen_mix rclosed=rclosed_mix
EMIXI_c030_2_14 (mix_i_src_c030_2_14 0 bpf_c030_2 0) vcvs gain=8.314696123025e-01
SMIXI_c030_2_14 (mix_i_src_c030_2_14 mix_i_c030_2 win_2_14 0) relay vt1=-1m vt2=1m ropen=ropen_mix rclosed=rclosed_mix
EMIXQ_c030_2_14 (mix_q_src_c030_2_14 0 bpf_c030_2 0) vcvs gain=-5.555702330196e-01
SMIXQ_c030_2_14 (mix_q_src_c030_2_14 mix_q_c030_2 win_2_14 0) relay vt1=-1m vt2=1m ropen=ropen_mix rclosed=rclosed_mix
EMIXI_c030_2_15 (mix_i_src_c030_2_15 0 bpf_c030_2 0) vcvs gain=9.807852804032e-01
SMIXI_c030_2_15 (mix_i_src_c030_2_15 mix_i_c030_2 win_2_15 0) relay vt1=-1m vt2=1m ropen=ropen_mix rclosed=rclosed_mix
EMIXQ_c030_2_15 (mix_q_src_c030_2_15 0 bpf_c030_2 0) vcvs gain=-1.950903220161e-01
SMIXQ_c030_2_15 (mix_q_src_c030_2_15 mix_q_c030_2 win_2_15 0) relay vt1=-1m vt2=1m ropen=ropen_mix rclosed=rclosed_mix
RMIXI_c030_2 (mix_i_c030_2 0) resistor r=1G
RMIXQ_c030_2 (mix_q_c030_2 0) resistor r=1G
RINTI_c030_2 (mix_i_c030_2 Icar_c030_2) resistor r=1k
CINTI_c030_2 (Icar_c030_2 0) capacitor c=80p
RINTQ_c030_2 (mix_q_c030_2 Qcar_c030_2) resistor r=1k
CINTQ_c030_2 (Qcar_c030_2 0) capacitor c=80p
save bpf_c030_2 Icar_c030_2 Qcar_c030_2

// bl030, carrier_3: 1000000000 Hz coherent I/Q phase-window verification-demod path
CBPF_c030_3 (bl030 n_cbpf_c030_3) capacitor c=2.533029591058e-14
LBPF_c030_3 (n_cbpf_c030_3 bpf_c030_3) inductor l=1.000000000000e-06
RBPF_c030_3 (bpf_c030_3 0) resistor r=3.141592653590e+02
EMIXI_c030_3_00 (mix_i_src_c030_3_00 0 bpf_c030_3 0) vcvs gain=9.807852804032e-01
SMIXI_c030_3_00 (mix_i_src_c030_3_00 mix_i_c030_3 win_3_00 0) relay vt1=-1m vt2=1m ropen=ropen_mix rclosed=rclosed_mix
EMIXQ_c030_3_00 (mix_q_src_c030_3_00 0 bpf_c030_3 0) vcvs gain=1.950903220161e-01
SMIXQ_c030_3_00 (mix_q_src_c030_3_00 mix_q_c030_3 win_3_00 0) relay vt1=-1m vt2=1m ropen=ropen_mix rclosed=rclosed_mix
EMIXI_c030_3_01 (mix_i_src_c030_3_01 0 bpf_c030_3 0) vcvs gain=8.314696123025e-01
SMIXI_c030_3_01 (mix_i_src_c030_3_01 mix_i_c030_3 win_3_01 0) relay vt1=-1m vt2=1m ropen=ropen_mix rclosed=rclosed_mix
EMIXQ_c030_3_01 (mix_q_src_c030_3_01 0 bpf_c030_3 0) vcvs gain=5.555702330196e-01
SMIXQ_c030_3_01 (mix_q_src_c030_3_01 mix_q_c030_3 win_3_01 0) relay vt1=-1m vt2=1m ropen=ropen_mix rclosed=rclosed_mix
EMIXI_c030_3_02 (mix_i_src_c030_3_02 0 bpf_c030_3 0) vcvs gain=5.555702330196e-01
SMIXI_c030_3_02 (mix_i_src_c030_3_02 mix_i_c030_3 win_3_02 0) relay vt1=-1m vt2=1m ropen=ropen_mix rclosed=rclosed_mix
EMIXQ_c030_3_02 (mix_q_src_c030_3_02 0 bpf_c030_3 0) vcvs gain=8.314696123025e-01
SMIXQ_c030_3_02 (mix_q_src_c030_3_02 mix_q_c030_3 win_3_02 0) relay vt1=-1m vt2=1m ropen=ropen_mix rclosed=rclosed_mix
EMIXI_c030_3_03 (mix_i_src_c030_3_03 0 bpf_c030_3 0) vcvs gain=1.950903220161e-01
SMIXI_c030_3_03 (mix_i_src_c030_3_03 mix_i_c030_3 win_3_03 0) relay vt1=-1m vt2=1m ropen=ropen_mix rclosed=rclosed_mix
EMIXQ_c030_3_03 (mix_q_src_c030_3_03 0 bpf_c030_3 0) vcvs gain=9.807852804032e-01
SMIXQ_c030_3_03 (mix_q_src_c030_3_03 mix_q_c030_3 win_3_03 0) relay vt1=-1m vt2=1m ropen=ropen_mix rclosed=rclosed_mix
EMIXI_c030_3_04 (mix_i_src_c030_3_04 0 bpf_c030_3 0) vcvs gain=-1.950903220161e-01
SMIXI_c030_3_04 (mix_i_src_c030_3_04 mix_i_c030_3 win_3_04 0) relay vt1=-1m vt2=1m ropen=ropen_mix rclosed=rclosed_mix
EMIXQ_c030_3_04 (mix_q_src_c030_3_04 0 bpf_c030_3 0) vcvs gain=9.807852804032e-01
SMIXQ_c030_3_04 (mix_q_src_c030_3_04 mix_q_c030_3 win_3_04 0) relay vt1=-1m vt2=1m ropen=ropen_mix rclosed=rclosed_mix
EMIXI_c030_3_05 (mix_i_src_c030_3_05 0 bpf_c030_3 0) vcvs gain=-5.555702330196e-01
SMIXI_c030_3_05 (mix_i_src_c030_3_05 mix_i_c030_3 win_3_05 0) relay vt1=-1m vt2=1m ropen=ropen_mix rclosed=rclosed_mix
EMIXQ_c030_3_05 (mix_q_src_c030_3_05 0 bpf_c030_3 0) vcvs gain=8.314696123025e-01
SMIXQ_c030_3_05 (mix_q_src_c030_3_05 mix_q_c030_3 win_3_05 0) relay vt1=-1m vt2=1m ropen=ropen_mix rclosed=rclosed_mix
EMIXI_c030_3_06 (mix_i_src_c030_3_06 0 bpf_c030_3 0) vcvs gain=-8.314696123025e-01
SMIXI_c030_3_06 (mix_i_src_c030_3_06 mix_i_c030_3 win_3_06 0) relay vt1=-1m vt2=1m ropen=ropen_mix rclosed=rclosed_mix
EMIXQ_c030_3_06 (mix_q_src_c030_3_06 0 bpf_c030_3 0) vcvs gain=5.555702330196e-01
SMIXQ_c030_3_06 (mix_q_src_c030_3_06 mix_q_c030_3 win_3_06 0) relay vt1=-1m vt2=1m ropen=ropen_mix rclosed=rclosed_mix
EMIXI_c030_3_07 (mix_i_src_c030_3_07 0 bpf_c030_3 0) vcvs gain=-9.807852804032e-01
SMIXI_c030_3_07 (mix_i_src_c030_3_07 mix_i_c030_3 win_3_07 0) relay vt1=-1m vt2=1m ropen=ropen_mix rclosed=rclosed_mix
EMIXQ_c030_3_07 (mix_q_src_c030_3_07 0 bpf_c030_3 0) vcvs gain=1.950903220161e-01
SMIXQ_c030_3_07 (mix_q_src_c030_3_07 mix_q_c030_3 win_3_07 0) relay vt1=-1m vt2=1m ropen=ropen_mix rclosed=rclosed_mix
EMIXI_c030_3_08 (mix_i_src_c030_3_08 0 bpf_c030_3 0) vcvs gain=-9.807852804032e-01
SMIXI_c030_3_08 (mix_i_src_c030_3_08 mix_i_c030_3 win_3_08 0) relay vt1=-1m vt2=1m ropen=ropen_mix rclosed=rclosed_mix
EMIXQ_c030_3_08 (mix_q_src_c030_3_08 0 bpf_c030_3 0) vcvs gain=-1.950903220161e-01
SMIXQ_c030_3_08 (mix_q_src_c030_3_08 mix_q_c030_3 win_3_08 0) relay vt1=-1m vt2=1m ropen=ropen_mix rclosed=rclosed_mix
EMIXI_c030_3_09 (mix_i_src_c030_3_09 0 bpf_c030_3 0) vcvs gain=-8.314696123025e-01
SMIXI_c030_3_09 (mix_i_src_c030_3_09 mix_i_c030_3 win_3_09 0) relay vt1=-1m vt2=1m ropen=ropen_mix rclosed=rclosed_mix
EMIXQ_c030_3_09 (mix_q_src_c030_3_09 0 bpf_c030_3 0) vcvs gain=-5.555702330196e-01
SMIXQ_c030_3_09 (mix_q_src_c030_3_09 mix_q_c030_3 win_3_09 0) relay vt1=-1m vt2=1m ropen=ropen_mix rclosed=rclosed_mix
EMIXI_c030_3_10 (mix_i_src_c030_3_10 0 bpf_c030_3 0) vcvs gain=-5.555702330196e-01
SMIXI_c030_3_10 (mix_i_src_c030_3_10 mix_i_c030_3 win_3_10 0) relay vt1=-1m vt2=1m ropen=ropen_mix rclosed=rclosed_mix
EMIXQ_c030_3_10 (mix_q_src_c030_3_10 0 bpf_c030_3 0) vcvs gain=-8.314696123025e-01
SMIXQ_c030_3_10 (mix_q_src_c030_3_10 mix_q_c030_3 win_3_10 0) relay vt1=-1m vt2=1m ropen=ropen_mix rclosed=rclosed_mix
EMIXI_c030_3_11 (mix_i_src_c030_3_11 0 bpf_c030_3 0) vcvs gain=-1.950903220161e-01
SMIXI_c030_3_11 (mix_i_src_c030_3_11 mix_i_c030_3 win_3_11 0) relay vt1=-1m vt2=1m ropen=ropen_mix rclosed=rclosed_mix
EMIXQ_c030_3_11 (mix_q_src_c030_3_11 0 bpf_c030_3 0) vcvs gain=-9.807852804032e-01
SMIXQ_c030_3_11 (mix_q_src_c030_3_11 mix_q_c030_3 win_3_11 0) relay vt1=-1m vt2=1m ropen=ropen_mix rclosed=rclosed_mix
EMIXI_c030_3_12 (mix_i_src_c030_3_12 0 bpf_c030_3 0) vcvs gain=1.950903220161e-01
SMIXI_c030_3_12 (mix_i_src_c030_3_12 mix_i_c030_3 win_3_12 0) relay vt1=-1m vt2=1m ropen=ropen_mix rclosed=rclosed_mix
EMIXQ_c030_3_12 (mix_q_src_c030_3_12 0 bpf_c030_3 0) vcvs gain=-9.807852804032e-01
SMIXQ_c030_3_12 (mix_q_src_c030_3_12 mix_q_c030_3 win_3_12 0) relay vt1=-1m vt2=1m ropen=ropen_mix rclosed=rclosed_mix
EMIXI_c030_3_13 (mix_i_src_c030_3_13 0 bpf_c030_3 0) vcvs gain=5.555702330196e-01
SMIXI_c030_3_13 (mix_i_src_c030_3_13 mix_i_c030_3 win_3_13 0) relay vt1=-1m vt2=1m ropen=ropen_mix rclosed=rclosed_mix
EMIXQ_c030_3_13 (mix_q_src_c030_3_13 0 bpf_c030_3 0) vcvs gain=-8.314696123025e-01
SMIXQ_c030_3_13 (mix_q_src_c030_3_13 mix_q_c030_3 win_3_13 0) relay vt1=-1m vt2=1m ropen=ropen_mix rclosed=rclosed_mix
EMIXI_c030_3_14 (mix_i_src_c030_3_14 0 bpf_c030_3 0) vcvs gain=8.314696123025e-01
SMIXI_c030_3_14 (mix_i_src_c030_3_14 mix_i_c030_3 win_3_14 0) relay vt1=-1m vt2=1m ropen=ropen_mix rclosed=rclosed_mix
EMIXQ_c030_3_14 (mix_q_src_c030_3_14 0 bpf_c030_3 0) vcvs gain=-5.555702330196e-01
SMIXQ_c030_3_14 (mix_q_src_c030_3_14 mix_q_c030_3 win_3_14 0) relay vt1=-1m vt2=1m ropen=ropen_mix rclosed=rclosed_mix
EMIXI_c030_3_15 (mix_i_src_c030_3_15 0 bpf_c030_3 0) vcvs gain=9.807852804032e-01
SMIXI_c030_3_15 (mix_i_src_c030_3_15 mix_i_c030_3 win_3_15 0) relay vt1=-1m vt2=1m ropen=ropen_mix rclosed=rclosed_mix
EMIXQ_c030_3_15 (mix_q_src_c030_3_15 0 bpf_c030_3 0) vcvs gain=-1.950903220161e-01
SMIXQ_c030_3_15 (mix_q_src_c030_3_15 mix_q_c030_3 win_3_15 0) relay vt1=-1m vt2=1m ropen=ropen_mix rclosed=rclosed_mix
RMIXI_c030_3 (mix_i_c030_3 0) resistor r=1G
RMIXQ_c030_3 (mix_q_c030_3 0) resistor r=1G
RINTI_c030_3 (mix_i_c030_3 Icar_c030_3) resistor r=1k
CINTI_c030_3 (Icar_c030_3 0) capacitor c=80p
RINTQ_c030_3 (mix_q_c030_3 Qcar_c030_3) resistor r=1k
CINTQ_c030_3 (Qcar_c030_3 0) capacitor c=80p
save bpf_c030_3 Icar_c030_3 Qcar_c030_3

// bl031, carrier_0: 250000000 Hz coherent I/Q phase-window verification-demod path
CBPF_c031_0 (bl031 n_cbpf_c031_0) capacitor c=4.052847345694e-13
LBPF_c031_0 (n_cbpf_c031_0 bpf_c031_0) inductor l=1.000000000000e-06
RBPF_c031_0 (bpf_c031_0 0) resistor r=7.853981633974e+01
EMIXI_c031_0_00 (mix_i_src_c031_0_00 0 bpf_c031_0 0) vcvs gain=9.807852804032e-01
SMIXI_c031_0_00 (mix_i_src_c031_0_00 mix_i_c031_0 win_0_00 0) relay vt1=-1m vt2=1m ropen=ropen_mix rclosed=rclosed_mix
EMIXQ_c031_0_00 (mix_q_src_c031_0_00 0 bpf_c031_0 0) vcvs gain=1.950903220161e-01
SMIXQ_c031_0_00 (mix_q_src_c031_0_00 mix_q_c031_0 win_0_00 0) relay vt1=-1m vt2=1m ropen=ropen_mix rclosed=rclosed_mix
EMIXI_c031_0_01 (mix_i_src_c031_0_01 0 bpf_c031_0 0) vcvs gain=8.314696123025e-01
SMIXI_c031_0_01 (mix_i_src_c031_0_01 mix_i_c031_0 win_0_01 0) relay vt1=-1m vt2=1m ropen=ropen_mix rclosed=rclosed_mix
EMIXQ_c031_0_01 (mix_q_src_c031_0_01 0 bpf_c031_0 0) vcvs gain=5.555702330196e-01
SMIXQ_c031_0_01 (mix_q_src_c031_0_01 mix_q_c031_0 win_0_01 0) relay vt1=-1m vt2=1m ropen=ropen_mix rclosed=rclosed_mix
EMIXI_c031_0_02 (mix_i_src_c031_0_02 0 bpf_c031_0 0) vcvs gain=5.555702330196e-01
SMIXI_c031_0_02 (mix_i_src_c031_0_02 mix_i_c031_0 win_0_02 0) relay vt1=-1m vt2=1m ropen=ropen_mix rclosed=rclosed_mix
EMIXQ_c031_0_02 (mix_q_src_c031_0_02 0 bpf_c031_0 0) vcvs gain=8.314696123025e-01
SMIXQ_c031_0_02 (mix_q_src_c031_0_02 mix_q_c031_0 win_0_02 0) relay vt1=-1m vt2=1m ropen=ropen_mix rclosed=rclosed_mix
EMIXI_c031_0_03 (mix_i_src_c031_0_03 0 bpf_c031_0 0) vcvs gain=1.950903220161e-01
SMIXI_c031_0_03 (mix_i_src_c031_0_03 mix_i_c031_0 win_0_03 0) relay vt1=-1m vt2=1m ropen=ropen_mix rclosed=rclosed_mix
EMIXQ_c031_0_03 (mix_q_src_c031_0_03 0 bpf_c031_0 0) vcvs gain=9.807852804032e-01
SMIXQ_c031_0_03 (mix_q_src_c031_0_03 mix_q_c031_0 win_0_03 0) relay vt1=-1m vt2=1m ropen=ropen_mix rclosed=rclosed_mix
EMIXI_c031_0_04 (mix_i_src_c031_0_04 0 bpf_c031_0 0) vcvs gain=-1.950903220161e-01
SMIXI_c031_0_04 (mix_i_src_c031_0_04 mix_i_c031_0 win_0_04 0) relay vt1=-1m vt2=1m ropen=ropen_mix rclosed=rclosed_mix
EMIXQ_c031_0_04 (mix_q_src_c031_0_04 0 bpf_c031_0 0) vcvs gain=9.807852804032e-01
SMIXQ_c031_0_04 (mix_q_src_c031_0_04 mix_q_c031_0 win_0_04 0) relay vt1=-1m vt2=1m ropen=ropen_mix rclosed=rclosed_mix
EMIXI_c031_0_05 (mix_i_src_c031_0_05 0 bpf_c031_0 0) vcvs gain=-5.555702330196e-01
SMIXI_c031_0_05 (mix_i_src_c031_0_05 mix_i_c031_0 win_0_05 0) relay vt1=-1m vt2=1m ropen=ropen_mix rclosed=rclosed_mix
EMIXQ_c031_0_05 (mix_q_src_c031_0_05 0 bpf_c031_0 0) vcvs gain=8.314696123025e-01
SMIXQ_c031_0_05 (mix_q_src_c031_0_05 mix_q_c031_0 win_0_05 0) relay vt1=-1m vt2=1m ropen=ropen_mix rclosed=rclosed_mix
EMIXI_c031_0_06 (mix_i_src_c031_0_06 0 bpf_c031_0 0) vcvs gain=-8.314696123025e-01
SMIXI_c031_0_06 (mix_i_src_c031_0_06 mix_i_c031_0 win_0_06 0) relay vt1=-1m vt2=1m ropen=ropen_mix rclosed=rclosed_mix
EMIXQ_c031_0_06 (mix_q_src_c031_0_06 0 bpf_c031_0 0) vcvs gain=5.555702330196e-01
SMIXQ_c031_0_06 (mix_q_src_c031_0_06 mix_q_c031_0 win_0_06 0) relay vt1=-1m vt2=1m ropen=ropen_mix rclosed=rclosed_mix
EMIXI_c031_0_07 (mix_i_src_c031_0_07 0 bpf_c031_0 0) vcvs gain=-9.807852804032e-01
SMIXI_c031_0_07 (mix_i_src_c031_0_07 mix_i_c031_0 win_0_07 0) relay vt1=-1m vt2=1m ropen=ropen_mix rclosed=rclosed_mix
EMIXQ_c031_0_07 (mix_q_src_c031_0_07 0 bpf_c031_0 0) vcvs gain=1.950903220161e-01
SMIXQ_c031_0_07 (mix_q_src_c031_0_07 mix_q_c031_0 win_0_07 0) relay vt1=-1m vt2=1m ropen=ropen_mix rclosed=rclosed_mix
EMIXI_c031_0_08 (mix_i_src_c031_0_08 0 bpf_c031_0 0) vcvs gain=-9.807852804032e-01
SMIXI_c031_0_08 (mix_i_src_c031_0_08 mix_i_c031_0 win_0_08 0) relay vt1=-1m vt2=1m ropen=ropen_mix rclosed=rclosed_mix
EMIXQ_c031_0_08 (mix_q_src_c031_0_08 0 bpf_c031_0 0) vcvs gain=-1.950903220161e-01
SMIXQ_c031_0_08 (mix_q_src_c031_0_08 mix_q_c031_0 win_0_08 0) relay vt1=-1m vt2=1m ropen=ropen_mix rclosed=rclosed_mix
EMIXI_c031_0_09 (mix_i_src_c031_0_09 0 bpf_c031_0 0) vcvs gain=-8.314696123025e-01
SMIXI_c031_0_09 (mix_i_src_c031_0_09 mix_i_c031_0 win_0_09 0) relay vt1=-1m vt2=1m ropen=ropen_mix rclosed=rclosed_mix
EMIXQ_c031_0_09 (mix_q_src_c031_0_09 0 bpf_c031_0 0) vcvs gain=-5.555702330196e-01
SMIXQ_c031_0_09 (mix_q_src_c031_0_09 mix_q_c031_0 win_0_09 0) relay vt1=-1m vt2=1m ropen=ropen_mix rclosed=rclosed_mix
EMIXI_c031_0_10 (mix_i_src_c031_0_10 0 bpf_c031_0 0) vcvs gain=-5.555702330196e-01
SMIXI_c031_0_10 (mix_i_src_c031_0_10 mix_i_c031_0 win_0_10 0) relay vt1=-1m vt2=1m ropen=ropen_mix rclosed=rclosed_mix
EMIXQ_c031_0_10 (mix_q_src_c031_0_10 0 bpf_c031_0 0) vcvs gain=-8.314696123025e-01
SMIXQ_c031_0_10 (mix_q_src_c031_0_10 mix_q_c031_0 win_0_10 0) relay vt1=-1m vt2=1m ropen=ropen_mix rclosed=rclosed_mix
EMIXI_c031_0_11 (mix_i_src_c031_0_11 0 bpf_c031_0 0) vcvs gain=-1.950903220161e-01
SMIXI_c031_0_11 (mix_i_src_c031_0_11 mix_i_c031_0 win_0_11 0) relay vt1=-1m vt2=1m ropen=ropen_mix rclosed=rclosed_mix
EMIXQ_c031_0_11 (mix_q_src_c031_0_11 0 bpf_c031_0 0) vcvs gain=-9.807852804032e-01
SMIXQ_c031_0_11 (mix_q_src_c031_0_11 mix_q_c031_0 win_0_11 0) relay vt1=-1m vt2=1m ropen=ropen_mix rclosed=rclosed_mix
EMIXI_c031_0_12 (mix_i_src_c031_0_12 0 bpf_c031_0 0) vcvs gain=1.950903220161e-01
SMIXI_c031_0_12 (mix_i_src_c031_0_12 mix_i_c031_0 win_0_12 0) relay vt1=-1m vt2=1m ropen=ropen_mix rclosed=rclosed_mix
EMIXQ_c031_0_12 (mix_q_src_c031_0_12 0 bpf_c031_0 0) vcvs gain=-9.807852804032e-01
SMIXQ_c031_0_12 (mix_q_src_c031_0_12 mix_q_c031_0 win_0_12 0) relay vt1=-1m vt2=1m ropen=ropen_mix rclosed=rclosed_mix
EMIXI_c031_0_13 (mix_i_src_c031_0_13 0 bpf_c031_0 0) vcvs gain=5.555702330196e-01
SMIXI_c031_0_13 (mix_i_src_c031_0_13 mix_i_c031_0 win_0_13 0) relay vt1=-1m vt2=1m ropen=ropen_mix rclosed=rclosed_mix
EMIXQ_c031_0_13 (mix_q_src_c031_0_13 0 bpf_c031_0 0) vcvs gain=-8.314696123025e-01
SMIXQ_c031_0_13 (mix_q_src_c031_0_13 mix_q_c031_0 win_0_13 0) relay vt1=-1m vt2=1m ropen=ropen_mix rclosed=rclosed_mix
EMIXI_c031_0_14 (mix_i_src_c031_0_14 0 bpf_c031_0 0) vcvs gain=8.314696123025e-01
SMIXI_c031_0_14 (mix_i_src_c031_0_14 mix_i_c031_0 win_0_14 0) relay vt1=-1m vt2=1m ropen=ropen_mix rclosed=rclosed_mix
EMIXQ_c031_0_14 (mix_q_src_c031_0_14 0 bpf_c031_0 0) vcvs gain=-5.555702330196e-01
SMIXQ_c031_0_14 (mix_q_src_c031_0_14 mix_q_c031_0 win_0_14 0) relay vt1=-1m vt2=1m ropen=ropen_mix rclosed=rclosed_mix
EMIXI_c031_0_15 (mix_i_src_c031_0_15 0 bpf_c031_0 0) vcvs gain=9.807852804032e-01
SMIXI_c031_0_15 (mix_i_src_c031_0_15 mix_i_c031_0 win_0_15 0) relay vt1=-1m vt2=1m ropen=ropen_mix rclosed=rclosed_mix
EMIXQ_c031_0_15 (mix_q_src_c031_0_15 0 bpf_c031_0 0) vcvs gain=-1.950903220161e-01
SMIXQ_c031_0_15 (mix_q_src_c031_0_15 mix_q_c031_0 win_0_15 0) relay vt1=-1m vt2=1m ropen=ropen_mix rclosed=rclosed_mix
RMIXI_c031_0 (mix_i_c031_0 0) resistor r=1G
RMIXQ_c031_0 (mix_q_c031_0 0) resistor r=1G
RINTI_c031_0 (mix_i_c031_0 Icar_c031_0) resistor r=1k
CINTI_c031_0 (Icar_c031_0 0) capacitor c=80p
RINTQ_c031_0 (mix_q_c031_0 Qcar_c031_0) resistor r=1k
CINTQ_c031_0 (Qcar_c031_0 0) capacitor c=80p
save bpf_c031_0 Icar_c031_0 Qcar_c031_0

// bl031, carrier_1: 500000000 Hz coherent I/Q phase-window verification-demod path
CBPF_c031_1 (bl031 n_cbpf_c031_1) capacitor c=1.013211836423e-13
LBPF_c031_1 (n_cbpf_c031_1 bpf_c031_1) inductor l=1.000000000000e-06
RBPF_c031_1 (bpf_c031_1 0) resistor r=1.570796326795e+02
EMIXI_c031_1_00 (mix_i_src_c031_1_00 0 bpf_c031_1 0) vcvs gain=9.807852804032e-01
SMIXI_c031_1_00 (mix_i_src_c031_1_00 mix_i_c031_1 win_1_00 0) relay vt1=-1m vt2=1m ropen=ropen_mix rclosed=rclosed_mix
EMIXQ_c031_1_00 (mix_q_src_c031_1_00 0 bpf_c031_1 0) vcvs gain=1.950903220161e-01
SMIXQ_c031_1_00 (mix_q_src_c031_1_00 mix_q_c031_1 win_1_00 0) relay vt1=-1m vt2=1m ropen=ropen_mix rclosed=rclosed_mix
EMIXI_c031_1_01 (mix_i_src_c031_1_01 0 bpf_c031_1 0) vcvs gain=8.314696123025e-01
SMIXI_c031_1_01 (mix_i_src_c031_1_01 mix_i_c031_1 win_1_01 0) relay vt1=-1m vt2=1m ropen=ropen_mix rclosed=rclosed_mix
EMIXQ_c031_1_01 (mix_q_src_c031_1_01 0 bpf_c031_1 0) vcvs gain=5.555702330196e-01
SMIXQ_c031_1_01 (mix_q_src_c031_1_01 mix_q_c031_1 win_1_01 0) relay vt1=-1m vt2=1m ropen=ropen_mix rclosed=rclosed_mix
EMIXI_c031_1_02 (mix_i_src_c031_1_02 0 bpf_c031_1 0) vcvs gain=5.555702330196e-01
SMIXI_c031_1_02 (mix_i_src_c031_1_02 mix_i_c031_1 win_1_02 0) relay vt1=-1m vt2=1m ropen=ropen_mix rclosed=rclosed_mix
EMIXQ_c031_1_02 (mix_q_src_c031_1_02 0 bpf_c031_1 0) vcvs gain=8.314696123025e-01
SMIXQ_c031_1_02 (mix_q_src_c031_1_02 mix_q_c031_1 win_1_02 0) relay vt1=-1m vt2=1m ropen=ropen_mix rclosed=rclosed_mix
EMIXI_c031_1_03 (mix_i_src_c031_1_03 0 bpf_c031_1 0) vcvs gain=1.950903220161e-01
SMIXI_c031_1_03 (mix_i_src_c031_1_03 mix_i_c031_1 win_1_03 0) relay vt1=-1m vt2=1m ropen=ropen_mix rclosed=rclosed_mix
EMIXQ_c031_1_03 (mix_q_src_c031_1_03 0 bpf_c031_1 0) vcvs gain=9.807852804032e-01
SMIXQ_c031_1_03 (mix_q_src_c031_1_03 mix_q_c031_1 win_1_03 0) relay vt1=-1m vt2=1m ropen=ropen_mix rclosed=rclosed_mix
EMIXI_c031_1_04 (mix_i_src_c031_1_04 0 bpf_c031_1 0) vcvs gain=-1.950903220161e-01
SMIXI_c031_1_04 (mix_i_src_c031_1_04 mix_i_c031_1 win_1_04 0) relay vt1=-1m vt2=1m ropen=ropen_mix rclosed=rclosed_mix
EMIXQ_c031_1_04 (mix_q_src_c031_1_04 0 bpf_c031_1 0) vcvs gain=9.807852804032e-01
SMIXQ_c031_1_04 (mix_q_src_c031_1_04 mix_q_c031_1 win_1_04 0) relay vt1=-1m vt2=1m ropen=ropen_mix rclosed=rclosed_mix
EMIXI_c031_1_05 (mix_i_src_c031_1_05 0 bpf_c031_1 0) vcvs gain=-5.555702330196e-01
SMIXI_c031_1_05 (mix_i_src_c031_1_05 mix_i_c031_1 win_1_05 0) relay vt1=-1m vt2=1m ropen=ropen_mix rclosed=rclosed_mix
EMIXQ_c031_1_05 (mix_q_src_c031_1_05 0 bpf_c031_1 0) vcvs gain=8.314696123025e-01
SMIXQ_c031_1_05 (mix_q_src_c031_1_05 mix_q_c031_1 win_1_05 0) relay vt1=-1m vt2=1m ropen=ropen_mix rclosed=rclosed_mix
EMIXI_c031_1_06 (mix_i_src_c031_1_06 0 bpf_c031_1 0) vcvs gain=-8.314696123025e-01
SMIXI_c031_1_06 (mix_i_src_c031_1_06 mix_i_c031_1 win_1_06 0) relay vt1=-1m vt2=1m ropen=ropen_mix rclosed=rclosed_mix
EMIXQ_c031_1_06 (mix_q_src_c031_1_06 0 bpf_c031_1 0) vcvs gain=5.555702330196e-01
SMIXQ_c031_1_06 (mix_q_src_c031_1_06 mix_q_c031_1 win_1_06 0) relay vt1=-1m vt2=1m ropen=ropen_mix rclosed=rclosed_mix
EMIXI_c031_1_07 (mix_i_src_c031_1_07 0 bpf_c031_1 0) vcvs gain=-9.807852804032e-01
SMIXI_c031_1_07 (mix_i_src_c031_1_07 mix_i_c031_1 win_1_07 0) relay vt1=-1m vt2=1m ropen=ropen_mix rclosed=rclosed_mix
EMIXQ_c031_1_07 (mix_q_src_c031_1_07 0 bpf_c031_1 0) vcvs gain=1.950903220161e-01
SMIXQ_c031_1_07 (mix_q_src_c031_1_07 mix_q_c031_1 win_1_07 0) relay vt1=-1m vt2=1m ropen=ropen_mix rclosed=rclosed_mix
EMIXI_c031_1_08 (mix_i_src_c031_1_08 0 bpf_c031_1 0) vcvs gain=-9.807852804032e-01
SMIXI_c031_1_08 (mix_i_src_c031_1_08 mix_i_c031_1 win_1_08 0) relay vt1=-1m vt2=1m ropen=ropen_mix rclosed=rclosed_mix
EMIXQ_c031_1_08 (mix_q_src_c031_1_08 0 bpf_c031_1 0) vcvs gain=-1.950903220161e-01
SMIXQ_c031_1_08 (mix_q_src_c031_1_08 mix_q_c031_1 win_1_08 0) relay vt1=-1m vt2=1m ropen=ropen_mix rclosed=rclosed_mix
EMIXI_c031_1_09 (mix_i_src_c031_1_09 0 bpf_c031_1 0) vcvs gain=-8.314696123025e-01
SMIXI_c031_1_09 (mix_i_src_c031_1_09 mix_i_c031_1 win_1_09 0) relay vt1=-1m vt2=1m ropen=ropen_mix rclosed=rclosed_mix
EMIXQ_c031_1_09 (mix_q_src_c031_1_09 0 bpf_c031_1 0) vcvs gain=-5.555702330196e-01
SMIXQ_c031_1_09 (mix_q_src_c031_1_09 mix_q_c031_1 win_1_09 0) relay vt1=-1m vt2=1m ropen=ropen_mix rclosed=rclosed_mix
EMIXI_c031_1_10 (mix_i_src_c031_1_10 0 bpf_c031_1 0) vcvs gain=-5.555702330196e-01
SMIXI_c031_1_10 (mix_i_src_c031_1_10 mix_i_c031_1 win_1_10 0) relay vt1=-1m vt2=1m ropen=ropen_mix rclosed=rclosed_mix
EMIXQ_c031_1_10 (mix_q_src_c031_1_10 0 bpf_c031_1 0) vcvs gain=-8.314696123025e-01
SMIXQ_c031_1_10 (mix_q_src_c031_1_10 mix_q_c031_1 win_1_10 0) relay vt1=-1m vt2=1m ropen=ropen_mix rclosed=rclosed_mix
EMIXI_c031_1_11 (mix_i_src_c031_1_11 0 bpf_c031_1 0) vcvs gain=-1.950903220161e-01
SMIXI_c031_1_11 (mix_i_src_c031_1_11 mix_i_c031_1 win_1_11 0) relay vt1=-1m vt2=1m ropen=ropen_mix rclosed=rclosed_mix
EMIXQ_c031_1_11 (mix_q_src_c031_1_11 0 bpf_c031_1 0) vcvs gain=-9.807852804032e-01
SMIXQ_c031_1_11 (mix_q_src_c031_1_11 mix_q_c031_1 win_1_11 0) relay vt1=-1m vt2=1m ropen=ropen_mix rclosed=rclosed_mix
EMIXI_c031_1_12 (mix_i_src_c031_1_12 0 bpf_c031_1 0) vcvs gain=1.950903220161e-01
SMIXI_c031_1_12 (mix_i_src_c031_1_12 mix_i_c031_1 win_1_12 0) relay vt1=-1m vt2=1m ropen=ropen_mix rclosed=rclosed_mix
EMIXQ_c031_1_12 (mix_q_src_c031_1_12 0 bpf_c031_1 0) vcvs gain=-9.807852804032e-01
SMIXQ_c031_1_12 (mix_q_src_c031_1_12 mix_q_c031_1 win_1_12 0) relay vt1=-1m vt2=1m ropen=ropen_mix rclosed=rclosed_mix
EMIXI_c031_1_13 (mix_i_src_c031_1_13 0 bpf_c031_1 0) vcvs gain=5.555702330196e-01
SMIXI_c031_1_13 (mix_i_src_c031_1_13 mix_i_c031_1 win_1_13 0) relay vt1=-1m vt2=1m ropen=ropen_mix rclosed=rclosed_mix
EMIXQ_c031_1_13 (mix_q_src_c031_1_13 0 bpf_c031_1 0) vcvs gain=-8.314696123025e-01
SMIXQ_c031_1_13 (mix_q_src_c031_1_13 mix_q_c031_1 win_1_13 0) relay vt1=-1m vt2=1m ropen=ropen_mix rclosed=rclosed_mix
EMIXI_c031_1_14 (mix_i_src_c031_1_14 0 bpf_c031_1 0) vcvs gain=8.314696123025e-01
SMIXI_c031_1_14 (mix_i_src_c031_1_14 mix_i_c031_1 win_1_14 0) relay vt1=-1m vt2=1m ropen=ropen_mix rclosed=rclosed_mix
EMIXQ_c031_1_14 (mix_q_src_c031_1_14 0 bpf_c031_1 0) vcvs gain=-5.555702330196e-01
SMIXQ_c031_1_14 (mix_q_src_c031_1_14 mix_q_c031_1 win_1_14 0) relay vt1=-1m vt2=1m ropen=ropen_mix rclosed=rclosed_mix
EMIXI_c031_1_15 (mix_i_src_c031_1_15 0 bpf_c031_1 0) vcvs gain=9.807852804032e-01
SMIXI_c031_1_15 (mix_i_src_c031_1_15 mix_i_c031_1 win_1_15 0) relay vt1=-1m vt2=1m ropen=ropen_mix rclosed=rclosed_mix
EMIXQ_c031_1_15 (mix_q_src_c031_1_15 0 bpf_c031_1 0) vcvs gain=-1.950903220161e-01
SMIXQ_c031_1_15 (mix_q_src_c031_1_15 mix_q_c031_1 win_1_15 0) relay vt1=-1m vt2=1m ropen=ropen_mix rclosed=rclosed_mix
RMIXI_c031_1 (mix_i_c031_1 0) resistor r=1G
RMIXQ_c031_1 (mix_q_c031_1 0) resistor r=1G
RINTI_c031_1 (mix_i_c031_1 Icar_c031_1) resistor r=1k
CINTI_c031_1 (Icar_c031_1 0) capacitor c=80p
RINTQ_c031_1 (mix_q_c031_1 Qcar_c031_1) resistor r=1k
CINTQ_c031_1 (Qcar_c031_1 0) capacitor c=80p
save bpf_c031_1 Icar_c031_1 Qcar_c031_1

// bl031, carrier_2: 750000000 Hz coherent I/Q phase-window verification-demod path
CBPF_c031_2 (bl031 n_cbpf_c031_2) capacitor c=4.503163717437e-14
LBPF_c031_2 (n_cbpf_c031_2 bpf_c031_2) inductor l=1.000000000000e-06
RBPF_c031_2 (bpf_c031_2 0) resistor r=2.356194490192e+02
EMIXI_c031_2_00 (mix_i_src_c031_2_00 0 bpf_c031_2 0) vcvs gain=9.807852804032e-01
SMIXI_c031_2_00 (mix_i_src_c031_2_00 mix_i_c031_2 win_2_00 0) relay vt1=-1m vt2=1m ropen=ropen_mix rclosed=rclosed_mix
EMIXQ_c031_2_00 (mix_q_src_c031_2_00 0 bpf_c031_2 0) vcvs gain=1.950903220161e-01
SMIXQ_c031_2_00 (mix_q_src_c031_2_00 mix_q_c031_2 win_2_00 0) relay vt1=-1m vt2=1m ropen=ropen_mix rclosed=rclosed_mix
EMIXI_c031_2_01 (mix_i_src_c031_2_01 0 bpf_c031_2 0) vcvs gain=8.314696123025e-01
SMIXI_c031_2_01 (mix_i_src_c031_2_01 mix_i_c031_2 win_2_01 0) relay vt1=-1m vt2=1m ropen=ropen_mix rclosed=rclosed_mix
EMIXQ_c031_2_01 (mix_q_src_c031_2_01 0 bpf_c031_2 0) vcvs gain=5.555702330196e-01
SMIXQ_c031_2_01 (mix_q_src_c031_2_01 mix_q_c031_2 win_2_01 0) relay vt1=-1m vt2=1m ropen=ropen_mix rclosed=rclosed_mix
EMIXI_c031_2_02 (mix_i_src_c031_2_02 0 bpf_c031_2 0) vcvs gain=5.555702330196e-01
SMIXI_c031_2_02 (mix_i_src_c031_2_02 mix_i_c031_2 win_2_02 0) relay vt1=-1m vt2=1m ropen=ropen_mix rclosed=rclosed_mix
EMIXQ_c031_2_02 (mix_q_src_c031_2_02 0 bpf_c031_2 0) vcvs gain=8.314696123025e-01
SMIXQ_c031_2_02 (mix_q_src_c031_2_02 mix_q_c031_2 win_2_02 0) relay vt1=-1m vt2=1m ropen=ropen_mix rclosed=rclosed_mix
EMIXI_c031_2_03 (mix_i_src_c031_2_03 0 bpf_c031_2 0) vcvs gain=1.950903220161e-01
SMIXI_c031_2_03 (mix_i_src_c031_2_03 mix_i_c031_2 win_2_03 0) relay vt1=-1m vt2=1m ropen=ropen_mix rclosed=rclosed_mix
EMIXQ_c031_2_03 (mix_q_src_c031_2_03 0 bpf_c031_2 0) vcvs gain=9.807852804032e-01
SMIXQ_c031_2_03 (mix_q_src_c031_2_03 mix_q_c031_2 win_2_03 0) relay vt1=-1m vt2=1m ropen=ropen_mix rclosed=rclosed_mix
EMIXI_c031_2_04 (mix_i_src_c031_2_04 0 bpf_c031_2 0) vcvs gain=-1.950903220161e-01
SMIXI_c031_2_04 (mix_i_src_c031_2_04 mix_i_c031_2 win_2_04 0) relay vt1=-1m vt2=1m ropen=ropen_mix rclosed=rclosed_mix
EMIXQ_c031_2_04 (mix_q_src_c031_2_04 0 bpf_c031_2 0) vcvs gain=9.807852804032e-01
SMIXQ_c031_2_04 (mix_q_src_c031_2_04 mix_q_c031_2 win_2_04 0) relay vt1=-1m vt2=1m ropen=ropen_mix rclosed=rclosed_mix
EMIXI_c031_2_05 (mix_i_src_c031_2_05 0 bpf_c031_2 0) vcvs gain=-5.555702330196e-01
SMIXI_c031_2_05 (mix_i_src_c031_2_05 mix_i_c031_2 win_2_05 0) relay vt1=-1m vt2=1m ropen=ropen_mix rclosed=rclosed_mix
EMIXQ_c031_2_05 (mix_q_src_c031_2_05 0 bpf_c031_2 0) vcvs gain=8.314696123025e-01
SMIXQ_c031_2_05 (mix_q_src_c031_2_05 mix_q_c031_2 win_2_05 0) relay vt1=-1m vt2=1m ropen=ropen_mix rclosed=rclosed_mix
EMIXI_c031_2_06 (mix_i_src_c031_2_06 0 bpf_c031_2 0) vcvs gain=-8.314696123025e-01
SMIXI_c031_2_06 (mix_i_src_c031_2_06 mix_i_c031_2 win_2_06 0) relay vt1=-1m vt2=1m ropen=ropen_mix rclosed=rclosed_mix
EMIXQ_c031_2_06 (mix_q_src_c031_2_06 0 bpf_c031_2 0) vcvs gain=5.555702330196e-01
SMIXQ_c031_2_06 (mix_q_src_c031_2_06 mix_q_c031_2 win_2_06 0) relay vt1=-1m vt2=1m ropen=ropen_mix rclosed=rclosed_mix
EMIXI_c031_2_07 (mix_i_src_c031_2_07 0 bpf_c031_2 0) vcvs gain=-9.807852804032e-01
SMIXI_c031_2_07 (mix_i_src_c031_2_07 mix_i_c031_2 win_2_07 0) relay vt1=-1m vt2=1m ropen=ropen_mix rclosed=rclosed_mix
EMIXQ_c031_2_07 (mix_q_src_c031_2_07 0 bpf_c031_2 0) vcvs gain=1.950903220161e-01
SMIXQ_c031_2_07 (mix_q_src_c031_2_07 mix_q_c031_2 win_2_07 0) relay vt1=-1m vt2=1m ropen=ropen_mix rclosed=rclosed_mix
EMIXI_c031_2_08 (mix_i_src_c031_2_08 0 bpf_c031_2 0) vcvs gain=-9.807852804032e-01
SMIXI_c031_2_08 (mix_i_src_c031_2_08 mix_i_c031_2 win_2_08 0) relay vt1=-1m vt2=1m ropen=ropen_mix rclosed=rclosed_mix
EMIXQ_c031_2_08 (mix_q_src_c031_2_08 0 bpf_c031_2 0) vcvs gain=-1.950903220161e-01
SMIXQ_c031_2_08 (mix_q_src_c031_2_08 mix_q_c031_2 win_2_08 0) relay vt1=-1m vt2=1m ropen=ropen_mix rclosed=rclosed_mix
EMIXI_c031_2_09 (mix_i_src_c031_2_09 0 bpf_c031_2 0) vcvs gain=-8.314696123025e-01
SMIXI_c031_2_09 (mix_i_src_c031_2_09 mix_i_c031_2 win_2_09 0) relay vt1=-1m vt2=1m ropen=ropen_mix rclosed=rclosed_mix
EMIXQ_c031_2_09 (mix_q_src_c031_2_09 0 bpf_c031_2 0) vcvs gain=-5.555702330196e-01
SMIXQ_c031_2_09 (mix_q_src_c031_2_09 mix_q_c031_2 win_2_09 0) relay vt1=-1m vt2=1m ropen=ropen_mix rclosed=rclosed_mix
EMIXI_c031_2_10 (mix_i_src_c031_2_10 0 bpf_c031_2 0) vcvs gain=-5.555702330196e-01
SMIXI_c031_2_10 (mix_i_src_c031_2_10 mix_i_c031_2 win_2_10 0) relay vt1=-1m vt2=1m ropen=ropen_mix rclosed=rclosed_mix
EMIXQ_c031_2_10 (mix_q_src_c031_2_10 0 bpf_c031_2 0) vcvs gain=-8.314696123025e-01
SMIXQ_c031_2_10 (mix_q_src_c031_2_10 mix_q_c031_2 win_2_10 0) relay vt1=-1m vt2=1m ropen=ropen_mix rclosed=rclosed_mix
EMIXI_c031_2_11 (mix_i_src_c031_2_11 0 bpf_c031_2 0) vcvs gain=-1.950903220161e-01
SMIXI_c031_2_11 (mix_i_src_c031_2_11 mix_i_c031_2 win_2_11 0) relay vt1=-1m vt2=1m ropen=ropen_mix rclosed=rclosed_mix
EMIXQ_c031_2_11 (mix_q_src_c031_2_11 0 bpf_c031_2 0) vcvs gain=-9.807852804032e-01
SMIXQ_c031_2_11 (mix_q_src_c031_2_11 mix_q_c031_2 win_2_11 0) relay vt1=-1m vt2=1m ropen=ropen_mix rclosed=rclosed_mix
EMIXI_c031_2_12 (mix_i_src_c031_2_12 0 bpf_c031_2 0) vcvs gain=1.950903220161e-01
SMIXI_c031_2_12 (mix_i_src_c031_2_12 mix_i_c031_2 win_2_12 0) relay vt1=-1m vt2=1m ropen=ropen_mix rclosed=rclosed_mix
EMIXQ_c031_2_12 (mix_q_src_c031_2_12 0 bpf_c031_2 0) vcvs gain=-9.807852804032e-01
SMIXQ_c031_2_12 (mix_q_src_c031_2_12 mix_q_c031_2 win_2_12 0) relay vt1=-1m vt2=1m ropen=ropen_mix rclosed=rclosed_mix
EMIXI_c031_2_13 (mix_i_src_c031_2_13 0 bpf_c031_2 0) vcvs gain=5.555702330196e-01
SMIXI_c031_2_13 (mix_i_src_c031_2_13 mix_i_c031_2 win_2_13 0) relay vt1=-1m vt2=1m ropen=ropen_mix rclosed=rclosed_mix
EMIXQ_c031_2_13 (mix_q_src_c031_2_13 0 bpf_c031_2 0) vcvs gain=-8.314696123025e-01
SMIXQ_c031_2_13 (mix_q_src_c031_2_13 mix_q_c031_2 win_2_13 0) relay vt1=-1m vt2=1m ropen=ropen_mix rclosed=rclosed_mix
EMIXI_c031_2_14 (mix_i_src_c031_2_14 0 bpf_c031_2 0) vcvs gain=8.314696123025e-01
SMIXI_c031_2_14 (mix_i_src_c031_2_14 mix_i_c031_2 win_2_14 0) relay vt1=-1m vt2=1m ropen=ropen_mix rclosed=rclosed_mix
EMIXQ_c031_2_14 (mix_q_src_c031_2_14 0 bpf_c031_2 0) vcvs gain=-5.555702330196e-01
SMIXQ_c031_2_14 (mix_q_src_c031_2_14 mix_q_c031_2 win_2_14 0) relay vt1=-1m vt2=1m ropen=ropen_mix rclosed=rclosed_mix
EMIXI_c031_2_15 (mix_i_src_c031_2_15 0 bpf_c031_2 0) vcvs gain=9.807852804032e-01
SMIXI_c031_2_15 (mix_i_src_c031_2_15 mix_i_c031_2 win_2_15 0) relay vt1=-1m vt2=1m ropen=ropen_mix rclosed=rclosed_mix
EMIXQ_c031_2_15 (mix_q_src_c031_2_15 0 bpf_c031_2 0) vcvs gain=-1.950903220161e-01
SMIXQ_c031_2_15 (mix_q_src_c031_2_15 mix_q_c031_2 win_2_15 0) relay vt1=-1m vt2=1m ropen=ropen_mix rclosed=rclosed_mix
RMIXI_c031_2 (mix_i_c031_2 0) resistor r=1G
RMIXQ_c031_2 (mix_q_c031_2 0) resistor r=1G
RINTI_c031_2 (mix_i_c031_2 Icar_c031_2) resistor r=1k
CINTI_c031_2 (Icar_c031_2 0) capacitor c=80p
RINTQ_c031_2 (mix_q_c031_2 Qcar_c031_2) resistor r=1k
CINTQ_c031_2 (Qcar_c031_2 0) capacitor c=80p
save bpf_c031_2 Icar_c031_2 Qcar_c031_2

// bl031, carrier_3: 1000000000 Hz coherent I/Q phase-window verification-demod path
CBPF_c031_3 (bl031 n_cbpf_c031_3) capacitor c=2.533029591058e-14
LBPF_c031_3 (n_cbpf_c031_3 bpf_c031_3) inductor l=1.000000000000e-06
RBPF_c031_3 (bpf_c031_3 0) resistor r=3.141592653590e+02
EMIXI_c031_3_00 (mix_i_src_c031_3_00 0 bpf_c031_3 0) vcvs gain=9.807852804032e-01
SMIXI_c031_3_00 (mix_i_src_c031_3_00 mix_i_c031_3 win_3_00 0) relay vt1=-1m vt2=1m ropen=ropen_mix rclosed=rclosed_mix
EMIXQ_c031_3_00 (mix_q_src_c031_3_00 0 bpf_c031_3 0) vcvs gain=1.950903220161e-01
SMIXQ_c031_3_00 (mix_q_src_c031_3_00 mix_q_c031_3 win_3_00 0) relay vt1=-1m vt2=1m ropen=ropen_mix rclosed=rclosed_mix
EMIXI_c031_3_01 (mix_i_src_c031_3_01 0 bpf_c031_3 0) vcvs gain=8.314696123025e-01
SMIXI_c031_3_01 (mix_i_src_c031_3_01 mix_i_c031_3 win_3_01 0) relay vt1=-1m vt2=1m ropen=ropen_mix rclosed=rclosed_mix
EMIXQ_c031_3_01 (mix_q_src_c031_3_01 0 bpf_c031_3 0) vcvs gain=5.555702330196e-01
SMIXQ_c031_3_01 (mix_q_src_c031_3_01 mix_q_c031_3 win_3_01 0) relay vt1=-1m vt2=1m ropen=ropen_mix rclosed=rclosed_mix
EMIXI_c031_3_02 (mix_i_src_c031_3_02 0 bpf_c031_3 0) vcvs gain=5.555702330196e-01
SMIXI_c031_3_02 (mix_i_src_c031_3_02 mix_i_c031_3 win_3_02 0) relay vt1=-1m vt2=1m ropen=ropen_mix rclosed=rclosed_mix
EMIXQ_c031_3_02 (mix_q_src_c031_3_02 0 bpf_c031_3 0) vcvs gain=8.314696123025e-01
SMIXQ_c031_3_02 (mix_q_src_c031_3_02 mix_q_c031_3 win_3_02 0) relay vt1=-1m vt2=1m ropen=ropen_mix rclosed=rclosed_mix
EMIXI_c031_3_03 (mix_i_src_c031_3_03 0 bpf_c031_3 0) vcvs gain=1.950903220161e-01
SMIXI_c031_3_03 (mix_i_src_c031_3_03 mix_i_c031_3 win_3_03 0) relay vt1=-1m vt2=1m ropen=ropen_mix rclosed=rclosed_mix
EMIXQ_c031_3_03 (mix_q_src_c031_3_03 0 bpf_c031_3 0) vcvs gain=9.807852804032e-01
SMIXQ_c031_3_03 (mix_q_src_c031_3_03 mix_q_c031_3 win_3_03 0) relay vt1=-1m vt2=1m ropen=ropen_mix rclosed=rclosed_mix
EMIXI_c031_3_04 (mix_i_src_c031_3_04 0 bpf_c031_3 0) vcvs gain=-1.950903220161e-01
SMIXI_c031_3_04 (mix_i_src_c031_3_04 mix_i_c031_3 win_3_04 0) relay vt1=-1m vt2=1m ropen=ropen_mix rclosed=rclosed_mix
EMIXQ_c031_3_04 (mix_q_src_c031_3_04 0 bpf_c031_3 0) vcvs gain=9.807852804032e-01
SMIXQ_c031_3_04 (mix_q_src_c031_3_04 mix_q_c031_3 win_3_04 0) relay vt1=-1m vt2=1m ropen=ropen_mix rclosed=rclosed_mix
EMIXI_c031_3_05 (mix_i_src_c031_3_05 0 bpf_c031_3 0) vcvs gain=-5.555702330196e-01
SMIXI_c031_3_05 (mix_i_src_c031_3_05 mix_i_c031_3 win_3_05 0) relay vt1=-1m vt2=1m ropen=ropen_mix rclosed=rclosed_mix
EMIXQ_c031_3_05 (mix_q_src_c031_3_05 0 bpf_c031_3 0) vcvs gain=8.314696123025e-01
SMIXQ_c031_3_05 (mix_q_src_c031_3_05 mix_q_c031_3 win_3_05 0) relay vt1=-1m vt2=1m ropen=ropen_mix rclosed=rclosed_mix
EMIXI_c031_3_06 (mix_i_src_c031_3_06 0 bpf_c031_3 0) vcvs gain=-8.314696123025e-01
SMIXI_c031_3_06 (mix_i_src_c031_3_06 mix_i_c031_3 win_3_06 0) relay vt1=-1m vt2=1m ropen=ropen_mix rclosed=rclosed_mix
EMIXQ_c031_3_06 (mix_q_src_c031_3_06 0 bpf_c031_3 0) vcvs gain=5.555702330196e-01
SMIXQ_c031_3_06 (mix_q_src_c031_3_06 mix_q_c031_3 win_3_06 0) relay vt1=-1m vt2=1m ropen=ropen_mix rclosed=rclosed_mix
EMIXI_c031_3_07 (mix_i_src_c031_3_07 0 bpf_c031_3 0) vcvs gain=-9.807852804032e-01
SMIXI_c031_3_07 (mix_i_src_c031_3_07 mix_i_c031_3 win_3_07 0) relay vt1=-1m vt2=1m ropen=ropen_mix rclosed=rclosed_mix
EMIXQ_c031_3_07 (mix_q_src_c031_3_07 0 bpf_c031_3 0) vcvs gain=1.950903220161e-01
SMIXQ_c031_3_07 (mix_q_src_c031_3_07 mix_q_c031_3 win_3_07 0) relay vt1=-1m vt2=1m ropen=ropen_mix rclosed=rclosed_mix
EMIXI_c031_3_08 (mix_i_src_c031_3_08 0 bpf_c031_3 0) vcvs gain=-9.807852804032e-01
SMIXI_c031_3_08 (mix_i_src_c031_3_08 mix_i_c031_3 win_3_08 0) relay vt1=-1m vt2=1m ropen=ropen_mix rclosed=rclosed_mix
EMIXQ_c031_3_08 (mix_q_src_c031_3_08 0 bpf_c031_3 0) vcvs gain=-1.950903220161e-01
SMIXQ_c031_3_08 (mix_q_src_c031_3_08 mix_q_c031_3 win_3_08 0) relay vt1=-1m vt2=1m ropen=ropen_mix rclosed=rclosed_mix
EMIXI_c031_3_09 (mix_i_src_c031_3_09 0 bpf_c031_3 0) vcvs gain=-8.314696123025e-01
SMIXI_c031_3_09 (mix_i_src_c031_3_09 mix_i_c031_3 win_3_09 0) relay vt1=-1m vt2=1m ropen=ropen_mix rclosed=rclosed_mix
EMIXQ_c031_3_09 (mix_q_src_c031_3_09 0 bpf_c031_3 0) vcvs gain=-5.555702330196e-01
SMIXQ_c031_3_09 (mix_q_src_c031_3_09 mix_q_c031_3 win_3_09 0) relay vt1=-1m vt2=1m ropen=ropen_mix rclosed=rclosed_mix
EMIXI_c031_3_10 (mix_i_src_c031_3_10 0 bpf_c031_3 0) vcvs gain=-5.555702330196e-01
SMIXI_c031_3_10 (mix_i_src_c031_3_10 mix_i_c031_3 win_3_10 0) relay vt1=-1m vt2=1m ropen=ropen_mix rclosed=rclosed_mix
EMIXQ_c031_3_10 (mix_q_src_c031_3_10 0 bpf_c031_3 0) vcvs gain=-8.314696123025e-01
SMIXQ_c031_3_10 (mix_q_src_c031_3_10 mix_q_c031_3 win_3_10 0) relay vt1=-1m vt2=1m ropen=ropen_mix rclosed=rclosed_mix
EMIXI_c031_3_11 (mix_i_src_c031_3_11 0 bpf_c031_3 0) vcvs gain=-1.950903220161e-01
SMIXI_c031_3_11 (mix_i_src_c031_3_11 mix_i_c031_3 win_3_11 0) relay vt1=-1m vt2=1m ropen=ropen_mix rclosed=rclosed_mix
EMIXQ_c031_3_11 (mix_q_src_c031_3_11 0 bpf_c031_3 0) vcvs gain=-9.807852804032e-01
SMIXQ_c031_3_11 (mix_q_src_c031_3_11 mix_q_c031_3 win_3_11 0) relay vt1=-1m vt2=1m ropen=ropen_mix rclosed=rclosed_mix
EMIXI_c031_3_12 (mix_i_src_c031_3_12 0 bpf_c031_3 0) vcvs gain=1.950903220161e-01
SMIXI_c031_3_12 (mix_i_src_c031_3_12 mix_i_c031_3 win_3_12 0) relay vt1=-1m vt2=1m ropen=ropen_mix rclosed=rclosed_mix
EMIXQ_c031_3_12 (mix_q_src_c031_3_12 0 bpf_c031_3 0) vcvs gain=-9.807852804032e-01
SMIXQ_c031_3_12 (mix_q_src_c031_3_12 mix_q_c031_3 win_3_12 0) relay vt1=-1m vt2=1m ropen=ropen_mix rclosed=rclosed_mix
EMIXI_c031_3_13 (mix_i_src_c031_3_13 0 bpf_c031_3 0) vcvs gain=5.555702330196e-01
SMIXI_c031_3_13 (mix_i_src_c031_3_13 mix_i_c031_3 win_3_13 0) relay vt1=-1m vt2=1m ropen=ropen_mix rclosed=rclosed_mix
EMIXQ_c031_3_13 (mix_q_src_c031_3_13 0 bpf_c031_3 0) vcvs gain=-8.314696123025e-01
SMIXQ_c031_3_13 (mix_q_src_c031_3_13 mix_q_c031_3 win_3_13 0) relay vt1=-1m vt2=1m ropen=ropen_mix rclosed=rclosed_mix
EMIXI_c031_3_14 (mix_i_src_c031_3_14 0 bpf_c031_3 0) vcvs gain=8.314696123025e-01
SMIXI_c031_3_14 (mix_i_src_c031_3_14 mix_i_c031_3 win_3_14 0) relay vt1=-1m vt2=1m ropen=ropen_mix rclosed=rclosed_mix
EMIXQ_c031_3_14 (mix_q_src_c031_3_14 0 bpf_c031_3 0) vcvs gain=-5.555702330196e-01
SMIXQ_c031_3_14 (mix_q_src_c031_3_14 mix_q_c031_3 win_3_14 0) relay vt1=-1m vt2=1m ropen=ropen_mix rclosed=rclosed_mix
EMIXI_c031_3_15 (mix_i_src_c031_3_15 0 bpf_c031_3 0) vcvs gain=9.807852804032e-01
SMIXI_c031_3_15 (mix_i_src_c031_3_15 mix_i_c031_3 win_3_15 0) relay vt1=-1m vt2=1m ropen=ropen_mix rclosed=rclosed_mix
EMIXQ_c031_3_15 (mix_q_src_c031_3_15 0 bpf_c031_3 0) vcvs gain=-1.950903220161e-01
SMIXQ_c031_3_15 (mix_q_src_c031_3_15 mix_q_c031_3 win_3_15 0) relay vt1=-1m vt2=1m ropen=ropen_mix rclosed=rclosed_mix
RMIXI_c031_3 (mix_i_c031_3 0) resistor r=1G
RMIXQ_c031_3 (mix_q_c031_3 0) resistor r=1G
RINTI_c031_3 (mix_i_c031_3 Icar_c031_3) resistor r=1k
CINTI_c031_3 (Icar_c031_3 0) capacitor c=80p
RINTQ_c031_3 (mix_q_c031_3 Qcar_c031_3) resistor r=1k
CINTQ_c031_3 (Qcar_c031_3 0) capacitor c=80p
save bpf_c031_3 Icar_c031_3 Qcar_c031_3

tbtran tran stop=80n maxstep=10p
